* Native hybrid thermal FEM: V=temperature K; I=heat W
* Signed Gcorr terms are required. Thin tetrahedra are visualization only.
Rt1 T1 T76 1089447.8566096998
Rt2 T1 T300 1287551.7295423711
Rt3 T1 T808 445062.65955736791
Rt4 T1 T821 452584.70323766139
Gcorr1 T1 T1516 T1 T1516 -1.6239933974618754e-07
Rt5 T1 T2101 2454628.9176983475
Rt6 T1 T2102 15703161.848996431
Rt7 T1 T2434 18662992.44609623
Rt8 T1 T2832 1733092.4420275651
Rt9 T1 T3579 1290685.8391209811
Gcorr2 T1 T4870 T1 T4870 -1.6239933974622156e-07
Rt10 T1 T5454 2454628.9177014804
Rt11 T1 T5455 15703161.848917475
Rt12 T1 T5788 18662992.446015656
Rt13 T2 T79 866965.24069017929
Rt14 T2 T80 407507.00053059339
Rt15 T2 T636 624495.19096964365
Rt16 T2 T814 415833.20665139734
Gcorr3 T2 T1077 T2 T1077 -1.6406847847048799e-07
Rt17 T2 T1078 4165752.4180479348
Rt18 T2 T1249 1285873.9375908142
Gcorr4 T2 T1373 T2 T1373 -5.0930768214027263e-07
Rt19 T2 T2789 3143611.8237742698
Rt20 T2 T3560 3350762.7694498654
Gcorr5 T2 T4431 T2 T4431 -1.6406847847059538e-07
Rt21 T2 T4432 4165752.4180502794
Rt22 T2 T4603 1285873.937591959
Gcorr6 T2 T4727 T2 T4727 -5.0930768213934005e-07
Rt23 T3 T82 794109.08700514119
Rt24 T3 T83 917497.34237801167
Rt25 T3 T693 574114.14152481838
Rt26 T3 T824 457252.59202303377
Gcorr7 T3 T1811 T3 T1811 -8.5481349475890127e-08
Gcorr8 T3 T2077 T3 T2077 -5.8418855702572324e-09
Rt27 T3 T2078 7254467.9076897996
Rt28 T3 T2508 3879745.3019004511
Rt29 T3 T2788 1338908.5927200872
Rt30 T3 T3713 3483671.312100193
Gcorr9 T3 T5166 T3 T5166 -8.5481349476110594e-08
Gcorr10 T3 T5431 T3 T5431 -5.8418855702927614e-09
Rt31 T3 T5432 7254467.9076733459
Rt32 T3 T5862 3879745.3019013335
Rt33 T4 T85 1015541.7651505693
Rt34 T4 T86 954262.67175754684
Rt35 T4 T578 755176.11441148957
Rt36 T4 T832 421732.69035298418
Rt37 T4 T1141 1398425.0856749292
Gcorr11 T4 T1143 T4 T1143 -1.2984319959514572e-07
Gcorr12 T4 T1144 T4 T1144 -3.1199944583615957e-07
Rt38 T4 T2780 712916.07216244843
Rt39 T4 T3339 1301988.6079352524
Rt40 T4 T4495 1398425.0856749003
Gcorr13 T4 T4497 T4 T4497 -1.2984319959528948e-07
Gcorr14 T4 T4498 T4 T4498 -3.1199944583603225e-07
Rt41 T5 T88 1101953.6707354563
Rt42 T5 T89 903321.3327710951
Rt43 T5 T590 341567.19202779041
Rt44 T5 T837 700373.75307487685
Gcorr15 T5 T1137 T5 T1137 -4.2117718769193214e-07
Rt45 T5 T1240 2333703.3055503126
Rt46 T5 T2145 2359279.8291793559
Gcorr16 T5 T2170 T5 T2170 -1.2487142903148197e-07
Rt47 T5 T2779 1218833.0769033234
Rt48 T5 T3237 1744560.3256804058
Gcorr17 T5 T4491 T5 T4491 -4.2117718769195564e-07
Rt49 T5 T4594 2333703.3055505562
Rt50 T5 T5500 2359279.8291791128
Gcorr18 T5 T5526 T5 T5526 -1.2487142903145939e-07
Rt51 T6 T91 1013417.6470211102
Rt52 T6 T92 732084.37413143425
Rt53 T6 T584 584362.45973332378
Rt54 T6 T835 599078.17987690773
Rt55 T6 T1993 16238033.429648845
Rt56 T6 T2372 8969202.8526116051
Rt57 T6 T2720 7929992.6319262376
Rt58 T6 T2798 2853125.9262074358
Rt59 T6 T3664 1817680.1091858118
Rt60 T6 T5345 16238033.42955674
Rt61 T6 T5726 8969202.8526302315
Rt62 T6 T6075 7929992.6319337683
Rt63 T7 T94 951039.79464263399
Rt64 T7 T95 1039246.4916639465
Rt65 T7 T574 433812.10382679314
Rt66 T7 T828 581164.84842226049
Rt67 T7 T2108 2769697.0434960215
Gcorr19 T7 T2123 T7 T2123 -1.3908916459201504e-07
Rt68 T7 T2331 4665613.1207973827
Gcorr20 T7 T2448 T7 T2448 -1.245349480373786e-07
Rt69 T7 T2799 1479597.0103741973
Rt70 T7 T3611 1596896.1512128792
Rt71 T7 T5459 2769697.0434944034
Gcorr21 T7 T5479 T7 T5479 -1.3908916459224821e-07
Rt72 T7 T5684 4665613.1207967056
Gcorr22 T7 T5802 T7 T5802 -1.2453494803738964e-07
Rt73 T8 T97 939243.82313671964
Rt74 T8 T98 742551.3884591487
Rt75 T8 T608 417515.72766985052
Rt76 T8 T802 776736.93250777526
Gcorr23 T8 T2043 T8 T2043 -1.3122739257492735e-07
Rt77 T8 T2096 2022995.1824550761
Rt78 T8 T2237 251349800.19747102
Rt79 T8 T2856 1437528.1404211924
Rt80 T8 T3409 2664573.4960411387
Gcorr24 T8 T5397 T8 T5397 -1.3122739257473976e-07
Rt81 T8 T5449 2022995.1824551716
Rt82 T8 T5592 251349800.20800477
Rt83 T9 T101 893146.57032156107
Rt84 T9 T102 728006.82030918414
Rt85 T9 T599 604226.56038259424
Rt86 T9 T754 418027.58815269324
Gcorr25 T9 T1829 T9 T1829 -6.9974061263887898e-08
Rt87 T9 T1891 34781732.015336275
Gcorr26 T9 T1923 T9 T1923 -1.0140212990584566e-07
Rt88 T9 T2522 2477705.6058519678
Rt89 T9 T2677 13482779.250832273
Rt90 T9 T2853 1623794.0105183551
Rt91 T9 T3615 1876542.4732057832
Gcorr27 T9 T5184 T9 T5184 -6.9974061263988695e-08
Rt92 T9 T5248 34781732.015428275
Gcorr28 T9 T5279 T9 T5279 -1.0140212990599577e-07
Rt93 T9 T5876 2477705.6058525471
Rt94 T9 T6031 13482779.2507561
Rt95 T10 T102 937690.9225021688
Rt96 T10 T103 609786.8685148058
Rt97 T10 T576 573455.7452370628
Rt98 T10 T781 532688.17348671868
Gcorr29 T10 T1631 T10 T1631 -4.1370225224776833e-07
Gcorr30 T10 T1709 T10 T1709 -3.9338906918016424e-07
Rt99 T10 T1831 901047.6097395462
Rt100 T10 T2876 645667.13558595593
Rt101 T10 T3789 1150627.2979566576
Gcorr31 T10 T4985 T10 T4985 -4.1370225224785367e-07
Gcorr32 T10 T5063 T10 T5063 -3.933890691800915e-07
Rt102 T10 T5186 901047.60973953758
Rt103 T11 T106 868762.4921321579
Rt104 T11 T107 981844.98439094098
Rt105 T11 T585 529746.40081472951
Rt106 T11 T816 283019.88386520121
Gcorr33 T11 T1618 T11 T1618 -3.7501338663595077e-07
Rt107 T11 T1619 604040.30110592162
Gcorr34 T11 T1620 T11 T1620 -2.3703344806366756e-07
Gcorr35 T11 T1628 T11 T1628 -1.799881713290328e-07
Gcorr36 T11 T2649 T11 T2649 -5.5152599177157288e-07
Rt108 T11 T2844 1084677.2438665004
Rt109 T11 T3775 621201.83461916307
Gcorr37 T11 T4972 T11 T4972 -3.7501338663587835e-07
Rt110 T11 T4973 604040.30110592046
Gcorr38 T11 T4974 T11 T4974 -2.3703344806360364e-07
Gcorr39 T11 T4982 T11 T4982 -1.799881713290841e-07
Gcorr40 T11 T6003 T11 T6003 -5.515259917716634e-07
Rt111 T12 T109 827895.01253187144
Rt112 T12 T110 917034.57395976572
Rt113 T12 T641 572961.55346347566
Rt114 T12 T825 481359.00088409521
Gcorr41 T12 T1611 T12 T1611 -2.0377509592623692e-07
Rt115 T12 T1982 1632171.3886036754
Rt116 T12 T2021 11436198.242763057
Gcorr42 T12 T2371 T12 T2371 -1.6485709481515028e-07
Rt117 T12 T2839 1584516.7912381124
Rt118 T12 T3399 1124348.9522384654
Gcorr43 T12 T4965 T12 T4965 -2.0377509592614946e-07
Rt119 T12 T5334 1632171.3886040761
Rt120 T12 T5374 11436198.242747266
Gcorr44 T12 T5725 T12 T5725 -1.6485709481521021e-07
Rt121 T13 T112 709129.95763303433
Rt122 T13 T113 860396.48416551203
Rt123 T13 T646 504454.62429039751
Rt124 T13 T819 589701.18026996637
Rt125 T13 T1979 12471946.462133817
Rt126 T13 T2040 8471352.8716231994
Gcorr45 T13 T2185 T13 T2185 -1.8135224187606635e-07
Rt127 T13 T2203 2858671.7060591877
Rt128 T13 T2786 1712853.3429796041
Rt129 T13 T3544 2951868.3516948898
Rt130 T13 T5331 12471946.46213487
Rt131 T13 T5394 8471352.8716242574
Gcorr46 T13 T5542 T13 T5542 -1.8135224187609001e-07
Rt132 T13 T5560 2858671.7060588384
Rt133 T14 T114 978446.19326841389
Rt134 T14 T115 710720.14361975936
Rt135 T14 T542 670883.0902882471
Rt136 T14 T615 541143.72575657803
Rt137 T14 T839 564661.69145359856
Gcorr47 T14 T1204 T14 T1204 -1.7614249230384681e-07
Rt138 T14 T1443 2434482.2789350064
Gcorr48 T14 T1793 T14 T1793 -2.4990667769077476e-08
Rt139 T14 T2126 5173853.2234692685
Rt140 T14 T3215 1450453.9859824076
Gcorr49 T14 T4558 T14 T4558 -1.7614249230390417e-07
Rt141 T14 T4797 2434482.2789346538
Gcorr50 T14 T5148 T14 T5148 -2.4990667769034502e-08
Rt142 T14 T5482 5173853.2234705491
Rt143 T15 T132 5551427.2953871917
Rt144 T15 T133 1082864.3194604446
Rt145 T15 T842 316071.57625779678
Rt146 T15 T893 2967150.7167486111
Gcorr51 T15 T894 T15 T894 -1.3651580971392603e-07
Rt147 T15 T895 3992608.730389466
Gcorr52 T15 T2211 T15 T2211 -1.1055330892283102e-07
Rt148 T15 T2862 1540963.0559888952
Rt149 T15 T2863 3177555.2158567724
Rt150 T15 T3556 1180287.3541381112
Rt151 T15 T4247 2967150.7167480872
Gcorr53 T15 T4248 T15 T4248 -1.3651580971392699e-07
Rt152 T15 T4249 3992608.7303889305
Gcorr54 T15 T5567 T15 T5567 -1.1055330892292554e-07
Rt153 T16 T135 2773598.0340029406
Gcorr55 T16 T136 T16 T136 -1.7403368639278226e-07
Rt154 T16 T840 272681.39498187084
Rt155 T16 T1555 13352272.450533785
Rt156 T16 T1558 10016450.564167947
Rt157 T16 T1796 6944119.4246900231
Rt158 T16 T2822 1610555.1428779638
Rt159 T16 T2823 2281436.4248523125
Rt160 T16 T3407 1393790.5223759026
Rt161 T16 T4909 13352272.450549452
Rt162 T16 T4912 10016450.564157808
Rt163 T16 T5151 6944119.4246907616
Rt164 T17 T153 784680.42027294717
Rt165 T17 T154 758459.83860874921
Rt166 T17 T651 455863.55524604605
Gcorr56 T17 T1207 T17 T1207 -7.8092133444544452e-08
Rt167 T17 T1230 3325221.833019041
Rt168 T17 T1257 2865862.1246083849
Gcorr57 T17 T1258 T17 T1258 -1.3271982141409866e-07
Rt169 T17 T2752 3645558.442932568
Rt170 T17 T2966 1841793.611462204
Rt171 T17 T3848 1663669.2232972097
Gcorr58 T17 T4561 T17 T4561 -7.8092133444545736e-08
Rt172 T17 T4584 3325221.8330182265
Rt173 T17 T4611 2865862.1246085684
Gcorr59 T17 T4612 T17 T4612 -1.3271982141415165e-07
Rt174 T18 T154 769844.70675095858
Rt175 T18 T155 1308683.8823432946
Rt176 T18 T629 524601.78792940069
Rt177 T18 T827 296694.50702853937
Gcorr60 T18 T1202 T18 T1202 -1.3376767041169441e-07
Rt178 T18 T1205 2648661.5197378662
Gcorr61 T18 T2121 T18 T2121 -1.3251479608938092e-07
Rt179 T18 T2129 3217995.9288922548
Rt180 T18 T3582 4005090.1072962089
Rt181 T18 T3853 1818068.3970178685
Gcorr62 T18 T4556 T18 T4556 -1.3376767041158454e-07
Rt182 T18 T4559 2648661.5197392469
Gcorr63 T18 T5477 T18 T5477 -1.3251479608933603e-07
Rt183 T18 T5485 3217995.9288918478
Rt184 T19 T155 910051.09364191571
Rt185 T19 T156 955464.8938649107
Rt186 T19 T548 472745.34232402593
Rt187 T19 T620 331105.14533688012
Rt188 T19 T1198 1373278.9132975661
Gcorr64 T19 T1200 T19 T1200 -2.7438936915841157e-07
Rt189 T19 T1201 19379103.768533353
Gcorr65 T19 T2356 T19 T2356 -1.9344869892595462e-07
Rt190 T19 T3019 1944672.8001676367
Rt191 T19 T3869 1061177.5845809362
Rt192 T19 T4552 1373278.913296947
Gcorr66 T19 T4554 T19 T4554 -2.743893691585147e-07
Rt193 T19 T4555 19379103.768576499
Gcorr67 T19 T5709 T19 T5709 -1.9344869892606691e-07
Rt194 T20 T157 957854.21792138985
Rt195 T20 T158 1072942.4070384775
Rt196 T20 T561 350904.8158634564
Rt197 T20 T653 491535.84433854336
Rt198 T20 T1192 16562162.908962552
Rt199 T20 T1193 2887307.6067980011
Gcorr68 T20 T1194 T20 T1194 -1.383096445432701e-07
Rt200 T20 T3865 3589806.7326423475
Rt201 T20 T4034 1266596.4678520472
Rt202 T20 T4546 16562162.908945704
Rt203 T20 T4547 2887307.6067992835
Gcorr69 T20 T4548 T20 T4548 -1.3830964454317952e-07
Rt204 T21 T159 849944.64598345151
Rt205 T21 T160 1150329.6566567398
Rt206 T21 T633 457127.69100725342
Rt207 T21 T778 464307.63696955168
Rt208 T21 T1188 10220398.189968199
Rt209 T21 T1336 32664085.763525441
Rt210 T21 T2443 5638831.6371779321
Rt211 T21 T3854 3629570.521776726
Rt212 T21 T4145 1186185.9425713094
Rt213 T21 T4542 10220398.189987998
Rt214 T21 T4690 32664085.7635337
Rt215 T21 T5797 5638831.6371717239
Rt216 T22 T162 1006661.0918661221
Rt217 T22 T163 1118201.7080671401
Rt218 T22 T699 540144.5945680635
Rt219 T22 T766 420928.87141208758
Rt220 T22 T1178 17644986.877418574
Gcorr70 T22 T1179 T22 T1179 -8.890992472132125e-08
Rt221 T22 T2166 2583068.8682999844
Rt222 T22 T2787 1837713.5253508009
Rt223 T22 T3845 1288995.6060041243
Rt224 T22 T4532 17644986.877428338
Gcorr71 T22 T4533 T22 T4533 -8.8909924721567418e-08
Rt225 T22 T5522 2583068.8682981492
Rt226 T23 T168 952036.7308304403
Rt227 T23 T169 231478.78737825321
Rt228 T23 T611 276167.76615030708
Rt229 T23 T635 459708.77355249663
Gcorr72 T23 T1163 T23 T1163 -1.5435993158879975e-06
Rt230 T23 T1165 365230.85022932495
Gcorr73 T23 T1242 T23 T1242 -1.257921185124387e-07
Gcorr74 T23 T2320 T23 T2320 -6.7433481962227333e-07
Rt231 T23 T2757 1685449.1050514688
Rt232 T23 T3808 2787116.8710313272
Gcorr75 T23 T4517 T23 T4517 -1.5435993158970946e-06
Rt233 T23 T4519 365230.85022825032
Gcorr76 T23 T4596 T23 T4596 -1.2579211851238306e-07
Gcorr77 T23 T5674 T23 T5674 -6.7433481962129151e-07
Rt234 T24 T170 823067.83488583937
Rt235 T24 T171 812397.84028369957
Rt236 T24 T689 536069.7295753326
Rt237 T24 T779 374144.07594397268
Gcorr78 T24 T1157 T24 T1157 -1.0687140782176523e-07
Rt238 T24 T1158 2852604.2454767968
Gcorr79 T24 T1161 T24 T1161 -1.3579275571156418e-07
Rt239 T24 T2118 4040714.0072283228
Rt240 T24 T2959 1878012.1276942841
Rt241 T24 T3873 2789562.3374526082
Gcorr80 T24 T4511 T24 T4511 -1.0687140782161343e-07
Rt242 T24 T4512 2852604.2454794254
Gcorr81 T24 T4515 T24 T4515 -1.3579275571158625e-07
Rt243 T24 T5471 4040714.0072252043
Rt244 T25 T172 1039753.053441865
Rt245 T25 T173 1107650.3060565405
Rt246 T25 T606 454477.996352015
Rt247 T25 T724 403515.60289253725
Rt248 T25 T1152 3478565.7870121114
Gcorr82 T25 T1153 T25 T1153 -5.4539571941136425e-08
Rt249 T25 T1154 3608947.0855915812
Gcorr83 T25 T1298 T25 T1298 -1.6430066437931261e-07
Rt250 T25 T2982 1603159.1926288023
Rt251 T25 T4005 1284328.9779351959
Rt252 T25 T4506 3478565.7870122548
Gcorr84 T25 T4507 T25 T4507 -5.4539571941023683e-08
Rt253 T25 T4508 3608947.0855913199
Gcorr85 T25 T4652 T25 T4652 -1.6430066437943591e-07
Rt254 T26 T173 1430286.9367348405
Rt255 T26 T174 917526.30882493057
Rt256 T26 T777 455671.0210987177
Rt257 T26 T783 361938.42493935552
Gcorr86 T26 T1148 T26 T1148 -1.4540358018966988e-07
Rt258 T26 T1150 2617458.8803331372
Rt259 T26 T1467 8468734.1456452347
Rt260 T26 T2777 4675925.4899871666
Rt261 T26 T4055 1212826.0673862535
Gcorr87 T26 T4502 T26 T4502 -1.4540358018963261e-07
Rt262 T26 T4504 2617458.8803322338
Rt263 T26 T4821 8468734.1456575356
Rt264 T27 T174 1036975.401624776
Rt265 T27 T175 873099.91414524021
Rt266 T27 T672 447616.56487957411
Rt267 T27 T767 444601.22033388057
Rt268 T27 T1136 6187185.2089422718
Rt269 T27 T1687 11957513.868130315
Rt270 T27 T2147 7776509.2200765777
Rt271 T27 T3698 3824980.0703430017
Rt272 T27 T3964 1722845.5136784979
Rt273 T27 T4490 6187185.2089435691
Rt274 T27 T5041 11957513.868145475
Rt275 T27 T5503 7776509.2200682731
Rt276 T28 T175 1276691.4718513542
Rt277 T28 T176 991544.66778211144
Rt278 T28 T638 413361.69773395272
Rt279 T28 T787 391901.43469651439
Rt280 T28 T1131 3199506.4118959326
Gcorr88 T28 T1133 T28 T1133 -5.4215724480838295e-08
Rt281 T28 T1134 10856235.183652258
Rt282 T28 T2965 1770861.6815603005
Rt283 T28 T3940 3794718.2645774013
Rt284 T28 T4485 3199506.411897928
Gcorr89 T28 T4487 T28 T4487 -5.4215724480771036e-08
Rt285 T28 T4488 10856235.183637477
Rt286 T29 T176 901561.65332155547
Rt287 T29 T177 689871.86775020882
Rt288 T29 T545 434427.98574489902
Rt289 T29 T648 430795.18768638163
Rt290 T29 T1130 5153787.1027442347
Gcorr90 T29 T1132 T29 T1132 -1.3567244406007552e-07
Gcorr91 T29 T1478 T29 T1478 -1.3525123070830564e-07
Rt291 T29 T2259 2966143.2133181174
Rt292 T29 T2760 3984440.1351804244
Rt293 T29 T3932 1233972.8390850276
Rt294 T29 T4484 5153787.1027454156
Gcorr92 T29 T4486 T29 T4486 -1.3567244405996334e-07
Gcorr93 T29 T4832 T29 T4832 -1.3525123070838923e-07
Rt295 T29 T5614 2966143.2133179926
Rt296 T30 T178 731649.77979605645
Rt297 T30 T179 694601.5718353783
Rt298 T30 T543 304495.60537545965
Rt299 T30 T649 684988.73282433639
Gcorr94 T30 T1812 T30 T1812 -3.3181451985282897e-07
Rt300 T30 T1913 19638541.011035644
Rt301 T30 T2337 1971548.6036029086
Rt302 T30 T3874 3636585.9667951521
Rt303 T30 T4071 1284218.4421963256
Gcorr95 T30 T5167 T30 T5167 -3.318145198527935e-07
Rt304 T30 T5270 19638541.011104938
Rt305 T30 T5690 1971548.6036023542
Rt306 T31 T180 735621.07911753491
Rt307 T31 T181 1290313.7651073735
Rt308 T31 T552 429311.58813739417
Rt309 T31 T671 458723.92304654
Rt310 T31 T1674 7252045.4814730529
Rt311 T31 T2272 21386024.558432493
Rt312 T31 T2730 10548386.473019049
Rt313 T31 T3531 2202786.8619397939
Rt314 T31 T3885 2814218.3178923572
Rt315 T31 T5028 7252045.4814675851
Rt316 T31 T5626 21386024.558506645
Rt317 T31 T6085 10548386.473012788
Rt318 T32 T185 889852.69979216915
Rt319 T32 T186 819588.10762698506
Rt320 T32 T601 466684.11572478211
Rt321 T32 T639 432036.81454596971
Rt322 T32 T2060 2670598.9671726776
Gcorr96 T32 T2061 T32 T2061 -1.9278299694417119e-07
Rt323 T32 T2062 10000826.050473597
Rt324 T32 T2594 11653112.223131245
Rt325 T32 T2926 2083039.7182062415
Rt326 T32 T3842 2996051.8064988558
Rt327 T32 T5414 2670598.9671727205
Gcorr97 T32 T5415 T32 T5415 -1.9278299694381927e-07
Rt328 T32 T5416 10000826.05049644
Rt329 T32 T5948 11653112.223147521
Rt330 T33 T191 1094360.3773032259
Rt331 T33 T192 741106.46047108888
Rt332 T33 T547 462731.17772571603
Rt333 T33 T640 479247.35720475868
Rt334 T33 T1700 14096091.048564326
Gcorr98 T33 T1941 T33 T1941 -1.4720047911557559e-07
Rt335 T33 T2413 3990198.4691826911
Rt336 T33 T2517 9560615.9495002404
Rt337 T33 T2983 1529673.6624208644
Rt338 T33 T3878 1419749.3608852553
Rt339 T33 T5054 14096091.048550768
Gcorr99 T33 T5297 T33 T5297 -1.4720047911565373e-07
Rt340 T33 T5766 3990198.4691757513
Rt341 T33 T5871 9560615.9495393448
Rt342 T34 T193 1036891.6991124937
Rt343 T34 T194 724258.70877800789
Rt344 T34 T551 423473.42278872599
Rt345 T34 T809 505160.19361051702
Gcorr100 T34 T988 T34 T988 -8.5670670636391134e-08
Rt346 T34 T2373 4303233.2447473155
Rt347 T34 T2495 14004787.549786551
Rt348 T34 T2989 1610133.9905613251
Rt349 T34 T4050 2696181.7896009837
Gcorr101 T34 T4342 T34 T4342 -8.5670670636613811e-08
Rt350 T34 T5727 4303233.2447417704
Rt351 T34 T5849 14004787.54980188
Rt352 T35 T195 1266703.1216127784
Rt353 T35 T196 1378818.7110780745
Rt354 T35 T697 462110.51917059836
Rt355 T35 T830 302282.73350615986
Rt356 T35 T2029 3896786.6003545318
Rt357 T35 T2068 12624720.519895114
Gcorr102 T35 T2246 T35 T2246 -4.8156851594788747e-08
Rt358 T35 T2756 2345692.3394155726
Rt359 T35 T3923 2161165.8692540796
Rt360 T35 T5382 3896786.6003503716
Rt361 T35 T5422 12624720.519915346
Gcorr103 T35 T5601 T35 T5601 -4.8156851594937706e-08
Rt362 T36 T196 969437.23432567762
Rt363 T36 T197 1439183.0818944518
Rt364 T36 T621 511849.32477280288
Rt365 T36 T815 312192.25503702351
Gcorr104 T36 T972 T36 T972 -5.0201443620171653e-07
Rt366 T36 T974 39531388.109053001
Rt367 T36 T976 974771.20839771244
Gcorr105 T36 T986 T36 T986 -1.8136328585166853e-07
Rt368 T36 T2955 688508.26910698926
Rt369 T36 T4139 1101405.6943504736
Gcorr106 T36 T4326 T36 T4326 -5.0201443620069311e-07
Rt370 T36 T4328 39531388.109035403
Rt371 T36 T4330 974771.20839841245
Gcorr107 T36 T4340 T36 T4340 -1.8136328585196904e-07
Rt372 T37 T197 1079530.344367638
Rt373 T37 T198 835889.06812192046
Rt374 T37 T617 415496.38640692731
Rt375 T37 T776 368115.19647364336
Rt376 T37 T2012 9293067.4761572871
Gcorr108 T37 T2151 T37 T2151 -1.3252437035124915e-07
Rt377 T37 T2196 2835685.6028584917
Rt378 T37 T2206 8914903.0247251242
Rt379 T37 T2778 1598956.4776154652
Rt380 T37 T3889 15192980.975913491
Rt381 T37 T5365 9293067.4761508275
Gcorr109 T37 T5507 T37 T5507 -1.3252437035124084e-07
Rt382 T37 T5553 2835685.6028581737
Rt383 T37 T5562 8914903.0247350987
Rt384 T38 T198 1056845.5493594159
Rt385 T38 T199 978835.54084366874
Rt386 T38 T610 457836.45660534536
Rt387 T38 T780 392881.73660129745
Rt388 T38 T1015 7475864.4652305236
Rt389 T38 T1814 4349723.4396377048
Rt390 T38 T2459 520319849.6900177
Gcorr110 T38 T2726 T38 T2726 -1.0940652666772835e-08
Rt391 T38 T2841 7304040.0991223156
Rt392 T38 T4182 1090333.3984613349
Rt393 T38 T4369 7475864.4652336445
Rt394 T38 T5169 4349723.4396296786
Rt395 T38 T5813 520319849.677522
Gcorr111 T38 T6081 T38 T6081 -1.0940652667189747e-08
Rt396 T39 T199 844446.40621342417
Rt397 T39 T200 739500.11063095729
Rt398 T39 T647 484624.54050183221
Rt399 T39 T696 433137.7716389001
Gcorr112 T39 T1266 T39 T1266 -8.4787298409939382e-08
Gcorr113 T39 T1959 T39 T1959 -2.2885186743934366e-08
Rt400 T39 T2260 4460477.9130469635
Rt401 T39 T2267 3776462.5437940452
Rt402 T39 T3597 4134761.2245636843
Rt403 T39 T3913 1606023.3924881283
Gcorr114 T39 T4620 T39 T4620 -8.4787298409976558e-08
Gcorr115 T39 T5313 T39 T5313 -2.2885186744283267e-08
Rt404 T39 T5615 4460477.9130445272
Rt405 T39 T5622 3776462.5437903232
Rt406 T40 T201 716582.71447529108
Rt407 T40 T202 968551.87666854088
Rt408 T40 T577 414075.05598726502
Rt409 T40 T626 544722.06739374902
Rt410 T40 T1033 8949788.7595081218
Rt411 T40 T1910 16946018.287599411
Rt412 T40 T1911 7121295.2908794004
Rt413 T40 T2950 1391505.6211019105
Rt414 T40 T3971 5082169.1906179665
Rt415 T40 T4387 8949788.7594938241
Rt416 T40 T5267 16946018.28758657
Rt417 T40 T5268 7121295.2908908296
Rt418 T41 T204 1011959.987943776
Rt419 T41 T205 889022.80632657558
Rt420 T41 T605 487299.79985693918
Rt421 T41 T773 413515.0509869277
Rt422 T41 T1013 20569303.467694357
Rt423 T41 T1075 9945298.520677954
Rt424 T41 T2085 5030807.4983340446
Gcorr116 T41 T2691 T41 T2691 -5.0858964619496426e-08
Rt425 T41 T2957 3853259.0141563183
Rt426 T41 T4036 1228960.3222093142
Rt427 T41 T4367 20569303.467612341
Rt428 T41 T4429 9945298.52067036
Rt429 T41 T5439 5030807.4983371003
Gcorr117 T41 T6045 T41 T6045 -5.085896461964835e-08
Rt430 T42 T210 715782.83667668363
Rt431 T42 T211 891675.07271174807
Rt432 T42 T650 487377.73043498909
Rt433 T42 T784 463583.37676048448
Gcorr118 T42 T1025 T42 T1025 -1.4065596527090961e-07
Rt434 T42 T1787 15662146.710112248
Rt435 T42 T2084 2966847.4681576081
Rt436 T42 T2095 9096264.3017497323
Rt437 T42 T3651 1946131.3639996925
Rt438 T42 T3876 2600442.1891980139
Gcorr119 T42 T4379 T42 T4379 -1.4065596527097377e-07
Rt439 T42 T5141 15662146.710100949
Rt440 T42 T5438 2966847.4681533501
Rt441 T42 T5448 9096264.3017884661
Rt442 T43 T213 856236.0761339512
Rt443 T43 T214 777532.77866534819
Rt444 T43 T602 520841.81555160868
Rt445 T43 T632 487852.16946718632
Rt446 T43 T1039 12577129.056018554
Rt447 T43 T1791 7025430.2510484643
Rt448 T43 T2063 8294274.5789459581
Rt449 T43 T2956 1932763.1675207003
Rt450 T43 T3909 2742150.7517839796
Rt451 T43 T4393 12577129.055974618
Rt452 T43 T5146 7025430.2510416182
Rt453 T43 T5417 8294274.5789747685
Rt454 T44 T215 807716.01509295159
Rt455 T44 T216 751334.89059640933
Rt456 T44 T571 417006.85978960921
Rt457 T44 T644 504802.76558771083
Gcorr120 T44 T1045 T44 T1045 -1.4515690552725266e-07
Rt458 T44 T1261 7639636.9799258383
Rt459 T44 T1974 14720577.494545026
Rt460 T44 T2083 4116838.3560428685
Rt461 T44 T3682 4837206.1525042979
Rt462 T44 T3961 1018683.7880574641
Gcorr121 T44 T4399 T44 T4399 -1.4515690552688028e-07
Rt463 T44 T4615 7639636.9799029287
Rt464 T44 T5328 14720577.494633442
Rt465 T44 T5437 4116838.35604895
Rt466 T45 T217 980562.13455302513
Rt467 T45 T218 983989.1239521089
Rt468 T45 T549 487818.75296510529
Rt469 T45 T796 458338.17053262948
Rt470 T45 T1048 4053397.4379451778
Rt471 T45 T3750 4049423.8222359749
Rt472 T45 T4056 2345494.0327496389
Rt473 T45 T4402 4053397.4379452048
Rt474 T46 T219 569995.25525905192
Rt475 T46 T220 639876.39761329989
Rt476 T46 T793 480109.72947277041
Rt477 T46 T801 472136.26140865765
Gcorr122 T46 T1061 T46 T1061 -2.3853548858279865e-07
Rt478 T46 T2171 1027173.9128232023
Gcorr123 T46 T2295 T46 T2295 -5.3197575735317228e-07
Rt479 T46 T3042 420944.22529603494
Gcorr124 T46 T4415 T46 T4415 -2.3853548858308346e-07
Rt480 T46 T5528 1027173.9128236648
Gcorr125 T46 T5649 T46 T5649 -5.3197575735245061e-07
Rt481 T47 T221 484176.80411823501
Rt482 T47 T222 978623.81372551154
Rt483 T47 T691 519210.16467732401
Gcorr126 T47 T1848 T47 T1848 -1.1207307180444476e-07
Rt484 T47 T2044 3042562.8089626995
Rt485 T47 T2184 10001062.382153347
Rt486 T47 T2761 1056823.1518562695
Rt487 T47 T2801 3329765.5849333322
Rt488 T47 T3994 5288070.7137659211
Gcorr127 T47 T5203 T47 T5203 -1.1207307180471662e-07
Rt489 T47 T5398 3042562.8089584932
Rt490 T47 T5541 10001062.382171815
Gcorr128 T48 T239 T48 T239 -1.4648423444940292e-07
Rt491 T48 T240 1410506.9779064881
Rt492 T48 T841 316672.01143876649
Gcorr129 T48 T1251 T48 T1251 -1.5801226272047037e-07
Rt493 T48 T1311 3501727.3105268483
Rt494 T48 T1312 2848078.8666851111
Gcorr130 T48 T1313 T48 T1313 -1.1154436516032146e-07
Rt495 T48 T2891 1459686.2789771156
Rt496 T48 T2892 3119399.5964569957
Rt497 T48 T3526 1860886.0699366797
Rt498 T48 T4189 2043011.1654900683
Gcorr131 T48 T4605 T48 T4605 -1.5801226272041669e-07
Rt499 T48 T4665 3501727.3105152934
Rt500 T48 T4666 2848078.866694083
Gcorr132 T48 T4667 T48 T4667 -1.1154436516021374e-07
Rt501 T49 T242 1505095.369132672
Gcorr133 T49 T243 T49 T243 -1.2681635709066226e-07
Rt502 T49 T843 317110.31850443373
Gcorr134 T49 T1317 T49 T1317 -1.3432326012171596e-08
Rt503 T49 T1318 2272634.4632614609
Rt504 T49 T1319 2862981.0067086569
Gcorr135 T49 T1320 T49 T1320 -4.1914029448157363e-07
Rt505 T49 T2868 698137.591674831
Rt506 T49 T2869 3584731.3378533134
Rt507 T49 T3220 2128706.4500907236
Rt508 T49 T4193 3891345.8352617924
Gcorr136 T49 T4671 T49 T4671 -1.3432326011593006e-08
Rt509 T49 T4672 2272634.4632645333
Rt510 T49 T4673 2862981.0067088427
Gcorr137 T49 T4674 T49 T4674 -4.1914029448153705e-07
Rt511 T50 T260 794007.29155020125
Rt512 T50 T261 842422.91595735808
Rt513 T50 T612 552146.68958968855
Rt514 T50 T613 569831.73089888599
Rt515 T50 T831 790988.6189903277
Rt516 T50 T1054 4710418.7403122671
Gcorr138 T50 T1055 T50 T1055 -1.4604195021706917e-07
Rt517 T50 T1056 3561598.1728764614
Rt518 T50 T1057 10349206.181286726
Rt519 T50 T3216 1810365.6705580303
Rt520 T50 T4171 6454408.9967814274
Rt521 T50 T4408 4710418.7403214732
Gcorr139 T50 T4409 T50 T4409 -1.4604195021747625e-07
Rt522 T50 T4410 3561598.1728724684
Rt523 T50 T4411 10349206.181232717
Rt524 T51 T262 541284.70651256794
Rt525 T51 T263 688752.12557706982
Rt526 T51 T634 744803.58695134951
Rt527 T51 T822 308358.61519452819
Gcorr140 T51 T1241 T51 T1241 -4.6032676310671964e-07
Gcorr141 T51 T1885 T51 T1885 -4.8139516403838593e-07
Gcorr142 T51 T1958 T51 T1958 -8.0770140307604547e-08
Gcorr143 T51 T2308 T51 T2308 -1.3556049291629111e-07
Rt528 T51 T2689 663202.22644400306
Rt529 T51 T2785 989226.51535030978
Rt530 T51 T3543 3023699.0942752962
Gcorr144 T51 T4595 T51 T4595 -4.6032676310619284e-07
Gcorr145 T51 T5242 T51 T5242 -4.8139516403822595e-07
Gcorr146 T51 T5312 T51 T5312 -8.0770140307810151e-08
Gcorr147 T51 T5662 T51 T5662 -1.3556049291614246e-07
Rt531 T51 T6043 663202.22644428117
Rt532 T52 T265 1339434.4891074889
Rt533 T52 T266 765203.04512129165
Rt534 T52 T589 711852.79664208507
Rt535 T52 T826 394809.28406709159
Gcorr148 T52 T1589 T52 T1589 -3.8534933537549364e-07
Rt536 T52 T1998 10497173.165762091
Rt537 T52 T2312 2246905.5836220575
Rt538 T52 T2380 6548677.0458320957
Rt539 T52 T2838 3061761.2451713816
Rt540 T52 T3398 676447.75242027675
Gcorr149 T52 T4943 T52 T4943 -3.8534933537553784e-07
Rt541 T52 T5350 10497173.165774448
Rt542 T52 T5666 2246905.5836237264
Rt543 T52 T5734 6548677.0458113095
Rt544 T53 T268 974917.15228354884
Rt545 T53 T269 935165.27105636091
Rt546 T53 T580 427927.6361356008
Rt547 T53 T818 422211.91762326111
Gcorr150 T53 T1419 T53 T1419 -2.5501660157454438e-07
Rt548 T53 T1421 1480099.618118284
Rt549 T53 T1423 10424396.347416379
Gcorr151 T53 T1424 T53 T1424 -1.9870711935955793e-07
Rt550 T53 T2842 1035173.486481729
Rt551 T53 T3752 3651833.6827071779
Gcorr152 T53 T4773 T53 T4773 -2.5501660157455798e-07
Rt552 T53 T4775 1480099.618118759
Rt553 T53 T4777 10424396.347395385
Gcorr153 T53 T4778 T53 T4778 -1.9870711935952294e-07
Rt554 T54 T272 756558.6743667759
Rt555 T54 T273 996190.9050058244
Rt556 T54 T592 588463.1307852203
Rt557 T54 T769 466781.19667738234
Rt558 T54 T1803 17323278.377494823
Rt559 T54 T2045 11061829.273550004
Rt560 T54 T2296 6411839.1186565151
Rt561 T54 T2846 3220095.0768843694
Rt562 T54 T3788 1644480.528580694
Rt563 T54 T5158 17323278.377649426
Rt564 T54 T5399 11061829.273549357
Rt565 T54 T5650 6411839.1186356358
Rt566 T55 T273 484143.05969776789
Rt567 T55 T274 813826.92038274556
Rt568 T55 T583 530465.40836623812
Rt569 T55 T758 528994.24352245114
Gcorr154 T55 T1715 T55 T1715 -4.325844093793016e-07
Gcorr155 T55 T1803 T55 T1803 -5.0074485750817563e-07
Gcorr156 T55 T2064 T55 T2064 -4.3456709320322427e-07
Rt570 T55 T2354 589327.33604025177
Rt571 T55 T2861 754718.41179849184
Rt572 T55 T3545 608887.40803152986
Gcorr157 T55 T5069 T55 T5069 -4.3258440937976868e-07
Gcorr158 T55 T5158 T55 T5158 -5.0074485750795349e-07
Gcorr159 T55 T5418 T55 T5418 -4.3456709320333322e-07
Rt573 T55 T5707 589327.33604012954
Rt574 T56 T277 832619.22604163794
Rt575 T56 T278 886298.55809262441
Rt576 T56 T645 671057.18745923974
Rt577 T56 T805 389684.33256089559
Rt578 T56 T1724 19772132.136817202
Rt579 T56 T1725 2799133.6971662003
Rt580 T56 T1726 10474222.952410916
Gcorr160 T56 T1750 T56 T1750 -1.610604178268735e-07
Rt581 T56 T2859 2882527.2154995566
Rt582 T56 T3849 1458158.580186235
Rt583 T56 T5078 19772132.136744298
Rt584 T56 T5079 2799133.6971623707
Rt585 T56 T5080 10474222.952466931
Gcorr161 T56 T5104 T56 T5104 -1.6106041782704055e-07
Rt586 T57 T280 487167.06375843904
Rt587 T57 T281 691790.50943745743
Rt588 T57 T564 537361.64707900665
Rt589 T57 T829 719552.90009136603
Rt590 T57 T1733 2994245.9216690538
Gcorr162 T57 T1735 T57 T1735 -8.5432309185282848e-08
Rt591 T57 T1745 2089836.8565618272
Gcorr163 T57 T2426 T57 T2426 -4.1812729047198562e-07
Rt592 T57 T2794 1432200.0224500955
Rt593 T57 T3685 3231681.7189796781
Rt594 T57 T5087 2994245.9216686171
Gcorr164 T57 T5089 T57 T5089 -8.5432309185663127e-08
Rt595 T57 T5099 2089836.8565622966
Gcorr165 T57 T5779 T57 T5779 -4.1812729047154871e-07
Rt596 T58 T283 1675773.7502191539
Rt597 T58 T284 925264.31962052779
Rt598 T58 T586 775648.37305794947
Rt599 T58 T833 352113.18311058293
Rt600 T58 T1742 12076018.918818595
Rt601 T58 T1775 3409386.1803948153
Gcorr166 T58 T2143 T58 T2143 -9.2944034663823843e-08
Rt602 T58 T2793 1468047.3450216621
Rt603 T58 T3663 1556921.8926991713
Rt604 T58 T5096 12076018.91875395
Rt605 T58 T5129 3409386.1803996866
Gcorr167 T58 T5499 T58 T5499 -9.2944034663849942e-08
Rt606 T59 T286 949315.7626702846
Rt607 T59 T287 452155.40348827111
Rt608 T59 T591 392261.11346875393
Rt609 T59 T838 373557.785528254
Gcorr168 T59 T1300 T59 T1300 -4.7731004119659441e-07
Gcorr169 T59 T1301 T59 T1301 -4.3491601085756655e-07
Rt610 T59 T1302 579363.14205825469
Gcorr170 T59 T1528 T59 T1528 -5.1825519398909791e-07
Rt611 T59 T2782 860972.6735700696
Rt612 T59 T3255 2649722.460993228
Gcorr171 T59 T4654 T59 T4654 -4.7731004119647688e-07
Gcorr172 T59 T4655 T59 T4655 -4.3491601085760419e-07
Rt613 T59 T4656 579363.1420582094
Gcorr173 T59 T4882 T59 T4882 -5.1825519398931454e-07
Rt614 T60 T289 956998.53653730487
Rt615 T60 T290 301272.75977404712
Rt616 T60 T750 623642.68140109838
Rt617 T60 T834 422069.73925999092
Rt618 T60 T1072 23299199.958075028
Rt619 T60 T1233 4671487.3674596054
Rt620 T60 T1234 1007070.6839451665
Gcorr174 T60 T1235 T60 T1235 -9.653944999507811e-07
Rt621 T60 T2783 1572037.4401141838
Rt622 T60 T3340 3561992.7675441517
Rt623 T60 T4426 23299199.958206277
Rt624 T60 T4587 4671487.3674537912
Rt625 T60 T4588 1007070.6839444905
Gcorr175 T60 T4589 T60 T4589 -9.6539449995147439e-07
Rt626 T61 T292 1304025.6861995121
Rt627 T61 T293 1014656.1812539824
Rt628 T61 T630 560787.53762843437
Rt629 T61 T823 455041.15730887151
Gcorr176 T61 T1403 T61 T1403 -9.8262019186373453e-08
Rt630 T61 T1683 2796762.4482127088
Rt631 T61 T1773 30315009.251386262
Rt632 T61 T2790 1402362.2723578059
Rt633 T61 T3815 1419645.8981157918
Gcorr177 T61 T4757 T61 T4757 -9.8262019186419762e-08
Rt634 T61 T5037 2796762.4482145035
Rt635 T61 T5127 30315009.251134641
Rt636 T62 T295 932211.92659085686
Rt637 T62 T296 893636.17225812387
Rt638 T62 T716 528151.86682266893
Rt639 T62 T813 269726.28070629301
Rt640 T62 T1355 1006955.1168445033
Rt641 T62 T1530 28966926.943855844
Gcorr178 T62 T1692 T62 T1692 -1.0282972076957227e-07
Gcorr179 T62 T2197 T62 T2197 -5.8042760940044073e-07
Rt642 T62 T2791 1594904.3380886
Rt643 T62 T3558 3308739.4684734726
Rt644 T62 T4709 1006955.1168448627
Rt645 T62 T4884 28966926.944002338
Gcorr180 T62 T5046 T62 T5046 -1.0282972076960122e-07
Gcorr181 T62 T5554 T62 T5554 -5.8042760939988486e-07
Rt646 T63 T299 1207245.4225581326
Rt647 T63 T300 759267.08066683915
Rt648 T63 T623 523001.36265020567
Rt649 T63 T788 358049.13362890726
Rt650 T63 T1351 1384585.416772797
Gcorr182 T63 T1408 T63 T1408 -1.6433085055602581e-07
Rt651 T63 T1466 18408423.819977824
Gcorr183 T63 T2150 T63 T2150 -2.3005733717282009e-07
Rt652 T63 T2831 3231520.0598367942
Rt653 T63 T3676 1281721.3659490426
Rt654 T63 T4705 1384585.4167736149
Gcorr184 T63 T4762 T63 T4762 -1.6433085055586381e-07
Rt655 T63 T4820 18408423.81986491
Gcorr185 T63 T5506 T63 T5506 -2.3005733717289127e-07
Rt656 T64 T65 705332.21530563559
Rt657 T64 T301 8177599.8149096239
Gcorr186 T64 T323 T64 T323 -2.0009255686694566e-08
Rt658 T64 T435 9437767.5183109976
Rt659 T64 T450 613943249.45654106
Gcorr187 T64 T2611 T64 T2611 -5.8835567551316953e-08
Rt660 T64 T4107 4178816.8074656883
Rt661 T65 T72 705332.21530564048
Rt662 T65 T323 8082835.8618671848
Rt663 T65 T450 7333726.8663494075
Rt664 T65 T4107 4243730.5869548172
Rt665 T66 T67 639520.96327019238
Rt666 T66 T322 58511739.394491613
Gcorr188 T66 T345 T66 T345 -9.0094006484720515e-08
Rt667 T66 T346 19049949.163485084
Rt668 T66 T2592 3893790.4610189027
Rt669 T67 T73 639520.96327019623
Rt670 T67 T345 2024042.5850078883
Gcorr189 T67 T346 T67 T346 -4.2115952383523789e-08
Rt671 T67 T361 2811502.308472503
Gcorr190 T67 T473 T67 T473 -4.2115952383524094e-08
Rt672 T67 T2592 46080066.717335701
Gcorr191 T67 T3988 T67 T3988 -1.8243364470592464e-09
Rt673 T67 T5946 46080066.717338175
Rt674 T68 T69 638553.29111676
Rt675 T68 T360 15730177.825128457
Rt676 T68 T376 15118052.46973048
Rt677 T68 T2533 15569547.858241417
Rt678 T69 T74 638553.2911167643
Gcorr192 T69 T360 T69 T360 -2.5276980212878308e-08
Rt679 T69 T375 1916412.0134795008
Gcorr193 T69 T376 T69 T376 -3.2181257574456429e-08
Rt680 T69 T399 2310019.3738085586
Gcorr194 T69 T487 T69 T487 -2.527698021287851e-08
Gcorr195 T69 T488 T69 T488 -3.218125757445676e-08
Rt681 T69 T2533 2883977.2725478821
Gcorr196 T69 T3897 T69 T3897 -4.7021658910436706e-07
Rt682 T69 T5887 2883977.2725478932
Rt683 T70 T71 92836.095347059731
Rt684 T70 T398 4478233.5098145092
Rt685 T70 T422 311082088.23896819
Gcorr197 T70 T436 T70 T436 -7.0533411370860375e-08
Rt686 T70 T2646 106865.73087060222
Gcorr198 T70 T4080 T70 T4080 -9.1914297636081039e-06
Rt687 T71 T75 92836.095347059207
Gcorr199 T71 T398 T71 T398 -1.1212552598774748e-07
Rt688 T71 T421 7805419.890596942
Rt689 T71 T436 2001856.5768866576
Gcorr200 T71 T510 T71 T510 -1.1212552598774829e-07
Gcorr201 T71 T2646 T71 T2646 -9.1861412954219431e-06
Rt690 T71 T4080 53787.068415580368
Gcorr202 T71 T6000 T71 T6000 -9.1861412954220143e-06
Gcorr203 T72 T323 T72 T323 -2.0009255686695069e-08
Rt691 T72 T450 613943249.45676732
Rt692 T72 T451 8177599.8149095448
Rt693 T72 T524 9437767.518310884
Rt694 T72 T4107 4178816.8074656958
Gcorr204 T72 T5965 T72 T5965 -5.8835567551315497e-08
Gcorr205 T73 T345 T73 T345 -9.0094006484721507e-08
Rt695 T73 T472 58511739.394490004
Rt696 T73 T473 19049949.163484953
Rt697 T73 T5946 3893790.4610188762
Rt698 T74 T487 15730177.825128349
Rt699 T74 T488 15118052.469730377
Rt700 T74 T5887 15569547.858241314
Gcorr206 T75 T436 T75 T436 -7.0533411370861487e-08
Rt701 T75 T510 4478233.5098144785
Rt702 T75 T511 311082088.23891205
Gcorr207 T75 T4080 T75 T4080 -9.1914297636081767e-06
Rt703 T75 T6000 106865.7308706014
Rt704 T76 T77 981337.63535566919
Rt705 T76 T619 531334.94879739638
Rt706 T76 T821 418120.71157369047
Rt707 T76 T2102 6622617.9705018587
Rt708 T76 T2434 25785031.908063237
Rt709 T76 T2562 5351493.8787151491
Rt710 T76 T2832 3568720.4363963911
Rt711 T76 T3670 1822373.3686574034
Rt712 T76 T5455 6622617.9705138616
Rt713 T76 T5788 25785031.908075146
Rt714 T76 T5916 5351493.8787068706
Rt715 T77 T78 970707.90293191758
Rt716 T77 T619 528482.21798588312
Rt717 T77 T804 461334.86235620076
Rt718 T77 T1113 5075999.533770551
Gcorr208 T77 T2104 T77 T2104 -9.2989398794436014e-08
Rt719 T77 T2562 4039522.8881481979
Rt720 T77 T2654 42815782.716894843
Rt721 T77 T3670 1516881.4397004205
Rt722 T77 T3805 1715808.6505926601
Rt723 T77 T4467 5075999.5337649109
Gcorr209 T77 T5457 T77 T5457 -9.2989398794543997e-08
Rt724 T77 T5916 4039522.8881536978
Rt725 T77 T6008 42815782.716484815
Rt726 T78 T79 463908.67647304223
Rt727 T78 T628 594748.58262881124
Rt728 T78 T804 403427.47017234808
Rt729 T78 T996 4035948.9671629523
Gcorr210 T78 T1077 T78 T1077 -4.4424836197632311e-07
Rt730 T78 T1113 53454208.281355605
Rt731 T78 T2160 1233294.1641707071
Gcorr211 T78 T2654 T78 T2654 -2.5814324177129699e-07
Rt732 T78 T2834 3542485.7805433352
Rt733 T78 T3805 1093570.4412588901
Rt734 T78 T4350 4035948.967161939
Gcorr212 T78 T4431 T78 T4431 -4.4424836197624074e-07
Rt735 T78 T4467 53454208.282019891
Rt736 T78 T5516 1233294.1641709271
Gcorr213 T78 T6008 T78 T6008 -2.5814324177106691e-07
Rt737 T79 T628 439229.83461953263
Rt738 T79 T814 417088.96175382071
Gcorr214 T79 T996 T79 T996 -4.4488501247870445e-07
Rt739 T79 T1077 872520.23575171374
Gcorr215 T79 T1249 T79 T1249 -1.8368065831002702e-07
Rt740 T79 T1299 13686771.15335983
Gcorr216 T79 T2160 T79 T2160 -2.0408235027806637e-07
Rt741 T79 T2834 1672132.3726780291
Rt742 T79 T3560 2005872.1494808961
Gcorr217 T79 T4350 T79 T4350 -4.4488501247873997e-07
Rt743 T79 T4431 872520.23575168476
Gcorr218 T79 T4603 T79 T4603 -1.8368065830991947e-07
Rt744 T79 T4653 13686771.153360385
Gcorr219 T79 T5516 T79 T5516 -2.0408235027817622e-07
Rt745 T80 T81 935140.15089727985
Rt746 T80 T636 314214.90512838325
Rt747 T80 T718 361149.41484450636
Gcorr220 T80 T1078 T80 T1078 -5.0437974706092094e-07
Gcorr221 T80 T1249 T80 T1249 -5.161684423323301e-07
Rt748 T80 T1373 536278.72544046596
Gcorr222 T80 T1374 T80 T1374 -5.0891385641347943e-07
Rt749 T80 T2789 1336477.5143582188
Rt750 T80 T3742 3071417.7487501679
Gcorr223 T80 T4432 T80 T4432 -5.0437974706164378e-07
Gcorr224 T80 T4603 T80 T4603 -5.1616844233190373e-07
Rt751 T80 T4727 536278.72544008412
Gcorr225 T80 T4728 T80 T4728 -5.089138564145126e-07
Rt752 T81 T82 957920.6626200201
Rt753 T81 T642 564100.88988910627
Rt754 T81 T718 481112.56013580825
Rt755 T81 T1373 25533625.316940874
Rt756 T81 T1523 2494550.3466397105
Gcorr226 T81 T1784 T81 T1784 -1.0479796038484583e-07
Rt757 T81 T3739 1315123.9696426599
Rt758 T81 T3742 1688518.3425192391
Rt759 T81 T4727 25533625.317203242
Rt760 T81 T4877 2494550.3466384825
Gcorr227 T81 T5138 T81 T5138 -1.0479796038464295e-07
Rt761 T82 T642 493613.63254706573
Rt762 T82 T693 530469.32501204475
Rt763 T82 T1523 11433774.567435067
Rt764 T82 T1811 7268461.475968238
Rt765 T82 T2077 9638839.7822940163
Rt766 T82 T2788 3044046.8364837724
Rt767 T82 T3739 1514917.0377227867
Rt768 T82 T4877 11433774.567459153
Rt769 T82 T5166 7268461.4759617867
Rt770 T82 T5431 9638839.7822884545
Rt771 T83 T84 969914.92009760323
Rt772 T83 T614 603075.72289634217
Rt773 T83 T824 378461.61016725161
Rt774 T83 T1280 3490665.2353324294
Rt775 T83 T2078 12429670.907687433
Gcorr228 T83 T2508 T83 T2508 -7.0633294727092184e-08
Rt776 T83 T2781 1328732.4446573157
Rt777 T83 T3713 6032186.6991072837
Rt778 T83 T4634 3490665.2353305789
Rt779 T83 T5432 12429670.907711448
Gcorr229 T83 T5862 T83 T5862 -7.0633294727090609e-08
Rt780 T84 T85 968009.23748099012
Rt781 T84 T614 565463.41371553717
Rt782 T84 T760 466062.34048485727
Rt783 T84 T1142 13165541.424282519
Gcorr230 T84 T1145 T84 T1145 -7.5776071445572996e-08
Rt784 T84 T1280 3534420.0645717708
Rt785 T84 T2781 1473332.1924670944
Rt786 T84 T3858 1472377.3152325891
Rt787 T84 T4496 13165541.424278462
Gcorr231 T84 T4499 T84 T4499 -7.5776071445437206e-08
Rt788 T84 T4634 3534420.064573783
Rt789 T85 T760 614203.99423392909
Rt790 T85 T832 335475.96637801669
Gcorr232 T85 T1141 T85 T1141 -1.3392961533479905e-07
Rt791 T85 T1142 2757719.7031928087
Rt792 T85 T1143 26289266.983414855
Rt793 T85 T3339 3038510.1248914283
Rt794 T85 T3858 1377724.6712691535
Gcorr233 T85 T4495 T85 T4495 -1.3392961533467965e-07
Rt795 T85 T4496 2757719.7031935267
Rt796 T85 T4497 26289266.983433396
Rt797 T86 T87 1009199.9812118083
Rt798 T86 T578 474297.32445589389
Rt799 T86 T775 429369.90458928159
Gcorr234 T86 T1139 T86 T1139 -1.2368094912833175e-07
Rt800 T86 T1141 24445019.398730334
Rt801 T86 T2149 2651444.7263003271
Rt802 T86 T2780 1554692.9209731747
Rt803 T86 T3795 3330576.5178473843
Gcorr235 T86 T4493 T86 T4493 -1.2368094912840443e-07
Rt804 T86 T4495 24445019.398804259
Rt805 T86 T5505 2651444.7262989604
Rt806 T87 T88 737990.15843129787
Rt807 T87 T593 571888.31957143487
Rt808 T87 T775 459991.15970589098
Rt809 T87 T2149 12127453.650294608
Rt810 T87 T2178 8468913.5498262141
Rt811 T87 T2181 10479704.177191695
Rt812 T87 T3795 1654211.9413279251
Rt813 T87 T3796 3279110.4112985218
Rt814 T87 T5505 12127453.650311375
Rt815 T87 T5535 8468913.5498292297
Rt816 T87 T5538 10479704.177174775
Rt817 T88 T593 521157.3999444815
Rt818 T88 T837 433256.18112687021
Rt819 T88 T2145 1442355.1884291561
Gcorr236 T88 T2170 T88 T2170 -5.095481350326173e-07
Gcorr237 T88 T2178 T88 T2178 -1.3534046102891889e-07
Rt820 T88 T2181 4221518.3573646825
Rt821 T88 T2779 558567.12442984234
Rt822 T88 T3796 3234239.2114198958
Rt823 T88 T5500 1442355.1884290853
Gcorr238 T88 T5526 T88 T5526 -5.0954813503252645e-07
Gcorr239 T88 T5535 T88 T5535 -1.3534046102903232e-07
Rt824 T88 T5538 4221518.3573649162
Rt825 T89 T90 781181.50530688372
Rt826 T89 T590 434127.18690206989
Rt827 T89 T797 442475.5413207722
Gcorr240 T89 T1137 T89 T1137 -1.6866085667285588e-07
Rt828 T89 T1146 8323521.8575153872
Rt829 T89 T1240 1888925.0067945116
Gcorr241 T89 T1245 T89 T1245 -1.5109253857539701e-07
Rt830 T89 T3237 7795301.3263934134
Rt831 T89 T3724 1156672.5201552601
Gcorr242 T89 T4491 T89 T4491 -1.6866085667319726e-07
Rt832 T89 T4500 8323521.8574982351
Rt833 T89 T4594 1888925.0067944096
Gcorr243 T89 T4599 T89 T4599 -1.5109253857533398e-07
Rt834 T90 T91 739255.18545028812
Rt835 T90 T603 435363.34107447678
Rt836 T90 T797 513365.67349287134
Rt837 T90 T1146 3030668.278399705
Gcorr244 T90 T1147 T90 T1147 -1.9131820669423636e-07
Rt838 T90 T1245 150490003.76366627
Rt839 T90 T2551 5986289.6168700997
Rt840 T90 T2797 1668862.0016326276
Rt841 T90 T3724 4667293.7112442143
Rt842 T90 T4500 3030668.278400186
Gcorr245 T90 T4501 T90 T4501 -1.9131820669441638e-07
Rt843 T90 T4599 150490003.76253152
Rt844 T90 T5904 5986289.616863641
Rt845 T91 T603 664566.15599334822
Rt846 T91 T835 381319.02973963454
Rt847 T91 T1147 59341615.944019526
Rt848 T91 T2372 2630546.2764625899
Gcorr246 T91 T2551 T91 T2551 -8.8901031682655579e-08
Rt849 T91 T2797 1299832.6242458238
Rt850 T91 T3664 5756439.3099915152
Rt851 T91 T4501 59341615.945143424
Rt852 T91 T5726 2630546.2764607253
Gcorr247 T91 T5904 T91 T5904 -8.8901031682607867e-08
Rt853 T92 T93 710665.6968566752
Rt854 T92 T584 488094.48520241625
Rt855 T92 T761 563551.28001543891
Rt856 T92 T1274 2824221.2009582086
Gcorr248 T92 T1993 T92 T1993 -3.6848020405027313e-08
Rt857 T92 T2351 16324266.102472818
Gcorr249 T92 T2720 T92 T2720 -9.2880598750138354e-08
Rt858 T92 T2798 1264164.8720115973
Rt859 T92 T3814 3190954.642641949
Rt860 T92 T4628 2824221.2009578785
Gcorr250 T92 T5345 T92 T5345 -3.6848020405065482e-08
Rt861 T92 T5704 16324266.102437211
Gcorr251 T92 T6075 T92 T6075 -9.2880598750277109e-08
Rt862 T93 T94 653409.41953866137
Rt863 T93 T761 474210.60963267362
Rt864 T93 T763 560377.39531390939
Gcorr252 T93 T1274 T93 T1274 -1.0591621771673286e-07
Rt865 T93 T2130 3719243.7083715461
Gcorr253 T93 T2331 T93 T2331 -1.468414268041784e-07
Rt866 T93 T2351 3710636.1487546349
Rt867 T93 T3814 3319854.8118965658
Rt868 T93 T3816 1476067.8468551585
Gcorr254 T93 T4628 T93 T4628 -1.0591621771708605e-07
Rt869 T93 T5486 3719243.7083689147
Gcorr255 T93 T5684 T93 T5684 -1.4684142680415455e-07
Rt870 T93 T5704 3710636.1487527452
Rt871 T94 T574 326653.14677752071
Rt872 T94 T763 471120.66417278949
Gcorr256 T94 T2123 T94 T2123 -4.507635611823385e-07
Gcorr257 T94 T2130 T94 T2130 -1.2374038851354567e-07
Rt873 T94 T2331 1162636.9305775969
Rt874 T94 T2799 3264220.5600918895
Rt875 T94 T3816 3085205.4256871552
Gcorr258 T94 T5479 T94 T5479 -4.5076356118142016e-07
Gcorr259 T94 T5486 T94 T5486 -1.2374038851379523e-07
Rt876 T94 T5684 1162636.9305785035
Rt877 T95 T96 973504.10429542826
Rt878 T95 T594 538925.5305133611
Rt879 T95 T828 387515.52133552975
Gcorr260 T95 T1173 T95 T1173 -1.1427232397540991e-07
Rt880 T95 T1437 3213244.0450012712
Gcorr261 T95 T1440 T95 T1440 -1.1998634158677066e-07
Rt881 T95 T2108 3824009.4219257822
Rt882 T95 T2826 1442398.2890264769
Rt883 T95 T3611 1962546.1718403276
Gcorr262 T95 T4527 T95 T4527 -1.1427232397545816e-07
Rt884 T95 T4791 3213244.0450008041
Gcorr263 T95 T4794 T95 T4794 -1.1998634158646798e-07
Rt885 T95 T5459 3824009.4219301986
Rt886 T96 T97 1083516.2879226748
Rt887 T96 T594 485122.74120446667
Rt888 T96 T782 434530.52386962384
Gcorr264 T96 T1436 T96 T1436 -9.6996781099884221e-08
Rt889 T96 T1437 3146482.7650333764
Rt890 T96 T1438 4096728.1532270839
Gcorr265 T96 T1439 T96 T1439 -1.3479978624589957e-07
Rt891 T96 T2826 1571493.8611838615
Rt892 T96 T3740 1535387.1804225887
Gcorr266 T96 T4790 T96 T4790 -9.6996781100002091e-08
Rt893 T96 T4791 3146482.7650337429
Rt894 T96 T4792 4096728.153226437
Gcorr267 T96 T4793 T96 T4793 -1.3479978624578549e-07
Rt895 T97 T608 484878.75244532753
Rt896 T97 T782 434034.95980327274
Rt897 T97 T1438 2629515.8273042217
Gcorr268 T97 T1792 T97 T1792 -9.5368319779889906e-08
Rt898 T97 T2096 22130738.717807706
Rt899 T97 T3409 1469970.831669753
Rt900 T97 T3740 3323758.5865010568
Rt901 T97 T4792 2629515.8273039819
Gcorr269 T97 T5147 T97 T5147 -9.5368319780036575e-08
Rt902 T97 T5449 22130738.717753872
Rt903 T98 T99 888287.76811617112
Rt904 T98 T802 513323.09115461836
Rt905 T98 T817 405554.30837385613
Rt906 T98 T2043 2010911.9453604457
Gcorr270 T98 T2217 T98 T2217 -1.4643097376669995e-07
Rt907 T98 T2237 32332682.806872245
Rt908 T98 T2856 2664010.1982609439
Rt909 T98 T3592 4399867.8292764509
Rt910 T98 T5397 2010911.9453594035
Gcorr271 T98 T5573 T98 T5573 -1.464309737666563e-07
Rt911 T98 T5592 32332682.807190124
Rt912 T99 T100 960290.12661700684
Rt913 T99 T817 458414.77872776036
Rt914 T99 T820 391729.92827181797
Rt915 T99 T1691 2466677.2965559885
Gcorr272 T99 T2011 T99 T2011 -1.3329424751350261e-07
Gcorr273 T99 T2043 T99 T2043 -1.2478480395066361e-07
Rt916 T99 T2217 4551312.0752918832
Rt917 T99 T3592 1922526.2163664128
Rt918 T99 T3818 3474096.2769747749
Rt919 T99 T5045 2466677.2965539619
Gcorr274 T99 T5363 T99 T5363 -1.3329424751348725e-07
Gcorr275 T99 T5397 T99 T5397 -1.2478480395079063e-07
Rt920 T99 T5573 4551312.0752965184
Rt921 T100 T101 763377.94392676919
Rt922 T100 T692 528539.30471771932
Rt923 T100 T820 426008.5621211417
Gcorr276 T100 T1691 T100 T1691 -1.1586667839449747e-07
Rt924 T100 T2010 3256608.0599547168
Rt925 T100 T2011 3820396.412205311
Gcorr277 T100 T2379 T100 T2379 -7.9944653111550683e-08
Rt926 T100 T2854 3780403.1710208114
Rt927 T100 T3818 1532957.0943136348
Gcorr278 T100 T5045 T100 T5045 -1.1586667839462762e-07
Rt928 T100 T5362 3256608.059949718
Rt929 T100 T5363 3820396.4122092598
Gcorr279 T100 T5733 T100 T5733 -7.9944653111623872e-08
Rt930 T101 T599 453996.45453041937
Rt931 T101 T692 589162.42646696989
Rt932 T101 T1829 4852136.9934651926
Gcorr280 T101 T2010 T101 T2010 -7.0791901433452118e-08
Rt933 T101 T2379 3610916.4348819647
Gcorr281 T101 T2522 T101 T2522 -2.9114971133005445e-08
Rt934 T101 T2854 1771365.7285727253
Rt935 T101 T3615 3055293.4683629889
Rt936 T101 T5184 4852136.993459262
Gcorr282 T101 T5362 T101 T5362 -7.0791901433383826e-08
Rt937 T101 T5733 3610916.4348878451
Gcorr283 T101 T5876 T101 T5876 -2.9114971132877152e-08
Rt938 T102 T576 483215.99314909818
Rt939 T102 T754 562513.99523158465
Rt940 T102 T1831 22213638.752978157
Rt941 T102 T1891 6690206.4873155784
Rt942 T102 T1923 9368634.2199847605
Rt943 T102 T2853 3420346.1043735184
Rt944 T102 T3789 1687736.9556392222
Rt945 T102 T5186 22213638.752965283
Rt946 T102 T5248 6690206.4873033687
Rt947 T102 T5279 9368634.2200111765
Rt948 T103 T104 629333.9112790646
Rt949 T103 T598 498921.55168749404
Rt950 T103 T781 447763.60722401622
Rt951 T103 T1631 1613112.642248224
Gcorr284 T103 T1694 T103 T1694 -1.7788747677967555e-07
Gcorr285 T103 T1831 T103 T1831 -2.3829408136615869e-07
Rt952 T103 T2400 9476480.8090284653
Rt953 T103 T2876 3292232.4317520438
Rt954 T103 T3765 3380344.9499519663
Rt955 T103 T4985 1613112.6422458813
Gcorr286 T103 T5048 T103 T5048 -1.7788747677996397e-07
Gcorr287 T103 T5186 T103 T5186 -2.3829408136638487e-07
Rt956 T103 T5755 9476480.8090632688
Rt957 T104 T105 567478.45082329621
Rt958 T104 T598 562364.14443408686
Rt959 T104 T749 562609.04758765083
Rt960 T104 T1625 16488262.912281398
Gcorr288 T104 T1631 T104 T1631 -1.6476906040636116e-07
Rt961 T104 T1694 1521507.6006830069
Gcorr289 T104 T2173 T104 T2173 -2.387967423368355e-07
Rt962 T104 T3765 1644492.0912229102
Rt963 T104 T3773 1644747.9193387779
Rt964 T104 T4979 16488262.912222847
Gcorr290 T104 T4985 T104 T4985 -1.6476906040650553e-07
Rt965 T104 T5048 1521507.6006821853
Gcorr291 T104 T5530 T104 T5530 -2.3879674233726362e-07
Rt966 T105 T106 943098.51073715265
Rt967 T105 T596 405511.67036912724
Rt968 T105 T749 319793.89972503175
Gcorr292 T105 T1694 T105 T1694 -4.104078116006447e-07
Gcorr293 T105 T2167 T105 T2167 -4.1686528353299219e-07
Rt969 T105 T2173 875967.43315734004
Rt970 T105 T2845 3235277.4609537283
Rt971 T105 T3773 3104233.52761397
Gcorr294 T105 T5048 T105 T5048 -4.1040781160080056e-07
Gcorr295 T105 T5523 T105 T5523 -4.1686528353323629e-07
Rt972 T105 T5530 875967.43315703457
Rt973 T106 T596 506598.41184753657
Rt974 T106 T816 473791.78888140502
Rt975 T106 T1620 9574903.9077270962
Rt976 T106 T1628 6638522.9085266553
Rt977 T106 T2173 19898343.286606763
Rt978 T106 T2845 1707777.7834877681
Rt979 T106 T3775 3336556.5112750609
Rt980 T106 T4974 9574903.9077197779
Rt981 T106 T4982 6638522.9085325524
Rt982 T106 T5530 19898343.286586195
Rt983 T107 T108 818234.38089198316
Rt984 T107 T585 490362.29984198639
Rt985 T107 T786 514423.32810316567
Rt986 T107 T1617 7817221.5948801376
Rt987 T107 T1619 13688824.072854381
Rt988 T107 T1806 8055470.8615442999
Rt989 T107 T2844 1705701.1141122652
Rt990 T107 T3745 3451047.4153221408
Rt991 T107 T4971 7817221.5948715173
Rt992 T107 T4973 13688824.072849743
Rt993 T107 T5161 8055470.8615552001
Rt994 T108 T109 962675.76147499168
Rt995 T108 T616 576377.02151271631
Rt996 T108 T786 384435.39944229618
Gcorr296 T108 T1615 T108 T1615 -4.3505566914972588e-07
Gcorr297 T108 T1617 T108 T1617 -1.7703128996529604e-07
Gcorr298 T108 T1806 T108 T1806 -1.7317620802166546e-07
Rt997 T108 T2079 898697.41499507136
Rt998 T108 T3745 638189.16719654319
Rt999 T108 T3746 1120577.8914985175
Gcorr299 T108 T4969 T108 T4969 -4.3505566914966489e-07
Gcorr300 T108 T4971 T108 T4971 -1.7703128996521729e-07
Gcorr301 T108 T5161 T108 T5161 -1.7317620802172251e-07
Rt1000 T108 T5433 898697.41499514028
Rt1001 T109 T616 552079.80014800665
Rt1002 T109 T825 469321.60920156306
Rt1003 T109 T2021 8671697.2606829293
Rt1004 T109 T2079 11349893.844168155
Rt1005 T109 T2371 8447185.9127898999
Rt1006 T109 T2839 3330353.0248593292
Rt1007 T109 T3746 1696244.1859863542
Rt1008 T109 T5374 8671697.2606729995
Rt1009 T109 T5433 11349893.844163923
Rt1010 T109 T5725 8447185.9128018226
Rt1011 T110 T111 760277.13719503349
Rt1012 T110 T641 453576.56347606453
Rt1013 T110 T744 480019.64004537504
Rt1014 T110 T1981 8388405.3055226095
Rt1015 T110 T1982 3430176.2739765453
Gcorr302 T110 T2313 T110 T2313 -1.4761051087525204e-07
Rt1016 T110 T2333 13855198.704308331
Rt1017 T110 T3399 2187185.652899195
Rt1018 T110 T3759 2706700.2126676259
Rt1019 T110 T5333 8388405.3055174574
Rt1020 T110 T5334 3430176.2739760331
Gcorr303 T110 T5667 T110 T5667 -1.4761051087536758e-07
Rt1021 T110 T5686 13855198.704308996
Rt1022 T111 T112 969317.90268859942
Rt1023 T111 T744 564237.92974953656
Rt1024 T111 T746 482920.64770748839
Rt1025 T111 T1980 8343876.606686797
Rt1026 T111 T1981 14087980.12440053
Rt1027 T111 T2333 8012940.895663375
Rt1028 T111 T2818 1678540.8427946689
Rt1029 T111 T3759 3256588.7374007716
Rt1030 T111 T5332 8343876.6066940576
Rt1031 T111 T5333 14087980.124376679
Rt1032 T111 T5686 8012940.8956645327
Rt1033 T112 T646 483711.98613641917
Rt1034 T112 T746 437044.85098483122
Rt1035 T112 T1979 24820638.913036656
Rt1036 T112 T1980 2730169.8267335333
Rt1037 T112 T2203 10322951.319096126
Gcorr304 T112 T2275 T112 T2275 -1.5853947452824661e-07
Rt1038 T112 T2818 1435578.1368129449
Rt1039 T112 T3544 6460802.9525541803
Rt1040 T112 T5331 24820638.913051099
Rt1041 T112 T5332 2730169.8267325158
Rt1042 T112 T5560 10322951.319095381
Gcorr305 T112 T5629 T112 T5629 -1.5853947452836897e-07
Rt1043 T113 T114 1353418.5296754679
Rt1044 T113 T807 456748.93738359329
Rt1045 T113 T819 470419.47078317421
Rt1046 T113 T1444 9557406.1716259439
Rt1047 T113 T2040 7535711.9898925545
Rt1048 T113 T2185 7126829.9281063732
Rt1049 T113 T2786 3180664.3082870161
Rt1050 T113 T3661 1732142.3824288584
Rt1051 T113 T4798 9557406.1716184225
Rt1052 T113 T5394 7535711.9898839882
Rt1053 T113 T5542 7126829.9281183444
Rt1054 T114 T615 520638.73384279129
Rt1055 T114 T807 381428.74071142753
Gcorr306 T114 T1203 T114 T1203 -8.4669828762693004e-08
Rt1056 T114 T1443 3785481.1770964661
Rt1057 T114 T1444 1192278.0142890296
Gcorr307 T114 T1445 T114 T1445 -6.174039147408667e-07
Rt1058 T114 T3215 559061.49129875028
Rt1059 T114 T3661 3589757.7442667792
Gcorr308 T114 T4557 T114 T4557 -8.4669828762697332e-08
Rt1060 T114 T4797 3785481.1770949168
Rt1061 T114 T4798 1192278.0142895337
Gcorr309 T114 T4799 T114 T4799 -6.1740391474061884e-07
Rt1062 T115 T116 792996.00481410266
Rt1063 T115 T542 467300.18952337449
Rt1064 T115 T677 571816.553742819
Rt1065 T115 T1793 2520581.7807545434
Gcorr310 T115 T2126 T115 T2126 -1.0111646154656723e-07
Rt1066 T115 T2128 3292437.4325116747
Gcorr311 T115 T2596 T115 T2596 -9.2950652434123435e-08
Rt1067 T115 T2770 1411917.4969275738
Rt1068 T115 T3215 55935834.491681553
Rt1069 T115 T4095 21159845.01664339
Rt1070 T115 T5148 2520581.7807545438
Gcorr312 T115 T5482 T115 T5482 -1.0111646154649615e-07
Rt1071 T115 T5484 3292437.4325118158
Gcorr313 T115 T5950 T115 T5950 -9.2950652434184871e-08
Rt1072 T116 T117 823725.44895810389
Rt1073 T116 T541 486345.71645684063
Rt1074 T116 T677 571787.98741599161
Rt1075 T116 T1215 6482839.6093888879
Rt1076 T116 T2128 12615481.52606672
Rt1077 T116 T2596 3185664.1193726528
Gcorr314 T116 T2688 T116 T2688 -1.3918299454868707e-07
Rt1078 T116 T2770 4098903.7725862633
Rt1079 T116 T3859 1439500.142135608
Rt1080 T116 T4569 6482839.6093846373
Rt1081 T116 T5484 12615481.526058622
Rt1082 T116 T5950 3185664.1193754096
Gcorr315 T116 T6042 T116 T6042 -1.3918299454857018e-07
Rt1083 T117 T118 781862.61411883135
Rt1084 T117 T541 492845.06818371743
Rt1085 T117 T680 493902.63305011205
Gcorr316 T117 T1213 T117 T1213 -1.0902282825858015e-07
Rt1086 T117 T1215 8156424.8648230098
Gcorr317 T117 T2088 T117 T2088 -3.9471157615565885e-08
Rt1087 T117 T2609 4244813.3337452468
Rt1088 T117 T2688 4643157.7255137702
Rt1089 T117 T3562 2098157.4467286714
Rt1090 T117 T3859 3897984.9244530285
Gcorr318 T117 T4567 T117 T4567 -1.0902282825849621e-07
Rt1091 T117 T4569 8156424.864822492
Gcorr319 T117 T5442 T117 T5442 -3.9471157615428335e-08
Rt1092 T117 T5963 4244813.3337464239
Rt1093 T117 T6042 4643157.7255173661
Rt1094 T118 T119 772783.14977423381
Rt1095 T118 T539 567843.82508287113
Rt1096 T118 T680 509264.72489466087
Rt1097 T118 T1216 10883118.679454353
Rt1098 T118 T1282 11109507.880933929
Rt1099 T118 T2088 10892660.78924376
Rt1100 T118 T2609 5741922.587225277
Rt1101 T118 T2771 1604408.9760605334
Rt1102 T118 T3562 6615071.8248890778
Rt1103 T118 T4570 10883118.679454397
Rt1104 T118 T4638 11109507.880932651
Rt1105 T118 T5442 10892660.789254475
Rt1106 T118 T5963 5741922.5872227279
Rt1107 T119 T120 807397.96027337038
Rt1108 T119 T539 466146.35268308065
Rt1109 T119 T685 570729.80551181256
Gcorr320 T119 T1216 T119 T1216 -1.4935129373116668e-07
Rt1110 T119 T1219 3109250.1628868748
Rt1111 T119 T1282 3992318.7279268964
Gcorr321 T119 T2545 T119 T2545 -1.1689605490287562e-07
Rt1112 T119 T2610 9793809.906015059
Rt1113 T119 T2771 2086426.3196257718
Rt1114 T119 T3864 1610149.312629018
Gcorr322 T119 T4570 T119 T4570 -1.4935129373124566e-07
Rt1115 T119 T4573 3109250.1628847122
Rt1116 T119 T4638 3992318.7279265067
Gcorr323 T119 T5898 T119 T5898 -1.1689605490300233e-07
Rt1117 T119 T5964 9793809.9060194027
Rt1118 T120 T121 701894.00515448907
Rt1119 T120 T537 568216.86998740688
Rt1120 T120 T685 468002.46171500604
Gcorr324 T120 T1219 T120 T1219 -1.3944334582367032e-07
Rt1121 T120 T1221 2512828.8942564474
Gcorr325 T120 T1951 T120 T1951 -1.0164010356596765e-07
Gcorr326 T120 T2544 T120 T2544 -1.8740730296499382e-08
Rt1122 T120 T2610 3415610.5140535375
Rt1123 T120 T3513 2000786.2268747666
Rt1124 T120 T3864 1989813.0330625176
Gcorr327 T120 T4573 T120 T4573 -1.3944334582360422e-07
Rt1125 T120 T4575 2512828.8942551441
Gcorr328 T120 T5307 T120 T5307 -1.0164010356609219e-07
Gcorr329 T120 T5897 T120 T5897 -1.8740730296572581e-08
Rt1126 T120 T5964 3415610.5140544437
Rt1127 T121 T122 971939.01932973263
Rt1128 T121 T537 486777.52538774518
Rt1129 T121 T686 468384.89768428158
Rt1130 T121 T1221 21197873.849981174
Gcorr330 T121 T1222 T121 T1222 -1.3562559889568196e-07
Rt1131 T121 T1223 2317272.5476076687
Rt1132 T121 T2544 8885676.6024341621
Rt1133 T121 T2772 1588291.8911026814
Rt1134 T121 T3513 8949105.9268281236
Rt1135 T121 T4575 21197873.849977642
Gcorr331 T121 T4576 T121 T4576 -1.3562559889560952e-07
Rt1136 T121 T4577 2317272.5476073148
Rt1137 T121 T5897 8885676.602445947
Rt1138 T122 T123 979452.70062758226
Rt1139 T122 T535 464935.18846364314
Rt1140 T122 T686 493098.22788396565
Rt1141 T122 T1223 4125728.4444200322
Gcorr332 T122 T1224 T122 T1224 -7.7602762153210612e-08
Rt1142 T122 T1225 1114595.7320881952
Gcorr333 T122 T1231 T122 T1231 -6.4275535063570187e-07
Rt1143 T122 T2772 550829.0009956978
Rt1144 T122 T3653 3567738.5394407194
Rt1145 T122 T4577 4125728.4444197309
Gcorr334 T122 T4578 T122 T4578 -7.7602762153078475e-08
Rt1146 T122 T4579 1114595.7320882364
Gcorr335 T122 T4585 T122 T4585 -6.427553506358214e-07
Rt1147 T123 T124 657330.95050016837
Rt1148 T123 T535 491042.27797193651
Rt1149 T123 T673 493004.98518077889
Rt1150 T123 T1225 10760304.002204647
Rt1151 T123 T1226 5945775.2366769519
Rt1152 T123 T1229 2900471.5180944819
Gcorr336 T123 T1232 T123 T1232 -1.5140453857655488e-07
Rt1153 T123 T3548 9079262.4371529371
Rt1154 T123 T3653 1553024.8640635582
Rt1155 T123 T4579 10760304.002207816
Rt1156 T123 T4580 5945775.2366702799
Rt1157 T123 T4583 2900471.5180960968
Gcorr337 T123 T4586 T123 T4586 -1.514045385765273e-07
Rt1158 T124 T125 394127.39797075902
Rt1159 T124 T532 566816.33289220324
Rt1160 T124 T673 566043.21398110443
Gcorr338 T124 T1229 T124 T1229 -5.576340783685522e-08
Rt1161 T124 T1232 1093626.4305505201
Rt1162 T124 T1252 4288518.6796689043
Gcorr339 T124 T1253 T124 T1253 -6.302362832328605e-07
Rt1163 T124 T2773 2601428.2432373776
Rt1164 T124 T3548 3281570.4840007038
Gcorr340 T124 T4583 T124 T4583 -5.576340783692052e-08
Rt1165 T124 T4586 1093626.4305517056
Rt1166 T124 T4606 4288518.6796707576
Gcorr341 T124 T4607 T124 T4607 -6.3023628323170621e-07
Rt1167 T125 T126 935399.00954125635
Rt1168 T125 T532 465635.62446868152
Rt1169 T125 T687 555811.2911768374
Gcorr342 T125 T1232 T125 T1232 -6.2423040272359373e-07
Gcorr343 T125 T1252 T125 T1252 -1.2600715968606317e-07
Rt1170 T125 T1253 611118.73651083629
Gcorr344 T125 T1326 T125 T1326 -4.6689604763558932e-07
Rt1171 T125 T2773 1700865.617579798
Rt1172 T125 T3658 691578.60446161369
Gcorr345 T125 T4586 T125 T4586 -6.2423040272244017e-07
Gcorr346 T125 T4606 T125 T4606 -1.26007159686234e-07
Rt1173 T125 T4607 611118.73651111545
Gcorr347 T125 T4680 T125 T4680 -4.6689604763582739e-07
Rt1174 T126 T127 713353.35101283155
Rt1175 T126 T530 484758.86384717881
Rt1176 T126 T687 489169.53954208066
Rt1177 T126 T1253 42070684.235057674
Rt1178 T126 T1327 2071704.3373751396
Gcorr348 T126 T1943 T126 T1943 -1.3470972383648481e-07
Rt1179 T126 T2106 21072394.862881579
Rt1180 T126 T3656 3283736.9886597334
Rt1181 T126 T3658 1731916.2705705101
Rt1182 T126 T4607 42070684.235055916
Rt1183 T126 T4681 2071704.3373773594
Gcorr349 T126 T5299 T126 T5299 -1.3470972383634574e-07
Rt1184 T126 T5472 21072394.862715349
Rt1185 T127 T128 771701.08396979549
Rt1186 T127 T530 569553.82150648476
Rt1187 T127 T678 507578.32157152891
Gcorr350 T127 T1327 T127 T1327 -1.194517058697952e-07
Rt1188 T127 T1404 2982904.8154134541
Rt1189 T127 T1943 4068230.3218937553
Gcorr351 T127 T2567 T127 T2567 -4.2389495385102026e-08
Rt1190 T127 T2774 3602091.616991322
Rt1191 T127 T3656 1815539.1819925653
Gcorr352 T127 T4681 T127 T4681 -1.1945170586980955e-07
Rt1192 T127 T4758 2982904.8154146825
Rt1193 T127 T5299 4068230.3218927546
Gcorr353 T127 T5921 T127 T5921 -4.2389495385012803e-08
Rt1194 T128 T129 1132372.5181198386
Rt1195 T128 T528 493016.99394519557
Rt1196 T128 T678 571828.20878405403
Gcorr354 T128 T1404 T128 T1404 -1.196745890025239e-07
Rt1197 T128 T1586 15161811.374253588
Rt1198 T128 T2265 8844727.7829148248
Rt1199 T128 T2567 3077417.4011232234
Rt1200 T128 T2774 1887660.1604148229
Rt1201 T128 T4118 1062666.1542455843
Gcorr355 T128 T4758 T128 T4758 -1.1967458900261837e-07
Rt1202 T128 T4940 15161811.374335131
Rt1203 T128 T5620 8844727.7829154506
Rt1204 T128 T5921 3077417.4011189179
Rt1205 T129 T130 737271.68460794527
Rt1206 T129 T528 480023.40085809602
Rt1207 T129 T679 572832.44781059644
Rt1208 T129 T2163 2944357.659590635
Gcorr356 T129 T2164 T129 T2164 -1.4602073242755112e-07
Rt1209 T129 T2265 8635444.3982145134
Rt1210 T129 T2329 13355347.886183459
Rt1211 T129 T3657 1730261.8800609196
Rt1212 T129 T4118 973215.94732735818
Rt1213 T129 T5519 2944357.6595900455
Gcorr357 T129 T5520 T129 T5520 -1.460207324274446e-07
Rt1214 T129 T5620 8635444.3982028048
Rt1215 T129 T5682 13355347.886243049
Rt1216 T130 T131 746367.82365373895
Rt1217 T130 T526 480159.58898390911
Rt1218 T130 T679 572894.85691225936
Gcorr358 T130 T1068 T130 T1068 -3.2679591041697696e-08
Rt1219 T130 T2163 7170407.9592986098
Rt1220 T130 T2164 3200746.4615174974
Rt1221 T130 T2775 3713879.4593414241
Rt1222 T130 T3657 3760727.6922337562
Gcorr359 T130 T4422 T130 T4422 -3.2679591041778376e-08
Rt1223 T130 T5519 7170407.9593030764
Rt1224 T130 T5520 3200746.4615158089
Rt1225 T131 T132 806115.13120653713
Rt1226 T131 T526 626911.68527986237
Rt1227 T131 T771 428119.39855394117
Gcorr360 T131 T896 T131 T896 -4.7805572110376467e-08
Rt1228 T131 T1068 3334861.3538095285
Gcorr361 T131 T2164 T131 T2164 -1.536902723382601e-07
Rt1229 T131 T2207 3278118.9349725051
Rt1230 T131 T2775 1662230.7855658277
Rt1231 T131 T3764 3206596.547964944
Gcorr362 T131 T4250 T131 T4250 -4.7805572110377896e-08
Rt1232 T131 T4422 3334861.3538093911
Gcorr363 T131 T5520 T131 T5520 -1.5369027233819445e-07
Rt1233 T131 T5563 3278118.9349733572
Rt1234 T132 T771 613128.33894093847
Rt1235 T132 T842 216690.14766355825
Rt1236 T132 T894 3402586.3638858926
Gcorr364 T132 T895 T132 T895 -1.6032095686853469e-07
Rt1237 T132 T896 2754163.8375826613
Gcorr365 T132 T2207 T132 T2207 -1.4595519784764116e-07
Rt1238 T132 T2862 3298399.368780104
Rt1239 T132 T3764 1529813.3693152112
Rt1240 T132 T4248 3402586.3638858949
Gcorr366 T132 T4249 T132 T4249 -1.6032095686853633e-07
Rt1241 T132 T4250 2754163.8375826585
Gcorr367 T132 T5563 T132 T5563 -1.4595519784764206e-07
Rt1242 T133 T134 971977.59148094698
Rt1243 T133 T582 451603.07946414943
Rt1244 T133 T842 296914.29915330134
Rt1245 T133 T895 13589855.303356713
Gcorr368 T133 T897 T133 T897 -1.8482272893988267e-07
Rt1246 T133 T1076 2462187.7350916839
Rt1247 T133 T2211 22748329.689134888
Rt1248 T133 T2929 1257073.6287042846
Rt1249 T133 T3556 25639906.701300368
Rt1250 T133 T4249 13589855.303349191
Gcorr369 T133 T4251 T133 T4251 -1.8482272893988375e-07
Rt1251 T133 T4430 2462187.7350912886
Rt1252 T133 T5567 22748329.689190291
Rt1253 T134 T135 766550.08904614067
Rt1254 T134 T582 334241.94624261581
Rt1255 T134 T747 565005.04619213275
Gcorr370 T134 T897 T134 T897 -4.1880180062542222e-07
Rt1256 T134 T1076 2752787.5180751667
Rt1257 T134 T2165 3099190.7987192837
Rt1258 T134 T2348 20720665.55889846
Rt1259 T134 T2929 1706820.8098212839
Rt1260 T134 T3763 3089516.8700953596
Gcorr371 T134 T4251 T134 T4251 -4.1880180062542476e-07
Rt1261 T134 T4430 2752787.5180751644
Rt1262 T134 T5521 3099190.7987192795
Rt1263 T134 T5701 20720665.558898594
Rt1264 T135 T747 628649.0448420227
Rt1265 T135 T840 296315.81015913328
Rt1266 T135 T1796 10975574.700309239
Rt1267 T135 T2165 7767244.7383089252
Rt1268 T135 T2348 14406266.198357582
Rt1269 T135 T2822 1762368.8785742442
Rt1270 T135 T3763 3193980.8759066421
Rt1271 T135 T5151 10975574.700309359
Rt1272 T135 T5521 7767244.7383089634
Rt1273 T135 T5701 14406266.198357655
Rt1274 T136 T137 743901.90755386755
Rt1275 T136 T554 521346.728396016
Rt1276 T136 T840 228446.55217165194
Gcorr372 T136 T901 T136 T901 -1.3325327802072212e-07
Rt1277 T136 T1074 3966511.0989189576
Rt1278 T136 T1555 38539624.023008153
Rt1279 T136 T2140 4586441.2441640245
Rt1280 T136 T3407 1527282.8691335537
Rt1281 T136 T3647 3684199.9236584497
Gcorr373 T136 T4255 T136 T4255 -1.3325327802072304e-07
Rt1282 T136 T4428 3966511.0989189553
Rt1283 T136 T4909 38539624.023009382
Rt1284 T136 T5496 4586441.2441640422
Rt1285 T137 T138 739098.67759366427
Rt1286 T137 T554 569945.88810610713
Rt1287 T137 T655 483663.79288820259
Rt1288 T137 T901 2600339.0489174658
Gcorr374 T137 T902 T137 T902 -1.4461446590872746e-07
Rt1289 T137 T903 4081655.4456856684
Gcorr375 T137 T1074 T137 T1074 -6.1832085391202588e-08
Rt1290 T137 T2742 3555001.6793450569
Rt1291 T137 T3647 1696563.0962619623
Rt1292 T137 T4255 2600339.0489170304
Gcorr376 T137 T4256 T137 T4256 -1.4461446590868622e-07
Rt1293 T137 T4257 4081655.4456887138
Gcorr377 T137 T4428 T137 T4428 -6.1832085391128301e-08
Rt1294 T138 T139 738144.0009989402
Rt1295 T138 T558 570258.96600655117
Rt1296 T138 T655 570237.27588116832
Rt1297 T138 T902 2620793.5788590941
Rt1298 T138 T903 10427713.644253952
Gcorr378 T138 T904 T138 T904 -5.4344798760219544e-08
Rt1299 T138 T2742 3552252.0582671235
Rt1300 T138 T3629 1716644.2037114764
Rt1301 T138 T4256 2620793.5788589325
Rt1302 T138 T4257 10427713.644264834
Gcorr379 T138 T4258 T138 T4258 -5.4344798760145905e-08
Rt1303 T139 T140 742907.53515292902
Rt1304 T139 T558 485050.80127046298
Rt1305 T139 T666 570732.37756026967
Gcorr380 T139 T902 T139 T902 -1.4255357424186558e-07
Rt1306 T139 T904 3870893.1868458721
Rt1307 T139 T905 2712795.2954301108
Gcorr381 T139 T906 T139 T906 -6.1290882530638135e-08
Rt1308 T139 T2882 1712977.4456697295
Rt1309 T139 T3629 3583601.9027205063
Gcorr382 T139 T4256 T139 T4256 -1.4255357424186643e-07
Rt1310 T139 T4258 3870893.1868458707
Rt1311 T139 T4259 2712795.2954301159
Gcorr383 T139 T4260 T139 T4260 -6.1290882530639524e-08
Rt1312 T140 T141 756356.63122810214
Rt1313 T140 T559 571027.88861669786
Rt1314 T140 T666 484802.13998137607
Gcorr384 T140 T905 T140 T905 -1.3397760231935664e-07
Rt1315 T140 T906 3893508.4733623089
Rt1316 T140 T1394 2833603.8910577162
Gcorr385 T140 T2105 T140 T2105 -6.9459797624401077e-08
Rt1317 T140 T2882 4447535.8666228326
Rt1318 T140 T3916 1402864.4760182493
Gcorr386 T140 T4259 T140 T4259 -1.3397760231935749e-07
Rt1319 T140 T4260 3893508.4733623108
Rt1320 T140 T4748 2833603.8910577209
Gcorr387 T140 T5458 T140 T5458 -6.9459797624402255e-08
Rt1321 T141 T142 782478.20695552649
Rt1322 T141 T559 484619.41528084583
Rt1323 T141 T656 571144.9451888277
Gcorr388 T141 T1394 T141 T1394 -1.2569616457872407e-07
Rt1324 T141 T1704 3091366.9205673672
Rt1325 T141 T2105 4015347.8916205568
Rt1326 T141 T2383 48785680.353927806
Rt1327 T141 T3450 3660698.9067351636
Rt1328 T141 T3916 3640920.1040743636
Rt1329 T141 T4169 4807922.295140746
Gcorr389 T141 T4748 T141 T4748 -1.2569616457872499e-07
Rt1330 T141 T5058 3091366.9205673719
Rt1331 T141 T5458 4015347.8916205671
Rt1332 T141 T5737 48785680.353930436
Rt1333 T142 T143 782865.45284654654
Rt1334 T142 T563 568855.43324247515
Rt1335 T142 T656 457102.28309712332
Gcorr390 T142 T1704 T142 T1704 -1.3569074740959316e-07
Rt1336 T142 T2005 2576147.1254425952
Gcorr391 T142 T2169 T142 T2169 -2.0380735460530057e-08
Rt1337 T142 T2383 6560246.7104420466
Rt1338 T142 T2746 5140623.9942682711
Rt1339 T142 T4169 1132453.1829111166
Gcorr392 T142 T5058 T142 T5058 -1.3569074740938834e-07
Rt1340 T142 T5357 2576147.1254465063
Gcorr393 T142 T5525 T142 T5525 -2.0380735460194304e-08
Rt1341 T142 T5737 6560246.7104400592
Rt1342 T143 T144 1006415.9696227128
Rt1343 T143 T563 493305.21879059554
Rt1344 T143 T669 461138.55674592551
Rt1345 T143 T1657 2429874.4542714385
Gcorr394 T143 T1868 T143 T1868 -1.2255622394984805e-07
Rt1346 T143 T2005 10257407.232991319
Rt1347 T143 T2169 37242053.834717967
Rt1348 T143 T2746 3158745.3543582866
Rt1349 T143 T3813 1629636.812039553
Rt1350 T143 T5012 2429874.4542710059
Gcorr395 T143 T5223 T143 T5223 -1.2255622395021317e-07
Rt1351 T143 T5357 10257407.232985185
Rt1352 T143 T5525 37242053.834397875
Rt1353 T144 T145 459046.1564937603
Rt1354 T144 T566 572459.05218084331
Rt1355 T144 T669 494382.6073825265
Rt1356 T144 T1552 2969923.9403645708
Rt1357 T144 T1657 10909612.255404016
Rt1358 T144 T1790 1920875.3817905686
Gcorr396 T144 T2204 T144 T2204 -5.3563766364395652e-07
Rt1359 T144 T3641 3819223.6820688266
Rt1360 T144 T3813 1592635.9571187522
Rt1361 T144 T4906 2844489.2769798371
Rt1362 T144 T5012 10909612.255402386
Rt1363 T144 T5145 2537533.6548065464
Gcorr397 T144 T5781 T144 T5781 -4.2397312720715992e-07
Rt1364 T145 T146 378961.58419364429
Rt1365 T145 T566 454259.13948464434
Rt1366 T145 T654 563063.70633998711
Rt1367 T145 T1550 4420031.3145442549
Gcorr398 T145 T1552 T145 T1552 -1.014312281440562e-07
Gcorr399 T145 T1670 T145 T1670 -5.3511660574440639e-07
Gcorr400 T145 T1790 T145 T1790 -5.3992872813803994e-07
Rt1368 T145 T2204 728145.89993737137
Rt1369 T145 T2883 3376772.0131085264
Rt1370 T145 T3641 1826366.3138525744
Rt1371 T145 T4904 4755136.314802859
Gcorr401 T145 T4906 T145 T4906 -1.3158921737261622e-07
Gcorr402 T145 T5116 T145 T5116 -8.3983449854955888e-07
Gcorr403 T145 T5145 T145 T5145 -4.4504678123019555e-07
Rt1372 T145 T5781 613764.69194196095
Rt1373 T146 T147 806293.43792903738
Rt1374 T146 T568 397858.99930102821
Rt1375 T146 T654 182472.68223393269
Gcorr404 T146 T1548 T146 T1548 -5.5028763071591825e-07
Gcorr405 T146 T1550 T146 T1550 -5.2513335306762206e-07
Rt1376 T146 T1670 391129.69423399499
Gcorr406 T146 T2090 T146 T2090 -5.3344664819935065e-07
Gcorr407 T146 T2204 T146 T2204 -5.2471175523072447e-07
Rt1377 T146 T2883 630717.90071109275
Rt1378 T146 T3630 784620.4702938596
Gcorr408 T146 T4902 T146 T4902 -5.5028763071518641e-07
Gcorr409 T146 T4904 T146 T4904 -5.2513335306664765e-07
Rt1379 T146 T5116 177796.16516165141
Gcorr410 T146 T5527 T146 T5527 -2.8189241003566428e-06
Gcorr411 T146 T5717 T146 T5717 -5.001778008829421e-07
Gcorr412 T146 T5781 T146 T5781 -8.0677807025815671e-07
Rt1380 T147 T148 702920.65173670708
Rt1381 T147 T568 527252.32477722678
Rt1382 T147 T665 481924.12490455236
Rt1383 T147 T1670 27875961.782248519
Rt1384 T147 T1977 2130502.2733529946
Rt1385 T147 T1978 12415063.487444773
Gcorr413 T147 T2405 T147 T2405 -1.6267608345483655e-07
Rt1386 T147 T2749 3504560.4540899219
Rt1387 T147 T3630 1659004.3085834016
Gcorr414 T147 T5116 T147 T5116 -1.3790324097197135e-07
Gcorr415 T147 T5364 T147 T5364 -1.600618622233179e-07
Rt1388 T147 T5393 2248812.2306421483
Rt1389 T147 T5717 3617902.7247404438
Rt1390 T148 T149 694419.36344775115
Rt1391 T148 T570 492638.69581160066
Rt1392 T148 T665 569990.99262423953
Rt1393 T148 T1952 3590107.5917914421
Gcorr416 T148 T1953 T148 T1953 -1.571796025441896e-07
Gcorr417 T148 T1977 T148 T1977 -1.2291812105771482e-07
Rt1394 T148 T2405 2354759.2942207255
Rt1395 T148 T2749 1832130.4401516297
Rt1396 T148 T3644 3627169.1937780171
Rt1397 T148 T5001 3274227.3122980474
Gcorr418 T148 T5274 T148 T5274 -1.3323410426959846e-07
Rt1398 T148 T5364 2748909.4888340086
Gcorr419 T148 T5393 T148 T5393 -1.1284476955206812e-07
Rt1399 T149 T150 631769.79039567313
Rt1400 T149 T570 561735.09656610282
Rt1401 T149 T663 523681.76445796882
Rt1402 T149 T1765 17400500.655558221
Gcorr420 T149 T1952 T149 T1952 -1.217136573648299e-07
Rt1403 T149 T1953 1261953.9213738637
Gcorr421 T149 T2321 T149 T2321 -3.050605969968286e-07
Rt1404 T149 T2884 2279190.4089470548
Rt1405 T149 T3644 1646768.8810452817
Gcorr422 T149 T5001 T149 T5001 -1.405550001639026e-07
Rt1406 T149 T5273 7730884.8438532492
Rt1407 T149 T5274 1861882.1227415001
Gcorr423 T149 T6067 T149 T6067 -1.0276991219927428e-07
Rt1408 T150 T151 769039.22539487807
Rt1409 T150 T573 511617.39209750976
Rt1410 T150 T663 462339.8475899538
Gcorr424 T150 T1218 T150 T1218 -9.7678232643143677e-08
Gcorr425 T150 T1953 T150 T1953 -4.6109417363782762e-07
Rt1411 T150 T2321 1018444.3086911878
Rt1412 T150 T2884 1525132.4048101145
Rt1413 T150 T3631 3350978.5414608908
Gcorr426 T150 T4572 T150 T4572 -1.7875550628352895e-07
Gcorr427 T150 T5273 T150 T5273 -3.2372719071665904e-07
Rt1414 T150 T5738 1734304.2617566332
Rt1415 T150 T6067 2865330.1715581976
Rt1416 T151 T152 786466.81114434102
Rt1417 T151 T573 472318.30423549796
Rt1418 T151 T667 565311.92355766031
Rt1419 T151 T1218 294224752.33770162
Rt1420 T151 T1918 2690221.5219060914
Gcorr428 T151 T2321 T151 T2321 -7.2980744962965786e-08
Rt1421 T151 T2389 8265644.71230892
Rt1422 T151 T3631 1677508.6934387719
Rt1423 T151 T3646 3573570.2385857305
Gcorr429 T151 T4572 T151 T4572 -1.3494958791018797e-08
Rt1424 T151 T5239 2815181.2619676329
Gcorr430 T151 T5738 T151 T5738 -3.9587336800026249e-08
Rt1425 T151 T5745 8265644.7123073796
Rt1426 T152 T153 792610.29660437803
Rt1427 T152 T575 570979.92865947809
Rt1428 T152 T667 470881.74188369297
Gcorr431 T152 T1918 T152 T1918 -3.7774920187376321e-08
Rt1429 T152 T1957 3663568.9060749849
Rt1430 T152 T2389 134402661.95985061
Rt1431 T152 T2436 5540349.4989882475
Rt1432 T152 T2744 3634526.6114810705
Rt1433 T152 T3646 1792375.3647396537
Gcorr432 T152 T5239 T152 T5239 -3.7774920187396127e-08
Rt1434 T152 T5311 3663568.9060758306
Rt1435 T152 T5745 134402661.96105105
Rt1436 T152 T5790 5540349.4989837529
Rt1437 T153 T575 414397.05541172606
Rt1438 T153 T651 672344.82592445414
Gcorr433 T153 T1208 T153 T1208 -1.2587937780474165e-07
Rt1439 T153 T1230 2142925.8815356633
Rt1440 T153 T1957 21666558.571355123
Rt1441 T153 T2436 7412283.9997413987
Gcorr434 T153 T2650 T153 T2650 -8.3792068413605125e-08
Rt1442 T153 T2744 2073177.4508908046
Rt1443 T153 T3848 1399893.04112082
Gcorr435 T153 T4562 T153 T4562 -1.2587937780469499e-07
Rt1444 T153 T4584 2142925.8815356693
Rt1445 T153 T5311 21666558.571315777
Rt1446 T153 T5790 7412283.9997507641
Gcorr436 T153 T6004 T153 T6004 -8.3792068413566638e-08
Rt1447 T154 T629 488771.20788329741
Rt1448 T154 T651 572606.63485647552
Gcorr437 T154 T1205 T154 T1205 -7.5426554149141221e-08
Rt1449 T154 T1207 3251745.494642396
Gcorr438 T154 T1257 T154 T1257 -1.1746427308141042e-07
Rt1450 T154 T2121 3094424.0006152219
Rt1451 T154 T2752 1854511.916577355
Rt1452 T154 T3853 2862083.4914876185
Gcorr439 T154 T4559 T154 T4559 -7.5426554149192308e-08
Rt1453 T154 T4561 3251745.4946430069
Gcorr440 T154 T4611 T154 T4611 -1.174642730814793e-07
Rt1454 T154 T5477 3094424.0006135479
Rt1455 T155 T620 627269.72532312269
Rt1456 T155 T827 306703.21498463751
Rt1457 T155 T1200 23348909.006660812
Rt1458 T155 T1201 2500400.2557334546
Rt1459 T155 T1202 14306293.449076589
Gcorr441 T155 T2129 T155 T2129 -9.8660108092007557e-08
Rt1460 T155 T3019 2798576.9922379428
Rt1461 T155 T3582 1630720.8098593024
Rt1462 T155 T4554 23348909.006643668
Rt1463 T155 T4555 2500400.255734256
Rt1464 T155 T4556 14306293.449063487
Gcorr442 T155 T5485 T155 T5485 -9.8660108091977646e-08
Rt1465 T156 T157 731558.34031216975
Rt1466 T156 T548 472293.09813060617
Rt1467 T156 T789 558080.65744138032
Rt1468 T156 T1195 12392905.820297278
Rt1469 T156 T1197 16460922.818835592
Rt1470 T156 T1198 9541828.1224970184
Rt1471 T156 T2755 3053831.1795852766
Rt1472 T156 T3869 1571270.8762875113
Rt1473 T156 T4549 12392905.820287358
Rt1474 T156 T4551 16460922.818821093
Rt1475 T156 T4552 9541828.1225079224
Rt1476 T157 T561 469150.43211999681
Rt1477 T157 T789 559215.09105269623
Rt1478 T157 T1193 9386712.1385004893
Rt1479 T157 T1195 10016167.38059086
Rt1480 T157 T1197 24868561.636128578
Rt1481 T157 T2755 2938336.3888950516
Rt1482 T157 T3865 1595874.25573169
Rt1483 T157 T4547 9386712.138497347
Rt1484 T157 T4549 10016167.380594477
Rt1485 T157 T4551 24868561.636129349
Rt1486 T158 T159 956388.1117334275
Rt1487 T158 T579 482532.03102728602
Rt1488 T158 T653 566077.32175314089
Rt1489 T158 T1190 12694262.498867758
Gcorr443 T158 T1191 T158 T1191 -9.039296960430626e-08
Rt1490 T158 T1192 3095216.9657680709
Rt1491 T158 T2795 1824085.1433906916
Rt1492 T158 T4034 947994.57271072478
Rt1493 T158 T4544 12694262.498862471
Gcorr444 T158 T4545 T158 T4545 -9.0392969604430602e-08
Rt1494 T158 T4546 3095216.9657672136
Rt1495 T159 T579 416056.25009139621
Rt1496 T159 T778 444549.65111609164
Gcorr445 T159 T1188 T159 T1188 -1.9929117381003211e-07
Rt1497 T159 T1190 1474365.042403945
Gcorr446 T159 T1228 T159 T1228 -2.3650940805004031e-07
Rt1498 T159 T2443 12429617.53432711
Rt1499 T159 T2795 3367648.1058031479
Rt1500 T159 T3854 1064295.920559895
Gcorr447 T159 T4542 T159 T4542 -1.9929117381011502e-07
Rt1501 T159 T4544 1474365.0424044279
Gcorr448 T159 T4582 T159 T4582 -2.365094080499874e-07
Rt1502 T159 T5797 12429617.534288486
Rt1503 T160 T161 1028591.6753766343
Rt1504 T160 T633 555838.66139286268
Rt1505 T160 T751 297948.1811155341
Gcorr449 T160 T1186 T160 T1186 -9.5943439998320329e-08
Rt1506 T160 T1336 1305035.5419697431
Rt1507 T160 T2086 4830487.4948472567
Gcorr450 T160 T2087 T160 T2087 -5.5082844172295387e-07
Rt1508 T160 T2739 1760443.0749036702
Rt1509 T160 T4145 978282.9559525589
Gcorr451 T160 T4540 T160 T4540 -9.5943439998465119e-08
Rt1510 T160 T4690 1305035.54196873
Rt1511 T160 T5440 4830487.4948479105
Gcorr452 T160 T5441 T160 T5441 -5.5082844172337802e-07
Rt1512 T161 T162 740954.284321288
Rt1513 T161 T670 492335.66178205912
Rt1514 T161 T751 349927.80428636872
Gcorr453 T161 T1182 T161 T1182 -1.4712156159232332e-07
Rt1515 T161 T2086 1265917.2738967659
Gcorr454 T161 T2087 T161 T2087 -3.3232188130874001e-07
Rt1516 T161 T2089 20030816.062206149
Rt1517 T161 T2739 3305284.0642142599
Rt1518 T161 T3704 1380453.1895731972
Gcorr455 T161 T4536 T161 T4536 -1.4712156159239394e-07
Rt1519 T161 T5440 1265917.2738971158
Gcorr456 T161 T5441 T161 T5441 -3.3232188130870248e-07
Rt1520 T161 T5443 20030816.062106226
Rt1521 T162 T670 566671.789740109
Rt1522 T162 T699 484437.91370890534
Rt1523 T162 T1182 5681776.5818813061
Rt1524 T162 T2089 9163689.5756264441
Rt1525 T162 T2166 14081137.813924862
Rt1526 T162 T3704 3709694.8543112539
Rt1527 T162 T3845 1545365.87826583
Rt1528 T162 T4536 5681776.581885973
Rt1529 T162 T5443 9163689.575602578
Rt1530 T162 T5522 14081137.813953042
Rt1531 T163 T164 966685.17881107226
Rt1532 T163 T643 284158.71482160914
Rt1533 T163 T766 494645.81547987374
Rt1534 T163 T1175 18257602.8044798
Gcorr457 T163 T1177 T163 T1177 -1.958826839035856e-06
Rt1535 T163 T1178 335080.85900446883
Gcorr458 T163 T2109 T163 T2109 -7.3068295998285009e-07
Rt1536 T163 T2787 1680804.1796509027
Rt1537 T163 T4067 171822.43813678803
Rt1538 T163 T4529 18257602.804536365
Gcorr459 T163 T4531 T163 T4531 -1.9588268390360009e-06
Rt1539 T163 T4532 335080.85900445253
Gcorr460 T163 T5460 T163 T5460 -7.3068295998268301e-07
Rt1540 T164 T165 365096.78241095407
Rt1541 T164 T643 312435.23860633554
Rt1542 T164 T752 444431.07450393756
Gcorr461 T164 T1172 T164 T1172 -8.088257688410841e-07
Gcorr462 T164 T1174 T164 T1174 -1.1838800083639543e-07
Rt1543 T164 T1175 521024.23262230121
Gcorr463 T164 T2109 T164 T2109 -5.8048403479847624e-07
Rt1544 T164 T3507 7980857.7911268845
Rt1545 T164 T4067 3684260.8529150374
Rt1546 T164 T4156 1420188.6879828873
Gcorr464 T164 T4526 T164 T4526 -8.0882576884091056e-07
Gcorr465 T164 T4528 T164 T4528 -1.1838800083621037e-07
Rt1547 T164 T4529 521024.23262196465
Gcorr466 T164 T5460 T164 T5460 -5.8048403480007692e-07
Rt1548 T165 T166 707522.25628111977
Rt1549 T165 T637 497474.59667119267
Rt1550 T165 T752 515177.63675352366
Gcorr467 T165 T1171 T165 T1171 -9.4293139970595821e-08
Rt1551 T165 T1172 1018414.8762680031
Rt1552 T165 T1174 4741837.4584337529
Gcorr468 T165 T1175 T165 T1175 -7.5338106155735443e-07
Rt1553 T165 T2736 5609256.5139719844
Rt1554 T165 T4156 1977370.0352090101
Gcorr469 T165 T4525 T165 T4525 -9.4293139970583989e-08
Rt1555 T165 T4526 1018414.8762685902
Rt1556 T165 T4528 4741837.4584277235
Gcorr470 T165 T4529 T165 T4529 -7.5338106155707056e-07
Rt1557 T166 T167 805557.79371322412
Rt1558 T166 T637 591669.17125473497
Rt1559 T166 T774 429041.92337946594
Gcorr471 T166 T1169 T166 T1169 -9.8564861338916419e-08
Rt1560 T166 T1170 3148056.1208512592
Rt1561 T166 T1171 3424884.7098404416
Gcorr472 T166 T1172 T166 T1172 -1.3932524908563393e-07
Rt1562 T166 T2736 1738318.5869694257
Rt1563 T166 T3691 3590951.4568017619
Gcorr473 T166 T4523 T166 T4523 -9.8564861339003928e-08
Rt1564 T166 T4524 3148056.1208523805
Rt1565 T166 T4525 3424884.7098377296
Gcorr474 T166 T4526 T166 T4526 -1.3932524908566702e-07
Rt1566 T167 T168 1291766.5660248373
Rt1567 T167 T774 527886.31283271464
Rt1568 T167 T812 404450.77872074855
Rt1569 T167 T1167 29052028.584350009
Rt1570 T167 T1168 10781827.864653461
Rt1571 T167 T1169 2701948.5160370138
Gcorr475 T167 T1170 T167 T1170 -1.3963967769187011e-07
Rt1572 T167 T2907 1752261.3791577308
Rt1573 T167 T3691 1673095.7860500594
Rt1574 T167 T4521 29052028.584353719
Rt1575 T167 T4522 10781827.86468238
Rt1576 T167 T4523 2701948.5160345519
Gcorr476 T167 T4524 T167 T4524 -1.3963967769195658e-07
Rt1577 T168 T611 312661.53789516405
Rt1578 T168 T812 446331.31675680738
Rt1579 T168 T1165 6358541.4661083855
Gcorr477 T168 T1166 T168 T1166 -1.1829093463742921e-07
Rt1580 T168 T1167 1035798.8576498703
Gcorr478 T168 T2320 T168 T2320 -6.4469288327200024e-07
Rt1581 T168 T2907 1479474.1617795937
Rt1582 T168 T3808 1523100.582590654
Rt1583 T168 T4519 6358541.4661076963
Gcorr479 T168 T4520 T168 T4520 -1.1829093463765847e-07
Rt1584 T168 T4521 1035798.857649685
Gcorr480 T168 T5674 T168 T5674 -6.446928832719635e-07
Rt1585 T169 T170 834437.04209285718
Rt1586 T169 T635 551418.02841211914
Rt1587 T169 T756 428900.82583387499
Rt1588 T169 T1163 526150.18086405529
Gcorr481 T169 T1165 T169 T1165 -1.544565324002546e-06
Rt1589 T169 T1242 5640065.9871498607
Gcorr482 T169 T2120 T169 T2120 -1.1389873591894173e-07
Rt1590 T169 T2757 3069258.0595864281
Rt1591 T169 T3608 3303515.7366878102
Rt1592 T169 T4517 526150.18086162757
Gcorr483 T169 T4519 T169 T4519 -1.5445653240117962e-06
Rt1593 T169 T4596 5640065.9871355984
Gcorr484 T169 T5475 T169 T5475 -1.1389873591891179e-07
Rt1594 T170 T689 457723.37083963148
Rt1595 T170 T756 501131.84821840911
Rt1596 T170 T1161 2239356.9859745293
Gcorr485 T170 T1163 T170 T1163 -1.3394016777499644e-07
Gcorr486 T170 T2118 T170 T2118 -9.8165473166323417e-08
Rt1597 T170 T2120 5052622.1408702238
Rt1598 T170 T2959 3042947.7224492622
Rt1599 T170 T3608 1800319.1917132426
Rt1600 T170 T4515 2239356.9859753256
Gcorr487 T170 T4517 T170 T4517 -1.3394016777499922e-07
Gcorr488 T170 T5471 T170 T5471 -9.816547316636029e-08
Rt1601 T170 T5475 5052622.1408652291
Rt1602 T171 T172 737544.5272537393
Rt1603 T171 T625 474074.12861529336
Rt1604 T171 T779 512165.3801302627
Gcorr489 T171 T1155 T171 T1155 -1.367811345873617e-07
Rt1605 T171 T1156 2807948.1144453245
Rt1606 T171 T1157 4660885.0467605432
Gcorr490 T171 T1158 T171 T1158 -1.1452798892938749e-07
Rt1607 T171 T2750 3582643.236976875
Rt1608 T171 T3873 1347146.4435178081
Gcorr491 T171 T4509 T171 T4509 -1.3678113458729971e-07
Rt1609 T171 T4510 2807948.1144497865
Rt1610 T171 T4511 4660885.0467523169
Gcorr492 T171 T4512 T171 T4512 -1.1452798892926435e-07
Rt1611 T172 T625 562163.78612618265
Rt1612 T172 T724 473784.45984851627
Rt1613 T172 T1154 3290555.9473264785
Rt1614 T172 T1155 13387206.30185996
Gcorr493 T172 T1156 T172 T1156 -6.2675255685641588e-08
Rt1615 T172 T2750 1575512.1869308434
Rt1616 T172 T4005 2468888.7894058749
Rt1617 T172 T4508 3290555.9473285973
Rt1618 T172 T4509 13387206.301829493
Gcorr494 T172 T4510 T172 T4510 -6.267525568561799e-08
Rt1619 T173 T606 451878.52735455608
Rt1620 T173 T777 424141.63729639328
Rt1621 T173 T1150 4399218.6195917334
Gcorr495 T173 T1151 T173 T1151 -1.330186205623099e-07
Rt1622 T173 T1152 2811805.9920460619
Gcorr496 T173 T2132 T173 T2132 -8.7436610218150218e-08
Rt1623 T173 T2982 1757709.8670625249
Rt1624 T173 T4055 1095543.6053469121
Rt1625 T173 T4504 4399218.6195926191
Gcorr497 T173 T4505 T173 T4505 -1.3301862056219952e-07
Rt1626 T173 T4506 2811805.9920455292
Gcorr498 T173 T5488 T173 T5488 -8.7436610218284697e-08
Rt1627 T174 T672 504925.48445342964
Rt1628 T174 T783 480636.50910202082
Rt1629 T174 T1148 12708948.891808875
Rt1630 T174 T1467 16759332.10195427
Rt1631 T174 T2147 3302267.076739131
Gcorr499 T174 T2734 T174 T2734 -6.8866409915734033e-08
Rt1632 T174 T2777 2268930.9144514864
Rt1633 T174 T3964 1478505.9357819972
Rt1634 T174 T4502 12708948.891780602
Rt1635 T174 T4821 16759332.101949887
Rt1636 T174 T5503 3302267.0767400274
Gcorr500 T174 T6089 T174 T6089 -6.8866409915845008e-08
Rt1637 T175 T767 413792.91027744737
Rt1638 T175 T787 480400.3987475204
Rt1639 T175 T1134 1453777.9039359859
Gcorr501 T175 T1136 T175 T1136 -1.4143778380081849e-07
Rt1640 T175 T1687 3930489.6615750939
Gcorr502 T175 T2202 T175 T2202 -4.3507177153310322e-07
Rt1641 T175 T2965 688879.22217072954
Rt1642 T175 T3698 3331558.5034201411
Rt1643 T175 T4488 1453777.9039354951
Gcorr503 T175 T4490 T175 T4490 -1.4143778380067188e-07
Rt1644 T175 T5041 3930489.661578963
Gcorr504 T175 T5559 T175 T5559 -4.3507177153323409e-07
Rt1645 T176 T638 498045.82908582001
Rt1646 T176 T648 482678.20394994854
Rt1647 T176 T1130 14243432.474711586
Rt1648 T176 T1131 8540759.5447664987
Rt1649 T176 T1132 7514591.6979237013
Rt1650 T176 T2760 2997472.1756419861
Rt1651 T176 T3940 1559145.3410957863
Rt1652 T176 T4484 14243432.474741885
Rt1653 T176 T4485 8540759.5447577424
Rt1654 T176 T4486 7514591.6979221692
Rt1655 T177 T178 707241.94751743751
Rt1656 T177 T545 480074.37429750181
Rt1657 T177 T811 557861.38372941292
Rt1658 T177 T1478 4810722.6141144559
Gcorr505 T177 T2259 T177 T2259 -8.2736124269165928e-08
Rt1659 T177 T2644 10928645.399721811
Rt1660 T177 T2963 3327806.6499661361
Rt1661 T177 T3932 3114208.7124952236
Rt1662 T177 T4832 4810722.6141131306
Gcorr506 T177 T5614 T177 T5614 -8.273612426913255e-08
Rt1663 T177 T5998 10928645.399732804
Rt1664 T178 T649 791990.29065650946
Rt1665 T178 T811 408508.58971436822
Gcorr507 T178 T1478 T178 T1478 -1.0380918882532981e-07
Rt1666 T178 T2337 2893742.8621303109
Gcorr508 T178 T2564 T178 T2564 -1.306529859131564e-09
Gcorr509 T178 T2644 T178 T2644 -1.8264395365114466e-08
Rt1667 T178 T2963 1544919.4874788241
Rt1668 T178 T4071 1153792.9517100216
Gcorr510 T178 T4832 T178 T4832 -1.0380918882516055e-07
Rt1669 T178 T5690 2893742.8621302741
Gcorr511 T178 T5918 T178 T5918 -1.3065298593999601e-09
Gcorr512 T178 T5998 T178 T5998 -1.8264395365021213e-08
Rt1670 T179 T180 738961.55037903413
Rt1671 T179 T543 399318.25219960703
Rt1672 T179 T806 562907.14088837872
Gcorr513 T179 T1812 T179 T1812 -2.4945722663750231e-07
Rt1673 T179 T1913 7029881.4478092827
Gcorr514 T179 T2238 T179 T2238 -9.3711035922805873e-08
Rt1674 T179 T2631 2343383.0119684506
Rt1675 T179 T2741 1482144.4795012116
Rt1676 T179 T3874 2989647.7072276943
Gcorr515 T179 T5167 T179 T5167 -2.4945722663744429e-07
Rt1677 T179 T5270 7029881.4478024263
Gcorr516 T179 T5593 T179 T5593 -9.3711035922912044e-08
Rt1678 T179 T5985 2343383.0119689568
Rt1679 T180 T552 453671.95823721128
Rt1680 T180 T806 559727.14651152829
Gcorr517 T180 T1674 T180 T1674 -9.1887937774401254e-09
Rt1681 T180 T2238 3490569.8745267754
Rt1682 T180 T2631 13961160.265012858
Gcorr518 T180 T2730 T180 T2730 -1.2201002558494695e-07
Rt1683 T180 T2741 3264942.3801291022
Rt1684 T180 T3885 1529980.908014514
Gcorr519 T180 T5028 T180 T5028 -9.1887937775245242e-09
Rt1685 T180 T5593 3490569.8745254204
Rt1686 T180 T5985 13961160.26498865
Gcorr520 T180 T6085 T180 T6085 -1.2201002558509947e-07
Rt1687 T181 T182 967617.89562091848
Rt1688 T181 T588 515288.98694228847
Rt1689 T181 T671 385963.58858469268
Gcorr521 T181 T1971 T181 T1971 -4.0912459665514462e-07
Gcorr522 T181 T2142 T181 T2142 -1.0151601308768015e-07
Rt1690 T181 T2249 3999554.2310593477
Rt1691 T181 T2272 1612691.1256281233
Rt1692 T181 T2888 748274.95150233223
Rt1693 T181 T3531 2837933.2867794838
Gcorr523 T181 T5325 T181 T5325 -4.0912459665487335e-07
Gcorr524 T181 T5498 T181 T5498 -1.0151601308751564e-07
Rt1694 T181 T5604 3999554.2310595163
Rt1695 T181 T5626 1612691.1256292355
Rt1696 T182 T183 920391.74976431183
Rt1697 T182 T588 595346.38857206993
Rt1698 T182 T795 375603.87335759564
Rt1699 T182 T983 13583244.017993238
Gcorr525 T182 T989 T182 T989 -1.704881478153493e-07
Gcorr526 T182 T1971 T182 T1971 -2.705695974685918e-07
Rt1700 T182 T2249 1355637.2162167961
Rt1701 T182 T2888 955526.0385808039
Rt1702 T182 T3686 1776559.9051686965
Rt1703 T182 T4337 13583244.018047202
Gcorr527 T182 T4343 T182 T4343 -1.7048814781539162e-07
Gcorr528 T182 T5325 T182 T5325 -2.7056959746800745e-07
Rt1704 T182 T5604 1355637.2162172589
Rt1705 T183 T184 976209.36242246686
Rt1706 T183 T607 513413.90089373133
Rt1707 T183 T795 472390.90317296359
Rt1708 T183 T983 7587713.9311870411
Rt1709 T183 T984 7782167.9601233881
Rt1710 T183 T989 9096536.2800725009
Rt1711 T183 T2754 1752560.9110858855
Rt1712 T183 T3686 3511504.0426843278
Rt1713 T183 T4337 7587713.9311766941
Rt1714 T183 T4338 7782167.9601454623
Rt1715 T183 T4343 9096536.2800574247
Rt1716 T184 T185 956124.246689694
Rt1717 T184 T607 462425.56984953879
Rt1718 T184 T810 401293.20612349681
Rt1719 T184 T984 2403058.7401565192
Gcorr529 T184 T993 T184 T993 -1.759681739933924e-07
Rt1720 T184 T1281 11535931.32419017
Rt1721 T184 T2059 24091298.817915604
Rt1722 T184 T2754 1709404.1472909616
Rt1723 T184 T3687 3084243.2522396795
Rt1724 T184 T4338 2403058.74015278
Gcorr530 T184 T4347 T184 T4347 -1.7596817399343563e-07
Rt1725 T184 T4635 11535931.324262647
Rt1726 T184 T5413 24091298.817951709
Rt1727 T185 T639 403195.16517633339
Rt1728 T185 T810 432030.80397682468
Rt1729 T185 T1281 2872236.8883359171
Rt1730 T185 T2059 14647994.313435767
Rt1731 T185 T2060 2682803.1326864292
Gcorr531 T185 T2061 T185 T2061 -4.1372160267423485e-07
Rt1732 T185 T2926 1786858.8998485331
Rt1733 T185 T3687 3258531.3187332777
Rt1734 T185 T4635 2872236.8883374962
Rt1735 T185 T5413 14647994.313407924
Rt1736 T185 T5414 2682803.1326855086
Gcorr532 T185 T5415 T185 T5415 -4.1372160267430346e-07
Rt1737 T186 T187 1188559.9687128987
Rt1738 T186 T601 595557.66103321814
Rt1739 T186 T790 304532.55367905478
Rt1740 T186 T2062 2430265.7391749527
Rt1741 T186 T2194 3483493.7088912441
Gcorr533 T186 T2245 T186 T2245 -4.2836937548353381e-07
Rt1742 T186 T2594 12851013.691690654
Rt1743 T186 T2737 1725376.096054998
Rt1744 T186 T3842 2868424.5862919004
Rt1745 T186 T5416 2430265.7391722794
Rt1746 T186 T5551 3483493.7088920325
Gcorr534 T186 T5600 T186 T5600 -4.2836937548405082e-07
Rt1747 T186 T5948 12851013.69166968
Rt1748 T187 T188 771728.43202851235
Rt1749 T187 T597 591350.42654607387
Rt1750 T187 T790 419075.5345439529
Rt1751 T187 T1375 18866100.623409417
Rt1752 T187 T2193 9510544.6049604658
Rt1753 T187 T2194 2950654.4309252999
Gcorr535 T187 T2628 T187 T2628 -1.4228807168819222e-07
Rt1754 T187 T2737 1570448.1731518595
Rt1755 T187 T3717 1825629.7971520459
Rt1756 T187 T4729 18866100.623456784
Rt1757 T187 T5550 9510544.6049685068
Rt1758 T187 T5551 2950654.430923651
Gcorr536 T187 T5982 T187 T5982 -1.4228807168816199e-07
Rt1759 T188 T189 1271943.331405787
Rt1760 T188 T597 591924.16634580377
Rt1761 T188 T794 419648.90918813425
Rt1762 T188 T982 7116426.2665368607
Rt1763 T188 T1375 8918284.8557229955
Rt1764 T188 T2193 11191669.177713128
Rt1765 T188 T3717 3592563.648819102
Rt1766 T188 T3907 1434640.1230561072
Rt1767 T188 T4336 7116426.2665523896
Rt1768 T188 T4729 8918284.8557107188
Rt1769 T188 T5550 11191669.177694345
Rt1770 T189 T190 771997.94196670456
Rt1771 T189 T604 582702.6693538737
Rt1772 T189 T794 422805.16070499085
Gcorr537 T189 T959 T189 T959 -5.0906509213474899e-07
Rt1773 T189 T960 2041314.9193245661
Rt1774 T189 T982 3187287.9456854267
Rt1775 T189 T985 20783879.556563504
Rt1776 T189 T2763 3871467.8481549504
Rt1777 T189 T3907 529986.28737164172
Gcorr538 T189 T4313 T189 T4313 -5.0906509213458022e-07
Rt1778 T189 T4314 2041314.9193269853
Rt1779 T189 T4336 3187287.9456803841
Rt1780 T189 T4339 20783879.556601025
Rt1781 T190 T191 938169.4932755616
Rt1782 T190 T604 463678.10483310337
Rt1783 T190 T803 473697.60180730768
Rt1784 T190 T960 2977591.6344922716
Gcorr539 T190 T985 T190 T985 -1.5426598372707495e-07
Rt1785 T190 T1461 2986809.5832906677
Gcorr540 T190 T2069 T190 T2069 -1.751569665005823e-07
Rt1786 T190 T2763 3822164.2534520198
Rt1787 T190 T3911 1000973.6384336795
Rt1788 T190 T4314 2977591.634489723
Gcorr541 T190 T4339 T190 T4339 -1.542659837270496e-07
Rt1789 T190 T4815 2986809.5832923814
Gcorr542 T190 T5423 T190 T5423 -1.7515696650070528e-07
Rt1790 T191 T640 486568.62220440817
Rt1791 T191 T803 393917.61835921439
Rt1792 T191 T1461 12705989.566384966
Rt1793 T191 T2069 12752678.737938818
Gcorr543 T191 T2214 T191 T2214 -1.5219314947890772e-07
Rt1794 T191 T2413 3057867.0180603783
Rt1795 T191 T2983 1616337.3517519957
Rt1796 T191 T3911 2733776.061044367
Rt1797 T191 T4815 12705989.566353127
Rt1798 T191 T5423 12752678.737914892
Gcorr544 T191 T5570 T191 T5570 -1.5219314947891855e-07
Rt1799 T191 T5766 3057867.0180635178
Rt1800 T192 T193 963076.01651108521
Rt1801 T192 T547 433161.30880929029
Rt1802 T192 T800 560300.40228969057
Gcorr545 T192 T1700 T192 T1700 -1.5506369899244371e-07
Rt1803 T192 T1865 4632830.6738410769
Rt1804 T192 T2517 5835484.6799072521
Rt1805 T192 T2738 1544691.4691052795
Rt1806 T192 T3878 3244442.1125960071
Gcorr546 T192 T5054 T192 T5054 -1.5506369899222123e-07
Rt1807 T192 T5220 4632830.6738482388
Rt1808 T192 T5871 5835484.6799035193
Rt1809 T193 T551 457903.55418590893
Rt1810 T193 T800 563579.00039955706
Rt1811 T193 T1865 7401953.6388375079
Rt1812 T193 T2373 11386127.909832213
Rt1813 T193 T2738 1460351.3356609785
Rt1814 T193 T4050 2472779.9322788673
Rt1815 T193 T5220 7401953.6388270529
Rt1816 T193 T5727 11386127.909857148
Rt1817 T194 T195 668964.53559258161
Rt1818 T194 T544 457015.83060278173
Rt1819 T194 T809 553274.83717822551
Rt1820 T194 T988 3463510.3256319682
Gcorr547 T194 T2274 T194 T2274 -1.3913109666636512e-07
Rt1821 T194 T2495 13716786.203933442
Rt1822 T194 T2989 3233568.435599416
Rt1823 T194 T3891 3228932.8257517163
Rt1824 T194 T4342 3463510.3256309316
Gcorr548 T194 T5628 T194 T5628 -1.3913109666644564e-07
Rt1825 T194 T5849 13716786.203934832
Rt1826 T195 T544 587844.56161135505
Rt1827 T195 T830 381166.31985500426
Gcorr549 T195 T988 T195 T988 -1.2083801784622906e-07
Rt1828 T195 T2029 3710178.597563182
Rt1829 T195 T2274 15073636.171378043
Rt1830 T195 T2756 3273159.4508771584
Rt1831 T195 T3891 1327240.6405386294
Gcorr550 T195 T4342 T195 T4342 -1.2083801784590509e-07
Rt1832 T195 T5382 3710178.5975683481
Rt1833 T195 T5628 15073636.17136671
Rt1834 T196 T621 516282.3911722753
Rt1835 T196 T697 385168.33702336065
Gcorr551 T196 T972 T196 T972 -1.3188648233807094e-07
Rt1836 T196 T976 4314954.7592144208
Rt1837 T196 T2068 2614379.4373633419
Gcorr552 T196 T2158 T196 T2158 -9.9637299605838893e-08
Rt1838 T196 T2955 1626093.4122116354
Rt1839 T196 T3923 1422573.0766846635
Gcorr553 T196 T4326 T196 T4326 -1.3188648233818695e-07
Rt1840 T196 T4330 4314954.759216195
Rt1841 T196 T5422 2614379.4373623035
Gcorr554 T196 T5514 T196 T5514 -9.9637299605782102e-08
Rt1842 T197 T617 503042.38884964777
Rt1843 T197 T815 411733.98085781437
Rt1844 T197 T974 13092568.007638063
Rt1845 T197 T986 8224166.8600527849
Rt1846 T197 T2196 5465801.6399073945
Rt1847 T197 T2778 1907460.6792629256
Rt1848 T197 T4139 1669028.9677583647
Rt1849 T197 T4328 13092568.007619727
Rt1850 T197 T4340 8224166.8600469092
Rt1851 T197 T5553 5465801.6399132609
Rt1852 T198 T610 507190.93160073872
Rt1853 T198 T776 489008.34703637229
Rt1854 T198 T1814 3536126.8499174556
Gcorr555 T198 T2012 T198 T2012 -4.4491163211277235e-08
Rt1855 T198 T2206 8623994.6196758412
Rt1856 T198 T3889 1179099.8520573676
Rt1857 T198 T4182 3974907.0972098284
Rt1858 T198 T5169 3536126.8499203683
Gcorr556 T198 T5365 T198 T5365 -4.449116321099242e-08
Rt1859 T198 T5562 8623994.6196798813
Rt1860 T199 T696 553007.97559396457
Rt1861 T199 T780 404994.47361628403
Rt1862 T199 T1015 3067956.0187772131
Rt1863 T199 T1959 4426032.660846781
Gcorr557 T199 T2267 T199 T2267 -5.5619483109239525e-08
Gcorr558 T199 T2459 T199 T2459 -1.0358096133020037e-07
Rt1864 T199 T2841 3613419.1462678569
Rt1865 T199 T3597 1482791.0893568078
Rt1866 T199 T4369 3067956.0187724642
Rt1867 T199 T5313 4426032.6608464802
Gcorr559 T199 T5622 T199 T5622 -5.5619483109386796e-08
Gcorr560 T199 T5813 T199 T5813 -1.0358096133057567e-07
Rt1868 T200 T201 722993.4776431853
Rt1869 T200 T647 475145.34364427644
Rt1870 T200 T727 542228.67737546237
Rt1871 T200 T1266 2915693.3326653317
Rt1872 T200 T1912 10068500.815143237
Gcorr561 T200 T2260 T200 T2260 -8.7449660464673741e-08
Rt1873 T200 T2751 3980470.6585340882
Rt1874 T200 T3913 2951457.4097875268
Rt1875 T200 T4620 2915693.3326631025
Rt1876 T200 T5269 10068500.815149276
Gcorr562 T200 T5615 T200 T5615 -8.744966046487879e-08
Rt1877 T201 T626 521086.55563134543
Rt1878 T201 T727 485224.6908001047
Gcorr563 T201 T1266 T201 T1266 -1.4961388762813496e-07
Rt1879 T201 T1910 2662434.2734782654
Gcorr564 T201 T1911 T201 T1911 -1.4178386078592134e-07
Rt1880 T201 T1912 3639067.5181096257
Rt1881 T201 T2751 1453880.8669256032
Rt1882 T201 T3971 2720464.3986203736
Gcorr565 T201 T4620 T201 T4620 -1.4961388762805782e-07
Rt1883 T201 T5267 2662434.2734758975
Gcorr566 T201 T5268 T201 T5268 -1.4178386078596488e-07
Rt1884 T201 T5269 3639067.5181145268
Rt1885 T202 T203 919088.89146155654
Rt1886 T202 T577 451861.59701248346
Rt1887 T202 T772 470957.6929673602
Rt1888 T202 T1033 3279308.9974757913
Rt1889 T202 T1946 32729725.973729085
Gcorr567 T202 T2036 T202 T2036 -6.6215667966668515e-08
Rt1890 T202 T2950 3348327.3642213754
Rt1891 T202 T3835 1457904.2397458158
Rt1892 T202 T4387 3279308.9974757875
Rt1893 T202 T5302 32729725.973387711
Gcorr568 T202 T5389 T202 T5389 -6.62156679669895e-08
Rt1894 T203 T204 928278.58525551565
Rt1895 T203 T553 435713.42168487789
Rt1896 T203 T772 446495.91384580603
Rt1897 T203 T1946 1515920.5628574942
Gcorr569 T203 T2723 T203 T2723 -3.9038528403046485e-07
Rt1898 T203 T2759 3088039.5763563174
Rt1899 T203 T3835 3053857.7932362538
Rt1900 T203 T5302 1515920.5628574318
Gcorr570 T203 T6078 T203 T6078 -3.9038528403049375e-07
Rt1901 T204 T553 340002.24184607161
Rt1902 T204 T773 560061.26835235639
Gcorr571 T204 T1011 T204 T1011 -1.2733811865551745e-07
Rt1903 T204 T1946 3567606.5640510051
Rt1904 T204 T2085 1967065.7740690338
Gcorr572 T204 T2723 T204 T2723 -4.0296767547296207e-07
Rt1905 T204 T2759 1509005.1390223689
Rt1906 T204 T4036 1141664.4807683942
Gcorr573 T204 T4365 T204 T4365 -1.2733811865530852e-07
Rt1907 T204 T5302 3567606.5640515313
Rt1908 T204 T5439 1967065.7740697644
Gcorr574 T204 T6078 T204 T6078 -4.0296767547294249e-07
Rt1909 T205 T206 932811.87583626551
Rt1910 T205 T605 531100.93880118779
Rt1911 T205 T798 389944.36577641498
Gcorr575 T205 T1013 T205 T1013 -1.6556579442988924e-07
Rt1912 T205 T1016 2970013.8301371629
Rt1913 T205 T1075 3121665.6144608995
Gcorr576 T205 T2187 T205 T2187 -1.385638526004294e-07
Rt1914 T205 T2957 1205439.7434452721
Rt1915 T205 T3693 3700268.9017029139
Gcorr577 T205 T4367 T205 T4367 -1.6556579442986362e-07
Rt1916 T205 T4370 2970013.8301352286
Rt1917 T205 T4429 3121665.6144632259
Gcorr578 T205 T5544 T205 T5544 -1.3856385260043798e-07
Rt1918 T206 T207 976427.35193463927
Rt1919 T206 T609 509650.68924801156
Rt1920 T206 T798 463416.29586264479
Rt1921 T206 T1016 11549713.260078879
Gcorr579 T206 T1017 T206 T1017 -1.7149172060954148e-07
Rt1922 T206 T1018 2532238.8946493277
Rt1923 T206 T2187 17292310.467554629
Rt1924 T206 T2740 1360364.8591220563
Rt1925 T206 T3693 1701943.8077705391
Rt1926 T206 T4370 11549713.260080779
Gcorr580 T206 T4371 T206 T4371 -1.7149172060931847e-07
Rt1927 T206 T4372 2532238.8946488318
Rt1928 T206 T5544 17292310.467640903
Rt1929 T207 T208 778274.0626740834
Rt1930 T207 T609 328170.02806115756
Rt1931 T207 T695 569666.22852178465
Rt1932 T207 T1018 3376878.9631610517
Rt1933 T207 T1019 14584711.207668394
Rt1934 T207 T1020 1992659.5572569347
Gcorr581 T207 T2152 T207 T2152 -4.9636414052135912e-07
Rt1935 T207 T2740 1898257.5469791065
Rt1936 T207 T3898 2756460.7477677404
Rt1937 T207 T4372 3376878.9631639034
Rt1938 T207 T4373 14584711.207582526
Rt1939 T207 T4374 1992659.5572538145
Gcorr582 T207 T5508 T207 T5508 -4.9636414052230102e-07
Rt1940 T208 T209 733678.39415022556
Rt1941 T208 T694 560443.15927446121
Rt1942 T208 T695 492089.12654748623
Gcorr583 T208 T1019 T208 T1019 -1.868872927559007e-07
Rt1943 T208 T1020 7921236.871666478
Rt1944 T208 T1021 2625553.0523583172
Rt1945 T208 T1022 15026231.977198701
Rt1946 T208 T3593 3980096.6449437314
Rt1947 T208 T3898 1289964.4910275151
Gcorr584 T208 T4373 T208 T4373 -1.8688729275586441e-07
Rt1948 T208 T4374 7921236.871688474
Rt1949 T208 T4375 2625553.0523562878
Rt1950 T208 T4376 15026231.977194808
Rt1951 T209 T210 1022776.394718073
Rt1952 T209 T694 567014.5114244927
Rt1953 T209 T714 464142.07128830423
Rt1954 T209 T1021 12977124.76254037
Rt1955 T209 T1022 17363578.818200044
Rt1956 T209 T1023 2353839.2222042195
Gcorr585 T209 T1024 T209 T1024 -1.5623524084917559e-07
Rt1957 T209 T2776 1230568.9135799343
Rt1958 T209 T3593 2498064.1232296946
Rt1959 T209 T4375 12977124.762550326
Rt1960 T209 T4376 17363578.818314493
Rt1961 T209 T4377 2353839.2222023765
Gcorr586 T209 T4378 T209 T4378 -1.562352408490723e-07
Rt1962 T210 T650 570411.03215286462
Rt1963 T210 T714 463148.12648514617
Rt1964 T210 T1023 9117847.7952031828
Rt1965 T210 T1025 8383424.8864148902
Rt1966 T210 T2095 5797198.795172181
Rt1967 T210 T2776 1616725.8095732615
Rt1968 T210 T3651 6682227.7717585787
Rt1969 T210 T4377 9117847.7952329945
Rt1970 T210 T4379 8383424.8863975406
Rt1971 T210 T5448 5797198.7951685162
Rt1972 T211 T212 969363.02543769625
Rt1973 T211 T624 587186.20582862443
Rt1974 T211 T784 357677.37887850346
Gcorr587 T211 T1031 T211 T1031 -1.5292491954928808e-07
Rt1975 T211 T1416 1433021.2749868031
Gcorr588 T211 T1787 T211 T1787 -2.451878539508357e-07
Rt1976 T211 T2084 20218610.577819765
Rt1977 T211 T2735 1286139.9970370643
Rt1978 T211 T3876 1461167.188481353
Gcorr589 T211 T4385 T211 T4385 -1.5292491954916648e-07
Rt1979 T211 T4770 1433021.2749860061
Gcorr590 T211 T5141 T211 T5141 -2.4518785395103582e-07
Rt1980 T211 T5438 20218610.577947244
Rt1981 T212 T213 813657.05894766573
Rt1982 T212 T624 501147.91143817804
Rt1983 T212 T753 523825.36550570984
Rt1984 T212 T1034 6593643.2941687936
Rt1985 T212 T1416 9716891.8297364153
Rt1986 T212 T1417 9208474.8907594346
Rt1987 T212 T2735 1734645.764592458
Rt1988 T212 T3701 3513524.4615548006
Rt1989 T212 T4388 6593643.2941549961
Rt1990 T212 T4770 9716891.8297714535
Rt1991 T212 T4771 9208474.8907550909
Rt1992 T213 T632 524065.87135785987
Rt1993 T213 T753 408377.0375311246
Gcorr591 T213 T1034 T213 T1034 -1.3410976115806761e-07
Gcorr592 T213 T1035 T213 T1035 -4.615361324076843e-07
Rt1994 T213 T1417 21371124.27211155
Rt1995 T213 T2063 900298.91952653974
Gcorr593 T213 T2186 T213 T2186 -1.8889462975414152e-07
Rt1996 T213 T2956 1215411.934278985
Rt1997 T213 T3701 642629.86114830861
Gcorr594 T213 T4388 T213 T4388 -1.3410976115821425e-07
Gcorr595 T213 T4389 T213 T4389 -4.6153613240742066e-07
Rt1998 T213 T4771 21371124.272277258
Rt1999 T213 T5417 900298.91952630738
Gcorr596 T213 T5543 T213 T5543 -1.8889462975418498e-07
Rt2000 T214 T215 966726.07269876532
Rt2001 T214 T602 434432.424495493
Rt2002 T214 T713 561973.45518641593
Rt2003 T214 T1039 20843057.309678629
Rt2004 T214 T1697 2396535.2066001273
Gcorr597 T214 T1791 T214 T1791 -1.3885500288640597e-07
Rt2005 T214 T2758 1684148.2209170363
Rt2006 T214 T3909 2516454.050429069
Rt2007 T214 T4393 20843057.309755731
Rt2008 T214 T5051 2396535.2065986344
Gcorr598 T214 T5146 T214 T5146 -1.3885500288649056e-07
Rt2009 T215 T644 517928.14289692609
Rt2010 T215 T713 485004.07798582211
Rt2011 T215 T1697 8429254.8593103141
Rt2012 T215 T1974 24956343.197710507
Rt2013 T215 T2083 5743380.6147921886
Rt2014 T215 T2758 1645203.6917658853
Rt2015 T215 T3682 3475711.8847843129
Rt2016 T215 T5051 8429254.8593396097
Rt2017 T215 T5328 24956343.197676167
Rt2018 T215 T5437 5743380.6147804819
Rt2019 T216 T217 949351.79989828845
Rt2020 T216 T571 562842.72251263598
Rt2021 T216 T764 475233.54571353208
Rt2022 T216 T1045 11520425.9039465
Rt2023 T216 T1047 14612209.464575754
Rt2024 T216 T1261 8336201.491165543
Rt2025 T216 T2800 1643071.6937639473
Rt2026 T216 T3961 2667709.5235828105
Rt2027 T216 T4399 11520425.903955156
Rt2028 T216 T4401 14612209.464464914
Rt2029 T216 T4615 8336201.4911972163
Rt2030 T217 T549 443238.25210718083
Rt2031 T217 T764 571862.93167900387
Gcorr599 T217 T1046 T217 T1046 -1.2108051990701506e-07
Rt2032 T217 T1047 2564020.8532258035
Rt2033 T217 T1048 84587456.72882165
Rt2034 T217 T2800 1337754.2637910687
Rt2035 T217 T3750 1503931.6139337777
Gcorr600 T217 T4400 T217 T4400 -1.2108051990682135e-07
Rt2036 T217 T4401 2564020.8532302221
Rt2037 T217 T4402 84587456.725411311
Rt2038 T218 T219 957715.05208247749
Rt2039 T218 T556 461168.58848197112
Rt2040 T218 T796 448879.91002525215
Rt2041 T218 T1048 5380031.6522540841
Gcorr601 T218 T1049 T218 T1049 -1.295396588852289e-07
Rt2042 T218 T1050 3228594.8865874633
Gcorr602 T218 T1051 T218 T1051 -1.381989498591816e-07
Rt2043 T218 T2745 1422006.3707729699
Rt2044 T218 T4056 1166137.9456794255
Rt2045 T218 T4402 5380031.6522708507
Gcorr603 T218 T4403 T218 T4403 -1.2953965888508716e-07
Rt2046 T218 T4404 3228594.8865824426
Gcorr604 T218 T4405 T218 T4405 -1.3819894985922732e-07
Rt2047 T219 T556 456053.53482082696
Rt2048 T219 T793 449756.91039980849
Rt2049 T219 T1050 3286458.1956997328
Gcorr605 T219 T1052 T219 T1052 -1.4364584172179549e-07
Rt2050 T219 T1061 23088846.147040874
Rt2051 T219 T2171 14540513.35715428
Rt2052 T219 T2745 1020972.2943448984
Gcorr606 T219 T3042 T219 T3042 -2.3556993619017334e-08
Rt2053 T219 T4404 3286458.1957057854
Gcorr607 T219 T4406 T219 T4406 -1.4364584172161923e-07
Rt2054 T219 T4415 23088846.147047486
Rt2055 T219 T5528 14540513.357070815
Rt2056 T220 T221 649515.52582429152
Rt2057 T220 T525 560773.73585163429
Rt2058 T220 T801 472080.94376069313
Gcorr608 T220 T1848 T220 T1848 -1.4954540367110395e-07
Gcorr609 T220 T2171 T220 T2171 -1.3854660640734162e-07
Rt2059 T220 T2229 3330847.5616187369
Rt2060 T220 T2295 4558058.5026087118
Rt2061 T220 T3042 3123189.8860683991
Rt2062 T220 T3880 1485744.1063558999
Gcorr610 T220 T5203 T220 T5203 -1.4954540367084603e-07
Gcorr611 T220 T5528 T220 T5528 -1.3854660640770841e-07
Rt2063 T220 T5584 3330847.5616170396
Rt2064 T220 T5649 4558058.5026096608
Rt2065 T221 T525 357079.1923509257
Rt2066 T221 T691 1243070.1810995385
Rt2067 T221 T1848 3384242.2543305396
Rt2068 T221 T2184 15456170.677245345
Gcorr612 T221 T2229 T221 T2229 -1.0043259301520649e-07
Rt2069 T221 T2761 3268804.3762505716
Rt2070 T221 T3880 3315749.4932064484
Rt2071 T221 T5203 3384242.2543301461
Rt2072 T221 T5541 15456170.677188244
Gcorr613 T221 T5584 T221 T5584 -1.0043259301548157e-07
Rt2073 T222 T223 958822.39855849114
Rt2074 T222 T550 595881.70172082237
Rt2075 T222 T691 349094.9165498644
Gcorr614 T222 T1347 T222 T1347 -1.8602747889570154e-07
Rt2076 T222 T2044 17056201.472172841
Rt2077 T222 T2100 1325367.0592176171
Gcorr615 T222 T2184 T222 T2184 -2.4015420494374621e-07
Rt2078 T222 T3632 1350819.6382470187
Rt2079 T222 T3994 1324746.6527885299
Gcorr616 T222 T4701 T222 T4701 -1.86027478895553e-07
Rt2080 T222 T5398 17056201.472229917
Rt2081 T222 T5453 1325367.0592163156
Gcorr617 T222 T5541 T222 T5541 -2.401542049444421e-07
Rt2082 T223 T224 624594.71172144322
Rt2083 T223 T550 498174.98881236219
Rt2084 T223 T664 499189.17299181537
Rt2085 T223 T1066 7264137.1506551607
Gcorr618 T223 T1067 T223 T1067 -2.0383790739719893e-07
Rt2086 T223 T1255 2325942.7521613049
Rt2087 T223 T2100 16846523.119890507
Rt2088 T223 T2748 3634111.6680706115
Rt2089 T223 T3632 1854411.2519476505
Rt2090 T223 T4420 7264137.1506754272
Gcorr619 T223 T4421 T223 T4421 -2.0383790739673754e-07
Rt2091 T223 T4609 2325942.7521589934
Rt2092 T223 T5453 16846523.120034523
Rt2093 T224 T225 468754.46337807382
Rt2094 T224 T572 436125.04436504847
Rt2095 T224 T664 554523.0060495811
Rt2096 T224 T1067 484113.14521668083
Gcorr620 T224 T1255 T224 T1255 -4.1333308862616761e-07
Gcorr621 T224 T1256 T224 T1256 -4.0316909080725047e-07
Gcorr622 T224 T2058 T224 T2058 -4.0834034264983138e-07
Gcorr623 T224 T2198 T224 T2198 -4.1767297855210366e-07
Rt2097 T224 T2748 744150.8942920292
Rt2098 T224 T3648 749294.98195041937
Rt2099 T224 T4421 484113.1452167519
Gcorr624 T224 T4609 T224 T4609 -4.1333308862631261e-07
Gcorr625 T224 T4610 T224 T4610 -4.0316909080715444e-07
Gcorr626 T224 T5412 T224 T5412 -4.0834034264949336e-07
Gcorr627 T224 T5555 T224 T5555 -4.1767297855209264e-07
Rt2100 T225 T226 983660.56112636114
Rt2101 T225 T572 571851.33096409799
Rt2102 T225 T660 497553.56806611718
Gcorr628 T225 T1067 T225 T1067 -4.2355854993428236e-07
Rt2103 T225 T2058 2490713.1921846997
Rt2104 T225 T2198 2668534.3366829539
Rt2105 T225 T2254 15808431.865844818
Rt2106 T225 T3648 3800742.819042692
Rt2107 T225 T3756 1721514.6687298387
Gcorr629 T225 T4421 T225 T4421 -4.2355854993460138e-07
Rt2108 T225 T5412 2490713.192183834
Rt2109 T225 T5555 2668534.3366852677
Rt2110 T225 T5609 15808431.865719466
Rt2111 T226 T227 788287.68738876958
Rt2112 T226 T569 359766.27172700997
Rt2113 T226 T660 438778.92019829655
Gcorr630 T226 T1534 T226 T1534 -1.6862420965159963e-07
Gcorr631 T226 T1823 T226 T1823 -1.9380044329794087e-07
Gcorr632 T226 T2119 T226 T2119 -4.2903075493829541e-07
Rt2114 T226 T2254 910549.66286688147
Rt2115 T226 T2501 9162083.8549652137
Rt2116 T226 T2886 1966566.1423381092
Rt2117 T226 T3756 1179710.8977565558
Gcorr633 T226 T4888 T226 T4888 -1.6862420965146067e-07
Gcorr634 T226 T5178 T226 T5178 -1.9380044329807356e-07
Gcorr635 T226 T5476 T226 T5476 -4.2903075493863925e-07
Rt2118 T226 T5609 910549.66286725295
Rt2119 T226 T5855 9162083.8548995014
Rt2120 T227 T228 999905.3547161062
Rt2121 T227 T569 570166.34257877152
Rt2122 T227 T662 307348.66301838617
Gcorr636 T227 T1083 T227 T1083 -5.0059226010711103e-07
Rt2123 T227 T1534 2684695.2870848975
Rt2124 T227 T2244 1745154.8802727654
Gcorr637 T227 T2501 T227 T2501 -2.178721749832884e-08
Rt2125 T227 T2886 1797008.9770662975
Rt2126 T227 T3642 3664978.219029184
Gcorr638 T227 T4437 T227 T4437 -5.0059226010761257e-07
Rt2127 T227 T4888 2684695.2870880282
Rt2128 T227 T5599 1745154.8802683826
Gcorr639 T227 T5855 T227 T5855 -2.1787217498835042e-08
Rt2129 T228 T229 979126.40662727039
Rt2130 T228 T567 483930.19323862961
Rt2131 T228 T662 417919.33472396107
Gcorr640 T228 T1083 T228 T1083 -1.7759472346749553e-07
Gcorr641 T228 T1712 T228 T1712 -1.8140479106452084e-07
Rt2132 T228 T2022 2042229.9313959535
Rt2133 T228 T2244 3419317.7461787523
Rt2134 T228 T2743 1257997.9014810291
Rt2135 T228 T3642 1871895.8230508827
Gcorr642 T228 T4437 T228 T4437 -1.7759472346782752e-07
Gcorr643 T228 T5066 T228 T5066 -1.814047910638402e-07
Rt2136 T228 T5375 2042229.9313928601
Rt2137 T228 T5599 3419317.7461915328
Rt2138 T229 T230 790215.9771706427
Rt2139 T229 T567 508524.37192288175
Rt2140 T229 T658 566750.62792766141
Rt2141 T229 T1880 8586107.8557870742
Rt2142 T229 T2022 16260292.924931679
Rt2143 T229 T2700 4079125.1965914806
Rt2144 T229 T2743 1802266.810617974
Rt2145 T229 T3643 3641902.5128132827
Rt2146 T229 T5236 8586107.8557242621
Rt2147 T229 T5375 16260292.925084209
Rt2148 T229 T6054 4079125.1965961051
Rt2149 T230 T231 793202.50077384722
Rt2150 T230 T565 170313.44866117765
Rt2151 T230 T658 465398.14452151943
Rt2152 T230 T1880 19879245.62461723
Gcorr644 T230 T1881 T230 T1881 -1.9855748575969512e-07
Rt2153 T230 T2039 288018.59652029327
Gcorr645 T230 T2700 T230 T2700 -1.1871176220320672e-07
Gcorr646 T230 T2716 T230 T2716 -2.781915186145753e-06
Rt2154 T230 T3643 1759877.633650376
Rt2155 T230 T3649 1169473.3146098419
Rt2156 T230 T5236 19879245.624856561
Gcorr647 T230 T5237 T230 T5237 -1.9855748575915556e-07
Rt2157 T230 T5392 288018.59652526904
Gcorr648 T230 T6054 T230 T6054 -1.1871176220370127e-07
Gcorr649 T230 T6071 T230 T6071 -2.7819151860852139e-06
Rt2158 T231 T232 967081.50342097285
Rt2159 T231 T565 506149.77930417564
Rt2160 T231 T668 428524.55121594155
Gcorr650 T231 T1091 T231 T1091 -1.7888908696370295e-07
Gcorr651 T231 T2039 T231 T2039 -7.1012244763143796e-08
Rt2161 T231 T2110 1697640.8009628977
Rt2162 T231 T2716 11909598.352677345
Rt2163 T231 T2762 3404659.2062609396
Rt2164 T231 T3649 1613839.4762781335
Gcorr652 T231 T4445 T231 T4445 -1.7888908696405675e-07
Gcorr653 T231 T5392 T231 T5392 -7.1012244763752985e-08
Rt2165 T231 T5466 1697640.800959711
Rt2166 T231 T6071 11909598.352698008
Rt2167 T232 T233 646437.22614863189
Rt2168 T232 T562 569526.51694497
Rt2169 T232 T668 492019.4766372313
Rt2170 T232 T1093 2322174.3702155733
Gcorr654 T232 T1095 T232 T1095 -1.9465229627106153e-07
Rt2171 T232 T1096 8972808.9847633187
Rt2172 T232 T2110 13211626.123537246
Rt2173 T232 T2762 1879699.8561160699
Rt2174 T232 T3628 1859472.2086685214
Rt2175 T232 T4447 2322174.3702189559
Gcorr655 T232 T4449 T232 T4449 -1.9465229627056962e-07
Rt2176 T232 T4450 8972808.984712163
Rt2177 T232 T5466 13211626.12362501
Rt2178 T233 T234 626984.47619514691
Rt2179 T233 T562 492391.33400986699
Rt2180 T233 T661 491418.70534447528
Gcorr656 T233 T1093 T233 T1093 -1.6970638376014903e-07
Rt2181 T233 T1094 17536755.189138789
Rt2182 T233 T1095 1352363.4776735506
Gcorr657 T233 T1097 T233 T1097 -2.0364556583800771e-07
Rt2183 T233 T3628 3264100.8847247045
Rt2184 T233 T3650 3305912.2956925719
Gcorr658 T233 T4447 T233 T4447 -1.6970638376047387e-07
Rt2185 T233 T4448 17536755.189229492
Rt2186 T233 T4449 1352363.4776728607
Gcorr659 T233 T4451 T233 T4451 -2.0364556583776795e-07
Rt2187 T234 T235 646964.13416467991
Rt2188 T234 T560 565510.3446459932
Rt2189 T234 T661 567042.39128353226
Gcorr660 T234 T1095 T234 T1095 -2.0441310923895481e-07
Rt2190 T234 T1097 1447433.9335478472
Rt2191 T234 T1098 10911775.374579418
Gcorr661 T234 T1099 T234 T1099 -1.5499150902314854e-07
Rt2192 T234 T2747 1858922.5747127121
Rt2193 T234 T3650 1846745.4330574316
Gcorr662 T234 T4449 T234 T4449 -2.0441310923925646e-07
Rt2194 T234 T4451 1447433.9335485168
Rt2195 T234 T4452 10911775.374532858
Gcorr663 T234 T4453 T234 T4453 -1.5499150902292109e-07
Rt2196 T235 T236 775168.04415499361
Rt2197 T235 T560 493513.06868243869
Rt2198 T235 T657 496890.93215839961
Gcorr664 T235 T1097 T235 T1097 -2.0721089712627423e-07
Rt2199 T235 T1099 1446074.3199900256
Gcorr665 T235 T1101 T235 T1101 -2.2218482233872185e-07
Rt2200 T235 T1103 13142271.343003202
Rt2201 T235 T2262 11779215.352546196
Rt2202 T235 T2747 3495790.9813919892
Rt2203 T235 T3627 1163328.0039917713
Gcorr666 T235 T4451 T235 T4451 -2.0721089712670889e-07
Rt2204 T235 T4453 1446074.3199896696
Gcorr667 T235 T4455 T235 T4455 -2.2218482233821604e-07
Rt2205 T235 T4457 13142271.342987413
Rt2206 T235 T5617 11779215.35259279
Rt2207 T236 T237 780300.01233486843
Rt2208 T236 T557 436720.18531653681
Rt2209 T236 T657 568659.70518481289
Rt2210 T236 T1101 14996563.697412914
Rt2211 T236 T1103 2179993.8103436441
Rt2212 T236 T2031 12120618.036230221
Gcorr668 T236 T2209 T236 T2209 -1.8478556850276619e-07
Rt2213 T236 T2885 1802734.2424465758
Rt2214 T236 T3627 3299766.8156856177
Rt2215 T236 T4455 14996563.697372435
Rt2216 T236 T4457 2179993.8103461582
Rt2217 T236 T5384 12120618.036161063
Gcorr669 T236 T5565 T236 T5565 -1.8478556850289076e-07
Rt2218 T237 T238 1031794.0673990821
Rt2219 T237 T557 561647.99051233358
Rt2220 T237 T659 493751.3371489314
Gcorr670 T237 T1973 T237 T1973 -4.3538792002726018e-07
Rt2221 T237 T2031 2097748.1493879487
Rt2222 T237 T2032 3311385.4002635791
Rt2223 T237 T2209 15322463.012096358
Rt2224 T237 T2885 3835483.5910884808
Rt2225 T237 T3870 622829.51879356522
Gcorr671 T237 T5327 T237 T5327 -4.3538792002694074e-07
Rt2226 T237 T5384 2097748.1493881838
Rt2227 T237 T5385 3311385.4002597183
Rt2228 T237 T5565 15322463.012242129
Rt2229 T238 T239 784741.60639373562
Rt2230 T238 T555 436450.42347287771
Rt2231 T238 T659 570536.48585011391
Gcorr672 T238 T1500 T238 T1500 -1.6444218204103224e-07
Gcorr673 T238 T1973 T238 T1973 -1.4702736686189103e-07
Rt2232 T238 T2032 1721541.179394545
Rt2233 T238 T2188 7185948.331175453
Rt2234 T238 T2753 1954339.8992804871
Rt2235 T238 T3870 1085212.3874955189
Gcorr674 T238 T4854 T238 T4854 -1.6444218204084508e-07
Gcorr675 T238 T5327 T238 T5327 -1.4702736686189873e-07
Rt2236 T238 T5385 1721541.1793973146
Rt2237 T238 T5545 7185948.3311366038
Rt2238 T239 T555 612926.65881179378
Rt2239 T239 T841 231663.16213121256
Rt2240 T239 T1312 10838351.003342059
Rt2241 T239 T1500 9666879.9043259509
Rt2242 T239 T2188 7451539.2716660071
Rt2243 T239 T2753 7605739.9362247596
Rt2244 T239 T4189 994611.77665289899
Rt2245 T239 T4666 10838351.00328123
Rt2246 T239 T4854 9666879.9043587595
Rt2247 T239 T5545 7451539.2716753865
Rt2248 T240 T241 712518.03106662328
Rt2249 T240 T748 627751.4457291764
Rt2250 T240 T841 286996.36374012282
Gcorr676 T240 T1312 T240 T1312 -1.3879866077321946e-07
Rt2251 T240 T1313 3495188.9963657134
Rt2252 T240 T1314 3472770.144690691
Gcorr677 T240 T1315 T240 T1315 -1.4599203775394652e-07
Rt2253 T240 T2891 3419863.5727367187
Rt2254 T240 T3762 1520639.3839181541
Gcorr678 T240 T4666 T240 T4666 -1.3879866077325297e-07
Rt2255 T240 T4667 3495188.996355739
Rt2256 T240 T4668 3472770.1447015512
Gcorr679 T240 T4669 T240 T4669 -1.459920377538309e-07
Rt2257 T241 T242 719100.48477632343
Rt2258 T241 T581 471319.76903320552
Rt2259 T241 T748 563895.73904765211
Rt2260 T241 T1314 11188165.341390233
Rt2261 T241 T1315 3376319.8654835941
Gcorr680 T241 T1316 T241 T1316 -7.0168419779836958e-08
Rt2262 T241 T2824 3464606.0460474771
Rt2263 T241 T3762 3502729.8847738146
Rt2264 T241 T4668 11188165.341415493
Rt2265 T241 T4669 3376319.8654751577
Gcorr681 T241 T4670 T241 T4670 -7.0168419780377365e-08
Rt2266 T242 T581 627881.31984448945
Rt2267 T242 T843 285405.36389333406
Gcorr682 T242 T1315 T242 T1315 -1.302758404844894e-07
Rt2268 T242 T1316 3326163.6678776881
Rt2269 T242 T1317 3987028.1907116123
Gcorr683 T242 T1318 T242 T1318 -1.5310866452894449e-07
Rt2270 T242 T2824 1791235.1110740928
Rt2271 T242 T4193 2066394.9302997338
Gcorr684 T242 T4669 T242 T4669 -1.3027584048416533e-07
Rt2272 T242 T4670 3326163.6678822814
Rt2273 T242 T4671 3987028.190703202
Gcorr685 T242 T4672 T242 T4672 -1.5310866452938423e-07
Rt2274 T243 T244 836197.54470569058
Rt2275 T243 T770 607402.35311838298
Rt2276 T243 T843 227712.64469387196
Rt2277 T243 T1318 14046671.411733817
Rt2278 T243 T1321 6012812.9278962761
Rt2279 T243 T2137 8817917.2590551451
Rt2280 T243 T2868 1629638.7271084751
Rt2281 T243 T3755 3289941.4588671117
Rt2282 T243 T4672 14046671.411598003
Rt2283 T243 T4675 6012812.9279251369
Rt2284 T243 T5493 8817917.2590467781
Rt2285 T244 T245 969483.63538064132
Rt2286 T244 T527 618067.14289570518
Rt2287 T244 T770 391276.18860212382
Rt2288 T244 T1321 13638570.326250991
Gcorr686 T244 T1387 T244 T1387 -1.846875059183578e-07
Rt2289 T244 T1393 1467739.0251327748
Gcorr687 T244 T2137 T244 T2137 -1.6633061920221472e-07
Rt2290 T244 T2769 1213102.0372631114
Rt2291 T244 T3755 1665062.0634028341
Rt2292 T244 T4675 13638570.326149855
Gcorr688 T244 T4741 T244 T4741 -1.8468750591858317e-07
Rt2293 T244 T4747 1467739.0251347534
Gcorr689 T244 T5493 T244 T5493 -1.663306192016173e-07
Rt2294 T245 T246 478344.82206574793
Rt2295 T245 T527 497507.68088705814
Rt2296 T245 T674 570188.53532802314
Rt2297 T245 T1393 11911384.117210263
Rt2298 T245 T1526 2389032.8289342546
Rt2299 T245 T1527 2967560.7932961867
Gcorr690 T245 T1673 T245 T1673 -4.2030021141244998e-07
Rt2300 T245 T2769 1807890.8086138724
Rt2301 T245 T3652 3614800.7141338675
Rt2302 T245 T4747 11911384.117099583
Rt2303 T245 T4880 2389032.8289384446
Rt2304 T245 T4881 2967560.793295485
Gcorr691 T245 T5027 T245 T5027 -4.2030021141257826e-07
Rt2305 T246 T247 1061989.8440089154
Rt2306 T246 T529 559020.0122096889
Rt2307 T246 T674 433136.0904296753
Gcorr692 T246 T1526 T246 T1526 -1.8137492884815587e-07
Gcorr693 T246 T1527 T246 T1527 -4.2068164245458337e-07
Rt2308 T246 T1673 897135.48416342435
Gcorr694 T246 T1842 T246 T1842 -1.2787779088769652e-07
Rt2309 T246 T3652 1823226.6496085953
Rt2310 T246 T4114 919481.07286761259
Gcorr695 T246 T4880 T246 T4880 -1.8137492884763619e-07
Gcorr696 T246 T4881 T246 T4881 -4.2068164245429977e-07
Rt2311 T246 T5027 897135.48416386219
Gcorr697 T246 T5197 T246 T5197 -1.2787779088795844e-07
Rt2312 T247 T248 578181.78784167673
Rt2313 T247 T529 497861.78792812699
Rt2314 T247 T684 491639.60780113994
Gcorr698 T247 T1673 T247 T1673 -2.1735371927456292e-10
Rt2315 T247 T1702 7496970.4524779357
Gcorr699 T247 T2002 T247 T2002 -2.3610895858274905e-07
Rt2316 T247 T2125 2050593.9833732492
Rt2317 T247 T2768 4054448.8153991881
Rt2318 T247 T4114 1187378.2521271254
Gcorr700 T247 T5027 T247 T5027 -2.1735371867805734e-10
Rt2319 T247 T5056 7496970.4524608077
Gcorr701 T247 T5354 T247 T5354 -2.3610895858272502e-07
Rt2320 T247 T5481 2050593.9833771505
Rt2321 T248 T249 472576.67060338677
Rt2322 T248 T531 441424.74125109636
Rt2323 T248 T684 553510.2153630408
Gcorr702 T248 T1463 T248 T1463 -4.245201706444183e-07
Gcorr703 T248 T2001 T248 T2001 -4.1158917861777292e-07
Rt2324 T248 T2002 473671.16577706404
Gcorr704 T248 T2125 T248 T2125 -4.340809810782138e-07
Gcorr705 T248 T2189 T248 T2189 -4.2176931193409702e-07
Rt2325 T248 T2768 699564.17398163769
Rt2326 T248 T3659 748214.54926638317
Gcorr706 T248 T4817 T248 T4817 -4.2452017064439061e-07
Gcorr707 T248 T5353 T248 T5353 -4.1158917861799199e-07
Rt2327 T248 T5354 473671.16577709321
Gcorr708 T248 T5481 T248 T5481 -4.3408098107779684e-07
Gcorr709 T248 T5546 T248 T5546 -4.2176931193419516e-07
Rt2328 T249 T250 961403.43240310135
Rt2329 T249 T531 571784.18506668613
Rt2330 T249 T688 497021.08429461252
Rt2331 T249 T2001 2776257.2991282591
Gcorr710 T249 T2002 T249 T2002 -4.2079143139949854e-07
Rt2332 T249 T2098 14550508.048247878
Rt2333 T249 T2189 2432629.8075040551
Rt2334 T249 T3654 1868155.4364338026
Rt2335 T249 T3659 3660710.1992114303
Rt2336 T249 T5353 2776257.2991289706
Gcorr711 T249 T5354 T249 T5354 -4.2079143139947397e-07
Rt2337 T249 T5451 14550508.048359809
Rt2338 T249 T5546 2432629.8075005421
Rt2339 T250 T251 773318.35165344691
Rt2340 T250 T533 488950.31452010712
Rt2341 T250 T688 437954.75217361626
Rt2342 T250 T1285 19300921.77191266
Gcorr712 T250 T1287 T250 T1287 -1.8621541023420975e-07
Gcorr713 T250 T1291 T250 T1291 -4.3010541350375354e-07
Rt2343 T250 T2098 851692.48823892116
Gcorr714 T250 T2162 T250 T2162 -1.904132641910805e-07
Rt2344 T250 T2767 734654.51666915102
Rt2345 T250 T3654 1162417.383689706
Rt2346 T250 T4639 19300921.772094738
Gcorr715 T250 T4641 T250 T4641 -1.8621541023459034e-07
Gcorr716 T250 T4644 T250 T4644 -4.3010541350375317e-07
Rt2347 T250 T5451 851692.48823845072
Gcorr717 T250 T5518 T250 T5518 -1.9041326419086271e-07
Rt2348 T251 T252 1139806.685431103
Rt2349 T251 T533 570574.02160516905
Rt2350 T251 T676 490821.07889662671
Rt2351 T251 T1285 6043865.9794023922
Rt2352 T251 T1286 11863990.812587896
Rt2353 T251 T1287 7729400.3229639959
Rt2354 T251 T2767 3940594.1185807735
Rt2355 T251 T4172 1085800.8768706762
Rt2356 T251 T4639 6043865.9793771254
Rt2357 T251 T4640 11863990.812664488
Rt2358 T251 T4641 7729400.3229729626
Rt2359 T252 T253 786418.97211764939
Rt2360 T252 T534 496533.25530269119
Rt2361 T252 T676 437257.46611829114
Gcorr718 T252 T1089 T252 T1089 -1.8951344381369013e-07
Rt2362 T252 T1286 2717203.0287243766
Rt2363 T252 T1696 11756374.084974049
Rt2364 T252 T2111 8654297.5454586335
Rt2365 T252 T3655 3749583.7942220694
Rt2366 T252 T4172 1083516.7570768781
Gcorr719 T252 T4443 T252 T4443 -1.8951344381334293e-07
Rt2367 T252 T4640 2717203.028721218
Rt2368 T252 T5050 11756374.085034659
Rt2369 T252 T5465 8654297.5454840288
Rt2370 T253 T254 987299.15152325958
Rt2371 T253 T534 571118.95760452712
Rt2372 T253 T682 353834.61301110918
Gcorr720 T253 T1085 T253 T1085 -4.1196631791225251e-07
Rt2373 T253 T1696 13629595.39048722
Rt2374 T253 T2111 2919587.678661678
Rt2375 T253 T2112 2407943.9530579373
Rt2376 T253 T2766 1843057.062784527
Rt2377 T253 T3655 3350278.3310348657
Gcorr721 T253 T4439 T253 T4439 -4.1196631791203196e-07
Rt2378 T253 T5050 13629595.390502723
Rt2379 T253 T5465 2919587.6786552165
Rt2380 T253 T5473 2407943.9530631434
Rt2381 T254 T255 729594.64337624633
Rt2382 T254 T536 571288.8531975348
Rt2383 T254 T682 353957.261364559
Gcorr722 T254 T1085 T254 T1085 -4.158949987301897e-07
Rt2384 T254 T2112 2820493.2188349376
Rt2385 T254 T2113 2511601.6778311911
Rt2386 T254 T2114 8656187.2330086697
Rt2387 T254 T2766 1637570.1435421184
Rt2388 T254 T3557 7676241.1624689773
Gcorr723 T254 T4439 T254 T4439 -4.1589499872981648e-07
Rt2389 T254 T5464 2511601.6778346379
Rt2390 T254 T5473 2820493.2188294819
Rt2391 T254 T5474 8656187.2330473047
Rt2392 T255 T256 978797.33641853684
Rt2393 T255 T536 496533.84443466138
Rt2394 T255 T675 427923.85213310993
Gcorr724 T255 T1080 T255 T1080 -1.841516583226219e-07
Rt2395 T255 T1294 1550627.6574962744
Rt2396 T255 T2113 9988589.8912197445
Gcorr725 T255 T2114 T255 T2114 -1.1626067986264315e-07
Rt2397 T255 T3557 1895762.1326689492
Rt2398 T255 T3675 2945207.5007538032
Gcorr726 T255 T4434 T255 T4434 -1.8415165832251076e-07
Rt2399 T255 T4648 1550627.6574983338
Rt2400 T255 T5464 9988589.8911630027
Gcorr727 T255 T5474 T255 T5474 -1.1626067986246968e-07
Rt2401 T256 T257 645979.47569227207
Rt2402 T256 T538 568838.55719369918
Rt2403 T256 T675 352407.6289138358
Rt2404 T256 T1079 1472554.4170592863
Gcorr728 T256 T1080 T256 T1080 -4.3206010944802123e-07
Rt2405 T256 T1294 3395852.742460337
Rt2406 T256 T1295 11627957.467974532
Gcorr729 T256 T2311 T256 T2311 -2.0976216154152754e-07
Rt2407 T256 T2765 1835083.7140000944
Rt2408 T256 T3675 1833146.7894839081
Rt2409 T256 T4433 1472554.4170591861
Gcorr730 T256 T4434 T256 T4434 -4.3206010944765881e-07
Rt2410 T256 T4648 3395852.7424565065
Rt2411 T256 T4649 11627957.468026681
Gcorr731 T256 T5665 T256 T5665 -2.0976216154188554e-07
Rt2412 T257 T258 583250.40065197146
Rt2413 T257 T538 494737.2990189541
Rt2414 T257 T683 492266.42851062142
Rt2415 T257 T1069 15305101.362221153
Gcorr732 T257 T1079 T257 T1079 -1.695037176136248e-07
Gcorr733 T257 T2131 T257 T2131 -2.3915243035370587e-07
Rt2416 T257 T2311 1276144.2115299497
Rt2417 T257 T2765 2836360.5901103858
Rt2418 T257 T3623 4823588.9689367069
Rt2419 T257 T4423 15305101.362145854
Gcorr734 T257 T4433 T257 T4433 -1.6950371761320075e-07
Gcorr735 T257 T5487 T257 T5487 -2.3915243035395876e-07
Rt2420 T257 T5665 1276144.2115307567
Rt2421 T258 T259 648395.49147898436
Rt2422 T258 T540 564058.19165792759
Rt2423 T258 T683 563888.78997228877
Gcorr736 T258 T1597 T258 T1597 -1.8270171729618127e-07
Rt2424 T258 T2131 1383822.5484176727
Gcorr737 T258 T2311 T258 T2311 -2.1700368277496851e-07
Rt2425 T258 T2397 8842842.4131599404
Rt2426 T258 T3623 2351975.1783987046
Rt2427 T258 T3667 1792022.8804676083
Gcorr738 T258 T4951 T258 T4951 -1.8270171729661521e-07
Rt2428 T258 T5487 1383822.5484169351
Gcorr739 T258 T5665 T258 T5665 -2.1700368277471011e-07
Rt2429 T258 T5752 8842842.4131765589
Rt2430 T259 T260 962216.41929885407
Rt2431 T259 T540 494098.79242278915
Rt2432 T259 T681 496463.6569472471
Rt2433 T259 T1058 16174912.853736755
Rt2434 T259 T1060 10865384.178232005
Rt2435 T259 T1597 2203215.9826166518
Gcorr740 T259 T2131 T259 T2131 -1.8964958414953163e-07
Rt2436 T259 T2764 1788946.8901185133
Rt2437 T259 T3667 3439597.4483192731
Rt2438 T259 T4412 16174912.853865854
Rt2439 T259 T4414 10865384.178188445
Rt2440 T259 T4951 2203215.9826178895
Gcorr741 T259 T5487 T259 T5487 -1.8964958414915507e-07
Rt2441 T260 T612 436817.74983862467
Rt2442 T260 T681 566072.92095089506
Rt2443 T260 T1056 13939356.724540276
Gcorr742 T260 T1057 T260 T1057 -1.885787988264305e-07
Rt2444 T260 T1058 1408384.6734500153
Gcorr743 T260 T2135 T260 T2135 -2.1161133603984374e-07
Rt2445 T260 T2764 1362387.5072407711
Rt2446 T260 T4171 1090826.8191492117
Rt2447 T260 T4410 13939356.724669283
Gcorr744 T260 T4411 T260 T4411 -1.8857879882653186e-07
Rt2448 T260 T4412 1408384.6734481417
Gcorr745 T260 T5491 T260 T5491 -2.1161133604002567e-07
Rt2449 T261 T262 848415.21308903513
Rt2450 T261 T765 663253.16848843556
Rt2451 T261 T831 344887.92464663967
Rt2452 T261 T1053 16962109.987679914
Gcorr746 T261 T1054 T261 T1054 -5.6643748651007315e-08
Rt2453 T261 T1055 2649932.8420608137
Rt2454 T261 T3216 3603614.7215116913
Rt2455 T261 T3660 3605811.6059872862
Rt2456 T261 T4407 16962109.987779398
Gcorr747 T261 T4408 T261 T4408 -5.6643748650653427e-08
Rt2457 T261 T4409 2649932.8420608891
Rt2458 T262 T634 455951.52300057933
Rt2459 T262 T765 505109.05375677417
Rt2460 T262 T1053 4234112.8603006359
Gcorr748 T262 T1055 T262 T1055 -1.4009817507643685e-07
Rt2461 T262 T1241 1581922.8745740335
Rt2462 T262 T2308 11965569.613232901
Gcorr749 T262 T2689 T262 T2689 -4.1855370581636066e-07
Rt2463 T262 T2785 3159496.4245876572
Rt2464 T262 T3660 1697676.067291602
Rt2465 T262 T4407 4234112.8602940105
Gcorr750 T262 T4409 T262 T4409 -1.4009817507602543e-07
Rt2466 T262 T4595 1581922.8745758904
Rt2467 T262 T5662 11965569.613264654
Gcorr751 T262 T6043 T262 T6043 -4.1855370581618051e-07
Rt2468 T263 T264 691276.09205544309
Rt2469 T263 T622 509593.81983463041
Rt2470 T263 T822 450155.44443187839
Gcorr752 T263 T1884 T263 T1884 -1.5787983590453348e-07
Rt2471 T263 T1885 3423245.6594007676
Gcorr753 T263 T1958 T263 T1958 -2.1499434833353692e-07
Rt2472 T263 T2582 1789006.2373268257
Gcorr754 T263 T2689 T263 T2689 -1.4483653974260155e-07
Rt2473 T263 T2819 2541595.3821006767
Rt2474 T263 T3543 1668092.5310290356
Gcorr755 T263 T5241 T263 T5241 -1.5787983590485689e-07
Rt2475 T263 T5242 3423245.6593949492
Gcorr756 T263 T5312 T263 T5312 -2.1499434833321357e-07
Rt2476 T263 T5936 1789006.2373293177
Gcorr757 T263 T6043 T263 T6043 -1.4483653974232177e-07
Rt2477 T264 T265 704309.88559828105
Rt2478 T264 T622 560098.58498890267
Rt2479 T264 T745 483588.92880616937
Rt2480 T264 T1884 2361416.9071022142
Gcorr758 T264 T2380 T264 T2380 -1.3566964193256328e-07
Rt2481 T264 T2460 5422288.2312524617
Gcorr759 T264 T2582 T264 T2582 -1.5659991821025391e-07
Rt2482 T264 T2819 1670098.6185871046
Rt2483 T264 T3760 3201408.856546863
Rt2484 T264 T5241 2361416.9070999241
Gcorr760 T264 T5734 T264 T5734 -1.3566964193302759e-07
Rt2485 T264 T5814 5422288.231257705
Gcorr761 T264 T5936 T264 T5936 -1.565999182100241e-07
Rt2486 T265 T745 390671.45989334013
Rt2487 T265 T826 359858.54022909683
Gcorr762 T265 T1762 T265 T1762 -4.8216655228770249e-07
Rt2488 T265 T2380 710616.3858833327
Gcorr763 T265 T2460 T265 T2460 -6.2331830748056144e-07
Rt2489 T265 T3398 2904983.0442731692
Rt2490 T265 T3760 683986.92532917357
Gcorr764 T265 T5117 T265 T5117 -4.8216655228817249e-07
Rt2491 T265 T5734 710616.38588319509
Gcorr765 T265 T5814 T265 T5814 -6.2331830748036599e-07
Rt2492 T266 T267 711493.89347548352
Rt2493 T266 T589 424784.88898429385
Rt2494 T266 T723 570038.06241439772
Rt2495 T266 T1427 15000504.030552089
Rt2496 T266 T1508 2977630.5936112744
Gcorr766 T266 T1998 T266 T1998 -1.71781481412544e-07
Rt2497 T266 T2312 7858151.4432134554
Rt2498 T266 T2838 1531598.4987574036
Rt2499 T266 T3716 6499866.451974663
Rt2500 T266 T4781 15000504.030625464
Rt2501 T266 T4862 2977630.5936114821
Gcorr767 T266 T5350 T266 T5350 -1.7178148141235765e-07
Rt2502 T266 T5666 7858151.4432035303
Rt2503 T267 T268 1010340.632292648
Rt2504 T267 T723 489033.86359167704
Rt2505 T267 T736 419453.00864594581
Rt2506 T267 T1425 1841757.0985766684
Gcorr768 T267 T1427 T267 T1427 -1.2972267866748168e-07
Rt2507 T267 T1508 9518197.9769986272
Gcorr769 T267 T2212 T267 T2212 -1.754215772912288e-07
Rt2508 T267 T3716 1645905.6045137197
Rt2509 T267 T3860 2743554.8413559627
Rt2510 T267 T4779 1841757.0985783797
Gcorr770 T267 T4781 T267 T4781 -1.297226786674077e-07
Rt2511 T267 T4862 9518197.9769535307
Gcorr771 T267 T5568 T267 T5568 -1.754215772912983e-07
Rt2512 T268 T736 352735.31756447669
Rt2513 T268 T818 450668.93725980516
Rt2514 T268 T1423 2829659.5528573259
Rt2515 T268 T1424 23069798.94555654
Rt2516 T268 T1425 3074580.4023509328
Gcorr772 T268 T2212 T268 T2212 -4.0944264301089517e-07
Rt2517 T268 T2842 3061440.451335662
Rt2518 T268 T3860 1595445.0829899388
Rt2519 T268 T4777 2829659.5528585254
Rt2520 T268 T4778 23069798.945708971
Rt2521 T268 T4779 3074580.4023485268
Gcorr773 T268 T5568 T268 T5568 -4.0944264301071555e-07
Rt2522 T269 T270 1015457.6907801065
Rt2523 T269 T580 435548.76227670867
Rt2524 T269 T759 469590.67384325049
Gcorr774 T269 T1419 T269 T1419 -1.5958962251052597e-07
Rt2525 T269 T1420 3005078.3686635857
Rt2526 T269 T1421 3207524.8439510642
Gcorr775 T269 T1422 T269 T1422 -1.5899851954864519e-07
Rt2527 T269 T2843 1138527.4975612115
Rt2528 T269 T3752 2140278.521665195
Gcorr776 T269 T4773 T269 T4773 -1.5958962251007725e-07
Rt2529 T269 T4774 3005078.3686677958
Rt2530 T269 T4775 3207524.843948666
Gcorr777 T269 T4776 T269 T4776 -1.5899851954886293e-07
Rt2531 T270 T271 755414.35612516652
Rt2532 T270 T587 438164.29396965908
Rt2533 T270 T759 546065.91168925131
Rt2534 T270 T1420 1664068.0123914294
Gcorr778 T270 T1422 T270 T1422 -4.4047753715411754e-07
Rt2535 T270 T1456 3467405.2261175397
Gcorr779 T270 T2179 T270 T2179 -1.3642448832793754e-07
Rt2536 T270 T2843 638860.31594946305
Rt2537 T270 T3774 3358339.2594880466
Rt2538 T270 T4774 1664068.0123908997
Gcorr780 T270 T4776 T270 T4776 -4.4047753715405475e-07
Rt2539 T270 T4810 3467405.2261220147
Gcorr781 T270 T5536 T270 T5536 -1.3642448832782152e-07
Rt2540 T271 T272 1005380.0047070513
Rt2541 T271 T587 565161.61395131482
Rt2542 T271 T757 468585.36542106711
Rt2543 T271 T1456 9783281.066586718
Rt2544 T271 T1801 7544345.2082293564
Rt2545 T271 T2179 12839895.244110471
Rt2546 T271 T3766 1647825.2469515745
Rt2547 T271 T3774 3352301.3808621117
Rt2548 T271 T4810 9783281.066582635
Rt2549 T271 T5156 7544345.2082545226
Rt2550 T271 T5536 12839895.24404496
Rt2551 T272 T592 309495.33838074142
Rt2552 T272 T757 430183.19827355776
Rt2553 T272 T1801 913396.78471416095
Gcorr782 T272 T2045 T272 T2045 -1.6857728588019989e-07
Gcorr783 T272 T2221 T272 T2221 -4.8817929722675539e-07
Gcorr784 T272 T2296 T272 T2296 -1.2706485479632583e-07
Rt2554 T272 T2846 1000925.8062444037
Rt2555 T272 T3766 3335063.4589004545
Rt2556 T272 T5156 913396.78471463127
Gcorr785 T272 T5399 T272 T5399 -1.6857728588027832e-07
Gcorr786 T272 T5577 T272 T5577 -4.881792972260118e-07
Gcorr787 T272 T5650 T272 T5650 -1.2706485479642962e-07
Rt2557 T273 T583 478064.07963744045
Rt2558 T273 T769 417609.20478453452
Rt2559 T273 T1803 1295989.9453817664
Gcorr788 T273 T2354 T273 T2354 -3.2830262243557031e-07
Gcorr789 T273 T2355 T273 T2355 -1.440630867857376e-07
Rt2560 T273 T3545 3120134.445999586
Rt2561 T273 T3788 3285175.1001805402
Rt2562 T273 T5158 1295989.945381236
Gcorr790 T273 T5707 T273 T5707 -3.2830262243586699e-07
Gcorr791 T273 T5708 T273 T5708 -1.4406308678575862e-07
Rt2563 T274 T275 1199226.7307304374
Rt2564 T274 T758 433347.01857316424
Rt2565 T274 T791 438037.86975014344
Rt2566 T274 T1753 28904097.619633377
Rt2567 T274 T2064 2760068.6754943458
Gcorr792 T274 T2354 T274 T2354 -1.8733707317028558e-07
Rt2568 T274 T2437 6444304.6533329086
Rt2569 T274 T2861 3162769.9146301583
Rt2570 T274 T3671 1849301.3934822048
Rt2571 T274 T5107 28904097.620062225
Rt2572 T274 T5418 2760068.6754924506
Gcorr793 T274 T5707 T274 T5707 -1.8733707317014285e-07
Rt2573 T274 T5791 6444304.6533279521
Rt2574 T275 T276 758729.62345742271
Rt2575 T275 T690 385881.06922180345
Rt2576 T275 T791 384956.8699544702
Gcorr794 T275 T1719 T275 T1719 -4.4735180588064642e-07
Gcorr795 T275 T1721 T275 T1721 -2.4274353645369163e-07
Rt2577 T275 T1753 621364.23323994468
Gcorr796 T275 T2210 T275 T2210 -1.4729363781470355e-07
Gcorr797 T275 T2499 T275 T2499 -3.8802921429446716e-07
Rt2578 T275 T2872 702676.588460017
Rt2579 T275 T3671 999103.29618835065
Gcorr798 T275 T5073 T275 T5073 -4.4735180588061423e-07
Gcorr799 T275 T5075 T275 T5075 -2.4274353645417603e-07
Rt2580 T275 T5107 621364.23323977424
Gcorr800 T275 T5566 T275 T5566 -1.472936378150078e-07
Gcorr801 T275 T5853 T275 T5853 -3.8802921429415487e-07
Rt2581 T276 T277 1198335.3520795207
Rt2582 T276 T690 597330.12599502504
Rt2583 T276 T785 421921.71917862509
Rt2584 T276 T1721 9640556.1046803296
Rt2585 T276 T1723 11289231.687829323
Rt2586 T276 T2210 5182911.9449224006
Rt2587 T276 T2872 3456834.115535764
Rt2588 T276 T3673 1834119.7737037383
Rt2589 T276 T5075 9640556.1046753135
Rt2590 T276 T5077 11289231.687890911
Rt2591 T276 T5566 5182911.9449109398
Rt2592 T277 T645 484499.43357251288
Rt2593 T277 T785 393196.66381668218
Rt2594 T277 T1723 1512309.6320062631
Gcorr802 T277 T1724 T277 T1724 -2.4292295383032747e-07
Rt2595 T277 T1725 10605510.103628017
Gcorr803 T277 T2159 T277 T2159 -1.3520086137735987e-07
Rt2596 T277 T2859 993188.32204557885
Rt2597 T277 T3673 3562334.1536536026
Rt2598 T277 T5077 1512309.6320055551
Gcorr804 T277 T5078 T277 T5078 -2.4292295383024017e-07
Rt2599 T277 T5079 10605510.10368452
Gcorr805 T277 T5515 T277 T5515 -1.3520086137725703e-07
Rt2600 T278 T279 968016.99877972656
Rt2601 T278 T652 502747.53254690004
Rt2602 T278 T805 484576.60827639536
Rt2603 T278 T1726 8432190.2483093124
Rt2604 T278 T1750 10532249.098740447
Rt2605 T278 T2232 9261962.1484342031
Rt2606 T278 T3741 1732024.1139263171
Rt2607 T278 T3849 3015623.5763151217
Rt2608 T278 T5080 8432190.2482938264
Rt2609 T278 T5104 10532249.098725025
Rt2610 T278 T5587 9261962.1484650001
Rt2611 T279 T280 948168.9124229477
Rt2612 T279 T652 468557.53883763967
Rt2613 T279 T715 486213.11122200772
Gcorr806 T279 T1731 T279 T1731 -4.4346818246621721e-07
Gcorr807 T279 T2037 T279 T2037 -9.0280114465350652e-08
Rt2614 T279 T2232 1528681.2235754058
Rt2615 T279 T2426 4654851.8425994171
Rt2616 T279 T2825 656701.69381431339
Rt2617 T279 T3741 3371572.2403701204
Gcorr808 T279 T5085 T279 T5085 -4.4346818246609302e-07
Gcorr809 T279 T5390 T279 T5390 -9.0280114465184461e-08
Rt2618 T279 T5587 1528681.2235750163
Rt2619 T279 T5779 4654851.8426093645
Rt2620 T280 T715 651476.32996732101
Rt2621 T280 T829 364873.39096136962
Gcorr810 T280 T1731 T280 T1731 -4.2259022910758283e-07
Gcorr811 T280 T1733 T280 T1733 -1.3948257420866249e-07
Gcorr812 T280 T1745 T280 T1745 -4.0751632659314091e-07
Rt2622 T280 T2426 773123.83085992723
Rt2623 T280 T2825 746946.93264069885
Rt2624 T280 T3685 1688399.7095850704
Gcorr813 T280 T5085 T280 T5085 -4.2259022910749633e-07
Gcorr814 T280 T5087 T280 T5087 -1.3948257420898587e-07
Gcorr815 T280 T5099 T280 T5099 -4.0751632659310862e-07
Rt2625 T280 T5779 773123.83085980627
Rt2626 T281 T282 745079.41357026843
Rt2627 T281 T564 464972.79134665953
Rt2628 T281 T762 555049.74686284258
Rt2629 T281 T1735 2738598.7676917869
Gcorr816 T281 T1737 T281 T1737 -1.5573662858630651e-07
Gcorr817 T281 T1745 T281 T1745 -1.4153422668458847e-07
Rt2630 T281 T2168 5130875.2490000613
Rt2631 T281 T2794 3701288.2080137641
Rt2632 T281 T4195 1011928.1121204423
Rt2633 T281 T5089 2738598.7676917482
Gcorr818 T281 T5091 T281 T5091 -1.5573662858651556e-07
Gcorr819 T281 T5099 T281 T5099 -1.4153422668437621e-07
Rt2634 T281 T5524 5130875.2490003295
Rt2635 T282 T283 991233.79013401223
Rt2636 T282 T600 247412.6494751017
Rt2637 T282 T762 226119.65631735817
Rt2638 T282 T1737 467290.31641074317
Gcorr820 T282 T1752 T282 T1752 -9.4711679107557083e-07
Gcorr821 T282 T2168 T282 T2168 -9.4209360523392513e-07
Rt2639 T282 T4019 2657111.5356014166
Rt2640 T282 T4195 1969415.2017879151
Rt2641 T282 T5091 467290.31641075085
Gcorr822 T282 T5106 T282 T5106 -9.4711679107568603e-07
Gcorr823 T282 T5524 T282 T5524 -9.4209360523377711e-07
Rt2642 T283 T600 485339.73519084015
Rt2643 T283 T833 344088.00453958858
Rt2644 T283 T1737 45300141.386161759
Gcorr824 T283 T1738 T283 T1738 -6.5400067250988515e-07
Rt2645 T283 T1742 990095.29493545531
Gcorr825 T283 T1752 T283 T1752 -1.2084382758675211e-07
Rt2646 T283 T2793 1445167.5671752326
Rt2647 T283 T4019 386379.54765064229
Rt2648 T283 T5091 45300141.385517314
Gcorr826 T283 T5092 T283 T5092 -6.5400067251024503e-07
Rt2649 T283 T5096 990095.29493554123
Gcorr827 T283 T5106 T283 T5106 -1.2084382758662024e-07
Rt2650 T284 T285 945720.78460998449
Rt2651 T284 T586 467986.50126736815
Rt2652 T284 T755 458126.49018591299
Rt2653 T284 T1775 2774898.2266147733
Gcorr828 T284 T1776 T284 T1776 -1.2791578117231222e-07
Rt2654 T284 T2070 5200204.921237709
Gcorr829 T284 T2382 T284 T2382 -1.0603073763728991e-07
Rt2655 T284 T2792 1408237.9226990019
Rt2656 T284 T3663 2117253.9233611701
Rt2657 T284 T5129 2774898.226610471
Gcorr830 T284 T5130 T284 T5130 -1.2791578117230777e-07
Rt2658 T284 T5424 5200204.9212521724
Gcorr831 T284 T5736 T284 T5736 -1.0603073763732048e-07
Rt2659 T285 T286 597746.44106356474
Rt2660 T285 T755 553638.94969460624
Rt2661 T285 T768 425120.61130417377
Rt2662 T285 T2070 1416127.1290173752
Gcorr832 T285 T2470 T285 T2470 -4.0962680206794389e-07
Rt2663 T285 T2792 3162901.0618618345
Rt2664 T285 T3797 2957827.4914010367
Rt2665 T285 T5424 1416127.1290167428
Gcorr833 T285 T5824 T285 T5824 -4.0962680206826116e-07
Rt2666 T286 T591 491796.18745184614
Rt2667 T286 T768 544885.18628667947
Rt2668 T286 T1302 15454520.884217467
Gcorr834 T286 T1304 T286 T1304 -1.7299916947697296e-07
Gcorr835 T286 T2070 T286 T2070 -4.52307315466787e-07
Rt2669 T286 T2470 1166690.988538567
Rt2670 T286 T3255 1653213.6077858321
Rt2671 T286 T3797 715997.80245471711
Rt2672 T286 T4656 15454520.884191519
Gcorr836 T286 T4658 T286 T4658 -1.729991694777426e-07
Gcorr837 T286 T5424 T286 T5424 -4.5230731546670854e-07
Rt2673 T286 T5824 1166690.9885377767
Rt2674 T287 T288 631147.16442546248
Rt2675 T287 T792 628302.14318169188
Rt2676 T287 T838 444194.47621492634
Gcorr838 T287 T1073 T287 T1073 -1.2871000648034703e-07
Rt2677 T287 T1300 1608120.3602839003
Rt2678 T287 T1301 3706733.0541298729
Gcorr839 T287 T1302 T287 T1302 -4.4656341921966239e-07
Rt2679 T287 T2782 2315829.4767992278
Rt2680 T287 T3587 3018024.2838973827
Gcorr840 T287 T4427 T287 T4427 -1.2871000648021158e-07
Rt2681 T287 T4654 1608120.3602836134
Rt2682 T287 T4655 3706733.0541326115
Gcorr841 T287 T4656 T287 T4656 -4.4656341921971141e-07
Rt2683 T288 T289 561302.8525177124
Rt2684 T288 T595 488147.11298852618
Rt2685 T288 T792 440900.84171688266
Rt2686 T288 T990 17058886.03782852
Gcorr842 T288 T1072 T288 T1072 -2.5243316599685808e-07
Rt2687 T288 T1073 1510174.4432758461
Gcorr843 T288 T1300 T288 T1300 -1.7223056879779412e-07
Rt2688 T288 T3587 5575269.9464944471
Rt2689 T288 T4009 2270132.6488350946
Rt2690 T288 T4344 17058886.037797533
Gcorr844 T288 T4426 T288 T4426 -2.5243316599641169e-07
Rt2691 T288 T4427 1510174.4432769855
Gcorr845 T288 T4654 T288 T4654 -1.7223056879784923e-07
Rt2692 T289 T595 557371.46785430727
Rt2693 T289 T750 548557.39585949341
Rt2694 T289 T1072 901477.5806377352
Gcorr846 T289 T1073 T289 T1073 -4.5977040891053987e-07
Gcorr847 T289 T2636 T289 T2636 -3.6526753067632439e-07
Rt2695 T289 T2783 1205439.4924590418
Rt2696 T289 T4009 665988.23485571612
Rt2697 T289 T4426 901477.58063773136
Gcorr848 T289 T4427 T289 T4427 -4.5977040891045744e-07
Gcorr849 T289 T5990 T289 T5990 -3.6526753067641375e-07
Rt2698 T290 T291 702701.53811579198
Rt2699 T290 T546 602644.12349617202
Rt2700 T290 T834 337668.69738654944
Gcorr850 T290 T1233 T290 T1233 -1.0904230272862128e-07
Gcorr851 T290 T1234 T290 T1234 -9.6153232974533699e-07
Rt2701 T290 T1235 753957.44707533461
Rt2702 T290 T1517 22697535.017620761
Rt2703 T290 T3340 1992267.3842881706
Rt2704 T290 T3812 3074067.1888104952
Gcorr852 T290 T4587 T290 T4587 -1.0904230272868287e-07
Gcorr853 T290 T4588 T290 T4588 -9.6153232974619461e-07
Rt2705 T290 T4589 753957.44707487221
Rt2706 T290 T4871 22697535.017567329
Rt2707 T291 T292 2371196.918730136
Rt2708 T291 T546 616722.58949510171
Rt2709 T291 T844 306696.91050924791
Gcorr854 T291 T1235 T291 T1235 -8.7364637015209689e-08
Rt2710 T291 T1517 12771521.237233857
Rt2711 T291 T2097 3480043.5833400749
Rt2712 T291 T2784 2910689.0628410145
Rt2713 T291 T3812 1750961.1847623643
Gcorr855 T291 T4589 T291 T4589 -8.7364637015459273e-08
Rt2714 T291 T4871 12771521.237222793
Rt2715 T291 T5450 3480043.5833378974
Rt2716 T292 T823 418021.39347616868
Rt2717 T292 T844 314108.97386758524
Gcorr856 T292 T1337 T292 T1337 -7.8023864204557276e-07
Rt2718 T292 T1683 4276435.3011230631
Gcorr857 T292 T2091 T292 T2091 -8.4559816451302786e-08
Rt2719 T292 T2097 1131023.2412178966
Rt2720 T292 T2784 3461102.662264334
Rt2721 T292 T3815 400165.41693498538
Gcorr858 T292 T4691 T292 T4691 -7.8023864204929081e-07
Rt2722 T292 T5037 4276435.3011220209
Gcorr859 T292 T5444 T292 T5444 -8.4559816451278222e-08
Rt2723 T292 T5450 1131023.2412132469
Rt2724 T293 T294 482789.23898984288
Rt2725 T293 T630 521096.63181298564
Rt2726 T293 T717 464247.86769597756
Rt2727 T293 T1773 1141472.199480992
Gcorr860 T293 T2347 T293 T2347 -5.5347527419827682e-07
Rt2728 T293 T2790 2859163.2314381367
Rt2729 T293 T3857 2561800.0398224965
Rt2730 T293 T5127 1141472.1994811713
Gcorr861 T293 T5700 T293 T5700 -5.5347527419814129e-07
Rt2731 T294 T295 537761.02321259654
Rt2732 T294 T631 562651.60156195273
Rt2733 T294 T717 562740.61364316323
Gcorr862 T294 T1530 T294 T1530 -5.853133359057081e-07
Gcorr863 T294 T1773 T294 T1773 -3.8474836697021669e-07
Gcorr864 T294 T1824 T294 T1824 -1.707604118148843e-07
Rt2734 T294 T2347 598306.42479027307
Gcorr865 T294 T2534 T294 T2534 -2.2971948671654526e-07
Rt2735 T294 T3857 938263.33837652858
Rt2736 T294 T4173 415139.18031928455
Gcorr866 T294 T4884 T294 T4884 -5.8531333590581779e-07
Gcorr867 T294 T5127 T294 T5127 -3.8474836697043983e-07
Gcorr868 T294 T5179 T294 T5179 -1.7076041181505937e-07
Rt2737 T294 T5700 598306.4247899378
Gcorr869 T294 T5888 T294 T5888 -2.2971948671697576e-07
Rt2738 T295 T631 453584.94971475878
Rt2739 T295 T716 549855.35181627353
Rt2740 T295 T1530 1219185.0903213606
Gcorr870 T295 T2347 T295 T2347 -5.1317580135300406e-07
Rt2741 T295 T2791 3284593.7889281888
Rt2742 T295 T4173 1737081.623960793
Rt2743 T295 T4884 1219185.0903208177
Gcorr871 T295 T5700 T295 T5700 -5.1317580135337135e-07
Rt2744 T296 T297 454517.09009287931
Rt2745 T296 T618 615824.9547648523
Rt2746 T296 T813 418515.39880048187
Gcorr872 T296 T1116 T296 T1116 -4.4148042066387938e-07
Rt2747 T296 T1118 3520222.2828732836
Gcorr873 T296 T1355 T296 T1355 -1.38070966232149e-07
Rt2748 T296 T2197 1466278.0881321013
Rt2749 T296 T2833 3106212.8934651962
Rt2750 T296 T3558 2083880.3129118932
Gcorr874 T296 T4470 T296 T4470 -4.4148042066356576e-07
Rt2751 T296 T4472 3520222.2828722349
Gcorr875 T296 T4709 T296 T4709 -1.3807096623243984e-07
Rt2752 T296 T5554 1466278.0881323377
Rt2753 T297 T298 512134.08595498081
Rt2754 T297 T618 353160.6166780481
Rt2755 T297 T799 280391.30497020239
Gcorr876 T297 T995 T297 T995 -5.1360035253235147e-07
Gcorr877 T297 T1115 T297 T1115 -4.5321694569476714e-07
Rt2756 T297 T1116 371803.31389171048
Gcorr878 T297 T1118 T297 T1118 -4.5588866818066834e-07
Gcorr879 T297 T2182 T297 T2182 -4.3184049087244956e-07
Gcorr880 T297 T2197 T297 T2197 -4.5251731292602536e-07
Rt2757 T297 T2833 957007.80493327545
Rt2758 T297 T3672 1325708.7692761689
Gcorr881 T297 T4349 T297 T4349 -5.1360035253198651e-07
Gcorr882 T297 T4469 T297 T4469 -4.5321694569487164e-07
Rt2759 T297 T4470 371803.31389172946
Gcorr883 T297 T4472 T297 T4472 -4.5588866818080821e-07
Gcorr884 T297 T5539 T297 T5539 -4.3184049087243638e-07
Gcorr885 T297 T5554 T297 T5554 -4.5251731292602456e-07
Rt2760 T298 T299 675052.94949241343
Rt2761 T298 T627 519705.85412226937
Rt2762 T298 T799 462471.60687509523
Rt2763 T298 T995 3591643.8774053813
Gcorr886 T298 T1114 T298 T1114 -1.2358634369894677e-07
Rt2764 T298 T1115 1489635.9369133452
Gcorr887 T298 T1116 T298 T1116 -4.4361232996567639e-07
Rt2765 T298 T3669 3576140.8363973219
Rt2766 T298 T3672 3576293.9018855551
Rt2767 T298 T4349 3591643.8774064193
Gcorr888 T298 T4468 T298 T4468 -1.2358634369885608e-07
Rt2768 T298 T4469 1489635.9369119862
Gcorr889 T298 T4470 T298 T4470 -4.4361232996630156e-07
Rt2769 T299 T627 596621.42598903645
Rt2770 T299 T788 411132.72832643858
Rt2771 T299 T1114 2283279.6314870738
Gcorr890 T299 T1115 T299 T1115 -1.7154673478107511e-07
Rt2772 T299 T1278 14465454.8172764
Rt2773 T299 T1351 20762550.217878956
Rt2774 T299 T2831 1795109.2387120023
Rt2775 T299 T3669 1718993.3772910202
Rt2776 T299 T4468 2283279.6314873067
Gcorr891 T299 T4469 T299 T4469 -1.7154673478132866e-07
Rt2777 T299 T4632 14465454.817280628
Rt2778 T299 T4705 20762550.217742708
Rt2779 T300 T623 604374.16593997716
Rt2780 T300 T808 404019.22960471531
Rt2781 T300 T1408 7187407.1635233182
Rt2782 T300 T1466 6616971.0335905384
Rt2783 T300 T2101 11297435.947927402
Rt2784 T300 T3579 1807313.8045560142
Rt2785 T300 T3676 3567964.5269668689
Rt2786 T300 T4762 7187407.1635285299
Rt2787 T300 T4820 6616971.0336003276
Rt2788 T300 T5454 11297435.947886311
Rt2789 T301 T302 969228306.64263773
Rt2790 T301 T323 244395.38264084313
Rt2791 T301 T324 5958229.3467261633
Rt2792 T301 T2049 7570427.2606089311
Rt2793 T301 T2611 502794.26457370428
Gcorr892 T301 T3177 T301 T3177 -5.3657078931899223e-08
Gcorr893 T301 T4107 T301 T4107 -1.7948615306407368e-06
Gcorr894 T302 T303 T302 T303 -2.6482479967227841e-08
Rt2794 T302 T324 409771.54334205762
Rt2795 T302 T325 4313290.1796306409
Rt2796 T302 T875 7698881.5393374292
Rt2797 T302 T2049 4710105.7577440478
Rt2798 T302 T3446 15023946.632324221
Gcorr895 T303 T304 T303 T304 -4.2095105854120063e-08
Rt2799 T303 T325 214998.7151950949
Rt2800 T303 T326 3563834.0037487885
Rt2801 T303 T875 394782.77806964412
Rt2802 T303 T1859 12584458.424043441
Gcorr896 T303 T2445 T303 T2445 -3.6890072516628227e-07
Rt2803 T303 T2910 1499564.6153514339
Gcorr897 T303 T3446 T303 T3446 -2.5449524869236195e-06
Gcorr898 T304 T305 T304 T305 -4.0901442020595757e-08
Rt2804 T304 T326 611152.42970467301
Rt2805 T304 T327 3021848.2661636351
Rt2806 T304 T866 7799560.4135186765
Rt2807 T304 T1859 4284127.3110386599
Rt2808 T304 T3424 14721970.728168679
Gcorr899 T305 T306 T305 T306 -3.6654269596646985e-08
Rt2809 T305 T327 610899.71965521411
Rt2810 T305 T328 3056723.1389633212
Rt2811 T305 T866 4081497.1282593175
Rt2812 T305 T1996 2683601.611051634
Rt2813 T305 T2964 30331703.407411821
Gcorr900 T305 T4190 T305 T4190 -2.3268019751372391e-07
Gcorr901 T306 T307 T306 T307 -2.9203312544194701e-08
Rt2814 T306 T328 696026.15221429954
Rt2815 T306 T329 2393943.5110898223
Gcorr902 T306 T1945 T306 T1945 -6.8454489470354751e-09
Gcorr903 T306 T1996 T306 T1996 -8.2292900663221691e-08
Rt2816 T306 T2408 2240795.921752587
Rt2817 T306 T3402 60501704.771182865
Gcorr904 T307 T308 T307 T308 -3.8405135235787303e-08
Rt2818 T307 T329 999951.5385733064
Rt2819 T307 T330 2558641.3600267568
Rt2820 T307 T856 7496754.1528268075
Rt2821 T307 T1945 6259353.4420707924
Rt2822 T307 T3002 11364326.514499955
Gcorr905 T308 T309 T308 T309 -4.2947772408958011e-08
Rt2823 T308 T330 1392323.2886589365
Rt2824 T308 T331 3430104.6990448129
Rt2825 T308 T856 3500364.6636602306
Rt2826 T308 T1896 22710624.864911102
Gcorr906 T308 T2418 T308 T2418 -1.9269091138248274e-07
Rt2827 T308 T4198 1682639.0665287601
Gcorr907 T309 T310 T309 T310 -4.5965700699457586e-08
Rt2828 T309 T331 1291135.1113510532
Rt2829 T309 T332 1992097.0956842727
Rt2830 T309 T871 6243827.7846120745
Rt2831 T309 T1896 4592715.6360535901
Rt2832 T309 T3463 35222310.601854153
Gcorr908 T310 T311 T310 T311 -5.0038892819137824e-08
Rt2833 T310 T332 1015341.0816984694
Rt2834 T310 T333 1239024.4896213955
Gcorr909 T310 T871 T310 T871 -1.3146005012282259e-07
Gcorr910 T310 T1828 T310 T1828 -1.9616496342901868e-07
Rt2835 T310 T2682 816322.67757797881
Gcorr911 T310 T3004 T310 T3004 -4.229506247052453e-07
Gcorr912 T311 T312 T311 T312 -5.3542282795655119e-08
Rt2836 T311 T333 1577049.1758856361
Rt2837 T311 T334 1661537.6813406853
Rt2838 T311 T854 8056002.7790675154
Rt2839 T311 T1828 5552749.481099504
Rt2840 T311 T3385 9383019.8237016983
Gcorr913 T312 T313 T312 T313 -5.981319957237165e-08
Rt2841 T312 T334 1616750.1787986187
Rt2842 T312 T335 1503765.4213560033
Rt2843 T312 T854 7776515.677327876
Rt2844 T312 T1830 4944793.4460924165
Rt2845 T312 T2994 11920680.058949007
Gcorr914 T313 T314 T313 T314 -6.9338588037043832e-08
Rt2846 T313 T335 2421023.2235570941
Rt2847 T313 T336 1574929.8140487529
Rt2848 T313 T870 8723802.2845606972
Rt2849 T313 T1830 12757738.584571274
Gcorr915 T313 T2558 T313 T2558 -1.1786733880034866e-07
Rt2850 T313 T4007 1478434.4006643691
Gcorr916 T314 T315 T314 T315 -8.2516281992415124e-08
Rt2851 T314 T336 1744724.4996839298
Rt2852 T314 T337 1062770.8528264854
Rt2853 T314 T870 8449381.700340936
Rt2854 T314 T1816 5235781.3974159947
Rt2855 T314 T2947 8475020.0319213364
Gcorr917 T315 T316 T315 T316 -1.0588377192975392e-07
Rt2856 T315 T337 1704907.1356905047
Rt2857 T315 T338 606667.56655375299
Rt2858 T315 T857 5761383.3121691253
Rt2859 T315 T1816 10453782.617066476
Rt2860 T315 T2595 27189428.132263575
Rt2861 T315 T3473 2775016.7721002847
Gcorr918 T315 T4170 T315 T4170 -2.5929094569574405e-07
Gcorr919 T316 T317 T316 T317 -9.9995705172335847e-08
Rt2862 T316 T338 1696809.0921946496
Rt2863 T316 T339 521100.01370586752
Rt2864 T316 T857 19991964.683407638
Gcorr920 T316 T2264 T316 T2264 -1.8704331582218425e-07
Rt2865 T316 T2568 2639696.0971998018
Rt2866 T316 T2930 7430438.8053264413
Gcorr921 T317 T318 T317 T318 -8.3775075281428816e-08
Rt2867 T317 T339 1896422.5894990079
Rt2868 T317 T340 660140.76089765958
Rt2869 T317 T2264 2838933.9549602643
Rt2870 T317 T2463 3995023.9296378288
Gcorr922 T317 T3462 T317 T3462 -1.187004699218343e-07
Rt2871 T318 T319 25507693.178665403
Rt2872 T318 T340 933478.20483027794
Rt2873 T318 T341 428696.32256894116
Gcorr923 T318 T867 T318 T867 -1.6630929790329373e-07
Gcorr924 T318 T2463 T318 T2463 -4.8390297951202723e-07
Rt2874 T318 T2707 353975.02526333119
Gcorr925 T318 T2942 T318 T2942 -8.1634003542949683e-07
Gcorr926 T318 T3799 T318 T3799 -3.080203118855768e-07
Gcorr927 T319 T320 T319 T320 -4.7710266588374014e-08
Rt2875 T319 T341 4828881.135933131
Rt2876 T319 T342 457888.78747843183
Rt2877 T319 T867 10627441.490823338
Rt2878 T319 T883 8317123.8671268756
Gcorr928 T319 T2632 T319 T2632 -1.0311009897479962e-07
Rt2879 T319 T3799 4530736.2876063595
Rt2880 T319 T3810 6906316.9241343504
Gcorr929 T320 T321 T320 T321 -2.2747555857203497e-08
Rt2881 T320 T342 6084573.8695148807
Rt2882 T320 T343 361376.2443045153
Rt2883 T320 T877 6011814.8497914663
Rt2884 T320 T883 1518439.3796687454
Gcorr930 T320 T3778 T320 T3778 -4.4473433922225954e-07
Gcorr931 T321 T322 T321 T322 -3.2218663724302645e-08
Rt2885 T321 T343 3687140.6622584155
Rt2886 T321 T344 429317.14775843592
Rt2887 T321 T877 873316784.3277415
Gcorr932 T321 T1845 T321 T1845 -3.0436124631423173e-07
Rt2888 T321 T2685 1006886.8031600082
Gcorr933 T321 T3709 T321 T3709 -6.66800188177762e-07
Rt2889 T321 T3710 1345177.3475512515
Gcorr934 T322 T344 T322 T344 -2.6576249288238823e-08
Rt2890 T322 T345 379908.66718338785
Rt2891 T322 T2592 1146013.946201762
Rt2892 T322 T2685 1566220.9954688216
Gcorr935 T322 T3988 T322 T3988 -8.4132125895408492e-07
Rt2893 T323 T324 9192769.9155862257
Rt2894 T323 T451 244395.38264084331
Gcorr936 T323 T2611 T323 T2611 -1.869488395135938e-06
Rt2895 T323 T3177 2294969.6394312177
Rt2896 T323 T4107 209014.23384329132
Gcorr937 T323 T5965 T323 T5965 -1.8694883951359498e-06
Rt2897 T324 T325 28830235.550144456
Rt2898 T324 T451 5958229.3467261735
Rt2899 T324 T452 409771.54334206023
Gcorr938 T324 T2049 T324 T2049 -5.9473636924663057e-09
Rt2900 T324 T3177 1908725.0966783229
Rt2901 T324 T3446 2032325.6209060343
Gcorr939 T324 T5403 T324 T5403 -5.9473636924678327e-09
Gcorr940 T325 T326 T325 T326 -5.6046804937387278e-09
Rt2902 T325 T452 4313290.1796306511
Rt2903 T325 T453 214998.7151950949
Gcorr941 T325 T875 T325 T875 -2.5614743718867027e-06
Rt2904 T325 T2910 6419844.0879264986
Rt2905 T325 T3446 153455.50178639649
Gcorr942 T325 T4229 T325 T4229 -2.5614743718867184e-06
Gcorr943 T326 T327 T326 T327 -6.4652422088477552e-09
Rt2906 T326 T453 3563834.0037488062
Rt2907 T326 T454 611152.42970467685
Rt2908 T326 T1859 5476084.836599011
Rt2909 T326 T2910 6281475.0354475323
Rt2910 T326 T3424 1964409.3006661229
Rt2911 T326 T5214 5476084.8365991032
Gcorr944 T327 T328 T327 T328 -1.9485816198630934e-08
Rt2912 T327 T454 3021848.26616365
Rt2913 T327 T455 610899.7196552169
Gcorr945 T327 T866 T327 T866 -8.6100830675048522e-08
Rt2914 T327 T2964 663637641.92810082
Rt2915 T327 T3424 21230918.449785341
Rt2916 T327 T4190 890295.38094868767
Gcorr946 T327 T4220 T327 T4220 -8.6100830675051937e-08
Gcorr947 T328 T329 T328 T329 -5.6097953171744445e-09
Rt2917 T328 T455 3056723.1389629371
Rt2918 T328 T456 696026.15221416974
Rt2919 T328 T1996 77027499.401471093
Gcorr948 T328 T2408 T328 T2408 -2.6543583890172143e-07
Rt2920 T328 T2964 1363080.1883302964
Rt2921 T328 T3402 1241264.4227450986
Rt2922 T328 T5348 77027499.401661292
Gcorr949 T328 T5761 T328 T5761 -2.6543583890200879e-07
Gcorr950 T329 T330 T329 T330 -1.0748834589870786e-08
Rt2923 T329 T456 2393943.5110895601
Rt2924 T329 T457 999951.53857319208
Rt2925 T329 T1945 12081201.144209741
Rt2926 T329 T3002 2399741.2574687698
Rt2927 T329 T3402 5081680.6858917624
Rt2928 T329 T4136 6894167.4332286548
Rt2929 T329 T5301 12081201.144234635
Gcorr951 T330 T331 T330 T331 -9.7903801582344171e-08
Rt2930 T330 T457 2558641.3600267679
Rt2931 T330 T458 1392323.2886589456
Rt2932 T330 T856 4277132.3510187725
Rt2933 T330 T3002 2360432.1861843462
Gcorr952 T330 T3434 T330 T3434 -3.9395528104505786e-07
Rt2934 T330 T4198 1093735.3584798381
Rt2935 T330 T4210 4277132.351018819
Gcorr953 T331 T332 T331 T332 -1.8511218288698994e-08
Rt2936 T331 T458 3430104.6990443901
Rt2937 T331 T459 1291135.1113508004
Gcorr954 T331 T1896 T331 T1896 -8.9677663111952767e-08
Rt2938 T331 T3463 3111904.2581293234
Rt2939 T331 T4198 708965.92377333588
Gcorr955 T331 T5253 T331 T5253 -8.9677663112147281e-08
Gcorr956 T332 T333 T332 T333 -3.571133827755607e-08
Rt2940 T332 T459 1992097.095684282
Rt2941 T332 T460 1015341.0816984698
Rt2942 T332 T871 4124852.2036097129
Gcorr957 T332 T2682 T332 T2682 -4.457714366529305e-07
Rt2943 T332 T3004 1153032.8663969282
Rt2944 T332 T3463 2382746.7184135066
Rt2945 T332 T4225 4124852.203608206
Gcorr958 T332 T6036 T332 T6036 -4.4577143665302531e-07
Gcorr959 T333 T334 T333 T334 -4.572686144333516e-08
Rt2946 T333 T460 1239024.4896213864
Rt2947 T333 T461 1577049.1758856452
Rt2948 T333 T1828 2521272.4239244051
Gcorr960 T333 T2682 T333 T2682 -4.7013888475715389e-07
Rt2949 T333 T3004 1328521.5640969111
Rt2950 T333 T3385 3798538.3853705628
Rt2951 T333 T4135 16922470.31280148
Rt2952 T333 T5183 2521272.4239237616
Gcorr961 T333 T6036 T333 T6036 -4.7013888475726702e-07
Gcorr962 T334 T335 T334 T335 -5.2330334430815224e-08
Rt2953 T334 T461 1661537.6813406935
Rt2954 T334 T462 1616750.1787986271
Rt2955 T334 T854 25503711.095500525
Rt2956 T334 T2994 2617840.6444212906
Rt2957 T334 T3385 1894122.3867126182
Rt2958 T334 T4208 25503711.095501907
Gcorr963 T335 T336 T335 T336 -1.4889623223392271e-07
Rt2959 T335 T462 1503765.4213560109
Rt2960 T335 T463 2421023.223557109
Rt2961 T335 T1830 4989408.1564757274
Rt2962 T335 T2994 3009729.8729688679
Gcorr964 T335 T3967 T335 T3967 -1.6638410758862136e-07
Rt2963 T335 T4007 1197307.9292047916
Rt2964 T335 T5185 4989408.1564757898
Gcorr965 T336 T337 T336 T337 -9.1175846054541926e-08
Rt2965 T336 T463 1574929.8140487624
Rt2966 T336 T464 1744724.4996839392
Gcorr966 T336 T870 T336 T870 -2.481796113457704e-08
Rt2967 T336 T2947 2074602.2991130049
Rt2968 T336 T4007 973921.47225437348
Gcorr967 T336 T4224 T336 T4224 -2.4817961134578082e-08
Gcorr968 T337 T338 T337 T338 -1.1714895526662965e-07
Rt2969 T337 T464 1062770.8528264912
Rt2970 T337 T465 1704907.1356905135
Rt2971 T337 T1816 4155723.9983078064
Rt2972 T337 T2947 2895091.332187973
Rt2973 T337 T3473 5212157.1400690936
Rt2974 T337 T5171 4155723.998307867
Gcorr969 T338 T339 T338 T339 -1.5297252254956947e-07
Rt2975 T338 T465 606667.56655375636
Rt2976 T338 T466 1696809.0921946585
Rt2977 T338 T857 44566208.094201669
Rt2978 T338 T2930 6657638.0848392677
Gcorr970 T338 T3473 T338 T3473 -3.5503306815248412e-07
Rt2979 T338 T4170 902558.19716226438
Rt2980 T338 T4211 44566208.094207987
Gcorr971 T339 T340 T339 T340 -1.284701811540222e-07
Rt2981 T339 T466 521100.01370597782
Rt2982 T339 T467 1896422.5894995218
Rt2983 T339 T2264 4955587.3134909328
Gcorr972 T339 T2568 T339 T2568 -2.9363586780869657e-07
Rt2984 T339 T2930 1694338.3328946054
Rt2985 T339 T3462 1579177.3179966398
Rt2986 T339 T5619 4955587.3134782482
Gcorr973 T339 T5922 T339 T5922 -2.9363586780867979e-07
Gcorr974 T340 T341 T340 T341 -9.2992700493208718e-08
Rt2987 T340 T467 660140.76089785132
Rt2988 T340 T468 933478.20483007387
Rt2989 T340 T2463 941555.1754119253
Gcorr975 T340 T2707 T340 T2707 -9.5184871374271526e-07
Rt2990 T340 T2942 1171814.5044366985
Rt2991 T340 T3462 2861725.1415383732
Gcorr976 T340 T4150 T340 T4150 -4.3570087018898162e-07
Rt2992 T340 T5817 941555.17541162425
Gcorr977 T340 T6061 T340 T6061 -9.518487137428672e-07
Gcorr978 T341 T342 T341 T342 -4.2043899857380659e-08
Rt2993 T341 T468 428696.32256894553
Rt2994 T341 T469 4828881.1359331748
Gcorr979 T341 T2707 T341 T2707 -5.2597237163783631e-07
Rt2995 T341 T2942 3910620.2988588391
Rt2996 T341 T3799 563806.69982406707
Gcorr980 T341 T6061 T341 T6061 -5.259723716378235e-07
Rt2997 T342 T343 1548537.2562465752
Rt2998 T342 T469 457888.78747843433
Rt2999 T342 T470 6084573.8695149478
Rt3000 T342 T883 3878405.1472596191
Gcorr981 T342 T3778 T342 T3778 -6.5103854922592991e-07
Gcorr982 T342 T3799 T342 T3799 -1.0474428677904448e-07
Rt3001 T342 T3810 771621.69664768374
Rt3002 T342 T4237 3878405.1472596666
Rt3003 T343 T344 14954381.326043298
Rt3004 T343 T470 361376.24430451682
Rt3005 T343 T471 3687140.6622584322
Gcorr983 T343 T877 T343 T877 -1.797689741467427e-09
Gcorr984 T343 T883 T343 T883 -8.735038314356696e-07
Rt3006 T343 T3710 32781161.808835719
Rt3007 T343 T3778 348281.20595169254
Gcorr985 T343 T4231 T343 T4231 -1.7976897414700475e-09
Gcorr986 T343 T4237 T343 T4237 -8.7350383143566876e-07
Rt3008 T344 T345 3898034.2393680541
Rt3009 T344 T471 429317.14775843796
Gcorr987 T344 T472 T344 T472 -2.6576249288239868e-08
Gcorr988 T344 T2685 T344 T2685 -1.8393589624925112e-07
Rt3010 T344 T3709 908205.17216987954
Rt3011 T344 T3710 3700216.2515530922
Gcorr989 T344 T6039 T344 T6039 -1.8393589624925335e-07
Rt3012 T345 T472 379908.66718338866
Gcorr990 T345 T2592 T345 T2592 -6.4520037259716316e-07
Rt3013 T345 T2685 9003371.0312392265
Gcorr991 T345 T3709 T345 T3709 -2.1834838729641457e-07
Rt3014 T345 T3988 400958.9833848821
Gcorr992 T345 T5946 T345 T5946 -6.4520037259716718e-07
Rt3015 T345 T6039 9003371.0312394816
Rt3016 T346 T347 7297176.7084702598
Rt3017 T346 T361 526123.54728676006
Gcorr993 T346 T880 T346 T880 -2.1281672431796616e-07
Rt3018 T346 T2592 1962524.9408802532
Rt3019 T346 T4079 3551092.6750141932
Rt3020 T347 T348 6057821.696574688
Gcorr994 T347 T361 T347 T361 -8.7139345430093371e-08
Rt3021 T347 T362 469396.69863450277
Rt3022 T347 T880 4767574.5529213743
Rt3023 T347 T1961 8793427.3219042271
Rt3024 T347 T3881 6091218.5240607727
Gcorr995 T347 T3968 T347 T3968 -1.6604576760903935e-07
Rt3025 T347 T4079 3564601.2540977453
Rt3026 T348 T349 5950685.8395634443
Gcorr996 T348 T362 T348 T362 -9.2672741502230093e-08
Rt3027 T348 T363 449541.93168395135
Gcorr997 T348 T874 T348 T874 -1.7608330046348863e-07
Rt3028 T348 T1961 1301325.0713300486
Gcorr998 T348 T3881 T348 T3881 -3.5681582591863739e-07
Rt3029 T348 T4087 4917886.0353666451
Rt3030 T349 T350 3199892.0257738549
Gcorr999 T349 T363 T349 T363 -1.2655941142452804e-07
Rt3031 T349 T364 795625.04172717198
Gcorr1000 T349 T365 T349 T365 -1.3574968752876247e-07
Gcorr1001 T349 T874 T349 T874 -4.6707115938300783e-08
Gcorr1002 T349 T1940 T349 T1940 -2.1168142764093537e-07
Rt3032 T349 T3920 1420765.4768708965
Rt3033 T349 T4087 2284099.5634298702
Rt3034 T350 T351 5927135.4115486359
Rt3035 T350 T365 516763.968150781
Gcorr1003 T350 T366 T350 T366 -1.0240545140055322e-07
Gcorr1004 T350 T862 T350 T862 -3.1707649332774753e-08
Rt3036 T350 T1940 4605901.7129704915
Rt3037 T350 T3888 2858891.6986909597
Gcorr1005 T350 T3920 T350 T3920 -3.0154734222720398e-07
Rt3038 T350 T4011 4122100.5262960228
Rt3039 T351 T352 19124326.435976386
Rt3040 T351 T366 392338.85179966537
Gcorr1006 T351 T367 T351 T367 -5.4115401941805932e-08
Rt3041 T351 T862 12510798.707239119
Rt3042 T351 T1991 1448266.7348138792
Gcorr1007 T351 T3610 T351 T3610 -3.4605192092898358e-07
Rt3043 T351 T3888 13788674.941418011
Rt3044 T352 T353 17947528.992831022
Rt3045 T352 T367 339822.78154400509
Gcorr1008 T352 T368 T352 T368 -6.9774859108678317e-08
Rt3046 T352 T1991 2261132.2059876081
Rt3047 T352 T2261 2050436.9561127697
Gcorr1009 T352 T4066 T352 T4066 -4.5282394402581959e-07
Rt3048 T353 T354 5730121.9316505678
Rt3049 T353 T368 433865.51917520625
Gcorr1010 T353 T859 T353 T859 -1.2448201758996355e-07
Rt3050 T353 T2261 3536920.0339710354
Rt3051 T353 T3978 5912730.1763220262
Rt3052 T354 T355 39711532.96989432
Gcorr1011 T354 T368 T354 T368 -8.501789424990651e-08
Rt3053 T354 T369 540288.56718147709
Gcorr1012 T354 T859 T354 T859 -1.3410120215007416e-07
Rt3054 T354 T2600 2439232.749453533
Rt3055 T354 T3978 3155046.3618521448
Rt3056 T355 T356 4623555.0730208419
Gcorr1013 T355 T369 T355 T369 -1.1406288186189856e-07
Rt3057 T355 T370 430766.26740198646
Gcorr1014 T355 T2288 T355 T2288 -2.2039985047263859e-07
Rt3058 T355 T2541 1988260.5646302011
Rt3059 T355 T2600 3544340.1276440802
Gcorr1015 T355 T3753 T355 T3753 -4.6430955961808555e-09
Rt3060 T356 T357 4672441.9931977196
Gcorr1016 T356 T370 T356 T370 -8.0838361008488539e-08
Rt3061 T356 T371 475653.22750306851
Gcorr1017 T356 T864 T356 T864 -2.0047629234278629e-07
Rt3062 T356 T2288 1339444.7635392693
Gcorr1018 T356 T3753 T356 T3753 -3.0491508352429795e-07
Rt3063 T356 T3924 5485930.5974664949
Rt3064 T357 T358 5165969.7978492249
Gcorr1019 T357 T371 T357 T371 -2.6375327108055458e-08
Rt3065 T357 T372 508921.61745654355
Gcorr1020 T357 T373 T357 T373 -6.9754185852360837e-08
Rt3066 T357 T864 5327331.6167971091
Rt3067 T357 T1924 5309850.3610889055
Gcorr1021 T357 T2699 T357 T2699 -1.3851306684496157e-07
Rt3068 T357 T3439 36471032.08984533
Gcorr1022 T357 T3924 T357 T3924 -1.4948228693126169e-07
Rt3069 T357 T3944 1952847.3085423945
Rt3070 T358 T359 6282245.434241686
Rt3071 T358 T373 291697.48836168845
Gcorr1023 T358 T374 T358 T374 -9.3838167539607706e-08
Gcorr1024 T358 T876 T358 T876 -1.3808994329422157e-07
Rt3072 T358 T1924 536078.84873411001
Gcorr1025 T358 T3439 T358 T3439 -1.6367867239784592e-06
Rt3073 T358 T3867 2646792.222529145
Rt3074 T359 T360 19629829.250897806
Rt3075 T359 T374 398295.36834320228
Gcorr1026 T359 T375 T359 T375 -5.4997614375010268e-08
Gcorr1027 T359 T876 T359 T876 -1.3942744029108941e-07
Rt3076 T359 T1936 843097.26909622701
Gcorr1028 T359 T3515 T359 T3515 -8.4498997172553539e-07
Rt3077 T359 T3867 1821238.8252406192
Rt3078 T360 T375 379327.63969697809
Rt3079 T360 T1936 3835539.097544583
Rt3080 T360 T2533 1336267.2005886799
Gcorr1029 T360 T3897 T360 T3897 -5.3666932169215549e-07
Rt3081 T361 T362 58431507.063285559
Rt3082 T361 T473 526123.54728676286
Gcorr1030 T361 T474 T361 T474 -8.7139345430093967e-08
Rt3083 T361 T2592 375788733.097202
Rt3084 T361 T3988 7455063.1421699543
Rt3085 T361 T4079 740553.41685084358
Rt3086 T361 T5946 375788733.09741598
Rt3087 T362 T363 18881175.577177815
Rt3088 T362 T474 469396.69863450574
Gcorr1031 T362 T475 T362 T475 -9.2672741502230781e-08
Rt3089 T362 T3881 1098086.7287771362
Rt3090 T362 T3968 22845471.456577286
Rt3091 T362 T4079 2204452.3752336549
Rt3092 T363 T364 122641741.04359771
Rt3093 T363 T475 449541.93168395269
Gcorr1032 T363 T476 T363 T476 -1.2655941142452886e-07
Gcorr1033 T363 T1961 T363 T1961 -6.8655368482018967e-07
Rt3094 T363 T3881 499493.64040516521
Rt3095 T363 T4087 714431.20744497795
Gcorr1034 T363 T5315 T363 T5315 -6.86553684820192e-07
Rt3096 T364 T365 8566227.8562444579
Rt3097 T364 T476 795625.04172717733
Rt3098 T364 T3920 1930725.9062244035
Rt3099 T364 T4087 1960348.1728684888
Rt3100 T365 T366 22630496.137966074
Gcorr1035 T365 T476 T365 T476 -1.3574968752876345e-07
Rt3101 T365 T477 516763.96815078385
Rt3102 T365 T3888 2427852.2020619633
Rt3103 T365 T3920 2293440.2555210409
Rt3104 T365 T4011 2445218.2327652383
Rt3105 T366 T367 1562858.2628567449
Gcorr1036 T366 T477 T366 T477 -1.0240545140055394e-07
Rt3106 T366 T478 392338.85179966706
Rt3107 T366 T1991 22643457.18074248
Rt3108 T366 T3610 1080973.0367069149
Rt3109 T366 T3888 1178347.1637660558
Gcorr1037 T366 T4066 T366 T4066 -6.4373726061561828e-07
Rt3110 T366 T5343 22643457.180745088
Rt3111 T367 T368 2381650.3811266543
Gcorr1038 T367 T478 T367 T478 -5.4115401941806409e-08
Rt3112 T367 T479 339822.78154400672
Gcorr1039 T367 T1991 T367 T1991 -4.6393922733189733e-07
Gcorr1040 T367 T2261 T367 T2261 -1.0702317648191648e-07
Rt3113 T367 T2796 12292092.799095111
Rt3114 T367 T4066 520245.38267308369
Gcorr1041 T367 T5343 T367 T5343 -4.639392273318969e-07
Gcorr1042 T367 T5616 T367 T5616 -1.0702317648191828e-07
Rt3115 T368 T369 12349102.282888453
Gcorr1043 T368 T479 T368 T479 -6.9774859108678793e-08
Rt3116 T368 T480 433865.51917520893
Gcorr1044 T368 T481 T368 T481 -8.5017894249907118e-08
Rt3117 T368 T2261 7465227.238188317
Rt3118 T368 T2796 8566251.9181038812
Rt3119 T368 T3978 890895.79220633302
Rt3120 T368 T5616 7465227.2381883534
Rt3121 T369 T370 2231913.1996960244
Rt3122 T369 T481 540288.56718092447
Gcorr1045 T369 T482 T369 T482 -1.1406288186182026e-07
Rt3123 T369 T2600 1970075.4683394814
Gcorr1046 T369 T2840 T369 T2840 -2.998047639612394e-07
Rt3124 T369 T3978 1442174.7937959242
Rt3125 T369 T5954 1970075.4683471899
Rt3126 T370 T371 12275526.273465896
Rt3127 T370 T482 430766.267401424
Gcorr1047 T370 T483 T370 T483 -8.0838361008489108e-08
Gcorr1048 T370 T2541 T370 T2541 -3.6211820725205432e-08
Gcorr1049 T370 T2600 T370 T2600 -8.3540380006414098e-08
Rt3128 T370 T2840 4305494.6183020668
Rt3129 T370 T3753 828597.64288666914
Gcorr1050 T370 T5894 T370 T5894 -3.6211820725585935e-08
Gcorr1051 T370 T5954 T370 T5954 -8.3540380009078216e-08
Rt3130 T371 T372 7256625.0682543963
Rt3131 T371 T483 475653.22750291385
Gcorr1052 T371 T484 T371 T484 -2.6375327108055693e-08
Gcorr1053 T371 T2288 T371 T2288 -5.7150808806297855e-07
Rt3132 T371 T3753 1009938.7225241518
Rt3133 T371 T3924 606760.06552739977
Gcorr1054 T371 T5642 T371 T5642 -5.7150808806367217e-07
Rt3134 T372 T373 6544779.7050635871
Rt3135 T372 T484 508921.61745654693
Rt3136 T372 T3439 4994101.4319808325
Rt3137 T372 T3924 64863731.396530494
Rt3138 T372 T3944 1639679.8952038661
Rt3139 T373 T374 21813007.274947792
Gcorr1055 T373 T484 T373 T484 -6.9754185852361327e-08
Rt3140 T373 T485 291697.48836168862
Gcorr1056 T373 T1924 T373 T1924 -1.3020782633443439e-06
Rt3141 T373 T3439 270184.52595084102
Rt3142 T373 T3867 727322.10449130239
Gcorr1057 T373 T3912 T373 T3912 -7.3983497133149599e-07
Gcorr1058 T373 T5280 T373 T5280 -1.3020782633443551e-06
Rt3143 T374 T375 1200701.6394054212
Gcorr1059 T374 T485 T374 T485 -9.383816753960842e-08
Rt3144 T374 T486 398295.36834320379
Rt3145 T374 T1936 20332045.870696418
Rt3146 T374 T3515 1069802.4800547995
Rt3147 T374 T3867 1097162.945301248
Gcorr1060 T374 T3897 T374 T3897 -8.0937355528070654e-07
Rt3148 T374 T5292 20332045.870698977
Gcorr1061 T375 T486 T375 T486 -5.4997614375010718e-08
Rt3149 T375 T487 379327.63969697955
Gcorr1062 T375 T1936 T375 T1936 -5.1035548807517387e-07
Gcorr1063 T375 T2533 T375 T2533 -5.3522863979567924e-07
Rt3150 T375 T3897 321482.42044836428
Gcorr1064 T375 T5292 T375 T5292 -5.1035548807517197e-07
Gcorr1065 T375 T5887 T375 T5887 -5.3522863979568062e-07
Rt3151 T376 T377 16754353.523975385
Rt3152 T376 T399 423948.9535715399
Rt3153 T376 T881 10788541.175023554
Rt3154 T376 T2533 3046968.5411254126
Rt3155 T377 T378 19761047.633361518
Rt3156 T377 T399 12717917.569640823
Rt3157 T377 T400 316793.82568802062
Rt3158 T377 T881 2498494.6374094598
Rt3159 T377 T1935 1304541.1951683005
Gcorr1066 T377 T3070 T377 T3070 -1.1733548869661883e-07
Gcorr1067 T377 T3727 T377 T3727 -5.8499131491992897e-07
Rt3160 T378 T379 3133570.4449319718
Gcorr1068 T378 T400 T378 T400 -4.1974228121997059e-08
Rt3161 T378 T401 291959.02993275214
Rt3162 T378 T868 1105882.3205770878
Rt3163 T378 T1935 2242855.4227320924
Gcorr1069 T378 T3728 T378 T3728 -3.4459841713208158e-07
Gcorr1070 T378 T3821 T378 T3821 -7.1873250001830739e-07
Rt3164 T379 T380 4299563.3815230215
Gcorr1071 T379 T401 T379 T401 -1.0464266462728676e-07
Rt3165 T379 T402 465100.32914157066
Gcorr1072 T379 T868 T379 T868 -2.0913236374378476e-07
Gcorr1073 T379 T2024 T379 T2024 -4.195089678395796e-08
Gcorr1074 T379 T2514 T379 T2514 -4.0577755668544754e-08
Rt3166 T379 T3776 20653901.428721666
Rt3167 T379 T3821 1338025.947017601
Gcorr1075 T380 T381 T380 T381 -1.1675812111340895e-08
Gcorr1076 T380 T402 T380 T402 -1.0189600655989518e-07
Rt3168 T380 T403 404762.43752488709
Rt3169 T380 T2514 891973.53406069963
Rt3170 T380 T2693 4400174.8508769386
Gcorr1077 T380 T3776 T380 T3776 -8.5108074808566736e-07
Rt3171 T381 T382 5686423.3763504289
Gcorr1078 T381 T403 T381 T403 -1.3138035344486582e-07
Rt3172 T381 T404 423422.60030888411
Gcorr1079 T381 T861 T381 T861 -7.4644199780072264e-08
Rt3173 T381 T2576 3205044.9644940346
Rt3174 T381 T2693 2306498.5728680082
Gcorr1080 T381 T3495 T381 T3495 -7.9641884806199761e-08
Rt3175 T382 T383 2807162.3919343702
Gcorr1081 T382 T404 T382 T404 -3.1571363785511659e-08
Rt3176 T382 T405 379307.86914725136
Rt3177 T382 T861 28061791.357637331
Rt3178 T382 T2635 738840.5248184927
Gcorr1082 T382 T2932 T382 T2932 -7.1319317015190372e-07
Gcorr1083 T382 T3495 T382 T3495 -5.9181679694450663e-08
Rt3179 T383 T384 21410625.742963508
Gcorr1084 T383 T405 T383 T405 -4.6584446432394562e-08
Rt3180 T383 T406 567381.57647080824
Gcorr1085 T383 T1904 T383 T1904 -4.1041542999413656e-08
Rt3181 T383 T2619 1880393.3031720154
Gcorr1086 T383 T2635 T383 T2635 -3.2234321084380349e-07
Rt3182 T383 T2932 3119879.4789113603
Rt3183 T384 T385 18487774.422227275
Gcorr1087 T384 T406 T384 T406 -1.2293629637341911e-07
Rt3184 T384 T407 350807.22017292539
Rt3185 T384 T855 9303435.2860645931
Rt3186 T384 T2220 1464847.6230550499
Rt3187 T384 T2619 1973484.3519978998
Gcorr1088 T384 T3456 T384 T3456 -7.8401836009452859e-07
Gcorr1089 T385 T386 T385 T386 -1.9866530048532409e-07
Rt3188 T385 T407 12781822.352339292
Rt3189 T385 T408 942397.36537154519
Rt3190 T385 T852 1300802.3412419369
Rt3191 T385 T855 4121674.5866834461
Rt3192 T385 T1919 5486717.6216540961
Rt3193 T385 T2951 168269677.09568611
Gcorr1090 T385 T3984 T385 T3984 -3.5512764007756194e-08
Gcorr1091 T386 T387 T386 T387 -1.8491609019417587e-07
Rt3194 T386 T409 1038649.3061382509
Rt3195 T386 T850 2065078.1597848621
Rt3196 T386 T852 1271836.9591850876
Rt3197 T386 T873 10965759.007742545
Gcorr1092 T386 T1919 T386 T1919 -2.9350297824725276e-08
Rt3198 T386 T2728 3816516.8449228117
Gcorr1093 T386 T3984 T386 T3984 -1.3233707475411579e-07
Gcorr1094 T387 T388 T387 T388 -1.298013675449186e-07
Rt3199 T387 T410 1298052.5634057911
Rt3200 T387 T848 929171.3727646831
Rt3201 T387 T850 1286493.7227428225
Rt3202 T387 T873 3038788.6304573887
Rt3203 T387 T2023 2883984.2409115438
Gcorr1095 T387 T2659 T387 T2659 -2.9651078303804372e-07
Gcorr1096 T387 T2996 T387 T2996 -2.0080337876384473e-07
Gcorr1097 T387 T3372 T387 T3372 -5.4367785684770831e-08
Gcorr1098 T388 T389 T388 T389 -1.7091122224501222e-07
Rt3204 T388 T411 4445066.9978996227
Rt3205 T388 T845 974058.39021989203
Rt3206 T388 T848 2926902.4065485448
Gcorr1099 T388 T2051 T388 T2051 -3.3046368130970449e-07
Rt3207 T388 T2659 1220772.4501649498
Gcorr1100 T389 T390 T389 T390 -1.8187141576130874e-07
Rt3208 T389 T412 485143.12586587801
Rt3209 T389 T845 2195192.7984225703
Rt3210 T389 T846 1358481.642941965
Rt3211 T389 T853 7435486.2122021541
Rt3212 T389 T2051 569395.33363641147
Gcorr1101 T389 T2505 T389 T2505 -1.8902370334943706e-07
Gcorr1102 T389 T3012 T389 T3012 -1.4158185288662631e-06
Rt3213 T389 T3481 5566321.732400639
Gcorr1103 T390 T391 T390 T391 -1.7534421914892765e-07
Rt3214 T390 T413 895850.99948308663
Rt3215 T390 T846 2030489.0451062492
Rt3216 T390 T847 1259432.7218776636
Rt3217 T390 T853 2247445.5348560475
Rt3218 T390 T1909 3039148.2922744504
Gcorr1104 T390 T3613 T390 T3613 -2.8969914439149733e-07
Gcorr1105 T390 T3807 T390 T3807 -1.6770898864859811e-07
Gcorr1106 T391 T392 T391 T392 -1.8173224256656788e-07
Rt3219 T391 T414 1451800.8728046368
Rt3220 T391 T847 1487652.5670096159
Rt3221 T391 T849 1293454.6278952516
Rt3222 T391 T872 3099542.8270609081
Rt3223 T391 T1909 8010072.9235120965
Gcorr1107 T391 T3003 T391 T3003 -2.2767629798358842e-07
Rt3224 T391 T3807 14940467.256477904
Gcorr1108 T392 T393 T392 T393 -1.888792305805464e-07
Rt3225 T392 T415 1482344.3065909192
Rt3226 T392 T849 2094091.358709489
Rt3227 T392 T851 1227459.6397630894
Rt3228 T392 T872 4374399.3012568606
Gcorr1109 T392 T1914 T392 T1914 -7.2537256753038406e-09
Rt3229 T392 T4033 14102939.505735144
Rt3230 T393 T394 18421588.563547567
Rt3231 T393 T416 508565.91465296852
Rt3232 T393 T417 12567793.487634176
Rt3233 T393 T851 1207353.2901550934
Rt3234 T393 T860 2985870.1655695052
Rt3235 T393 T1914 1085865.4459864204
Gcorr1110 T393 T2958 T393 T2958 -1.0136374187079718e-07
Gcorr1111 T393 T3866 T393 T3866 -3.098331323967875e-07
Gcorr1112 T393 T4033 T393 T4033 -6.0246752402055229e-07
Rt3236 T394 T395 25550709.945935749
Rt3237 T394 T417 646101.57424953196
Rt3238 T394 T418 14966735.854996078
Rt3239 T394 T860 4290719.1438518958
Rt3240 T394 T2014 3202569.4923425224
Gcorr1113 T394 T3523 T394 T3523 -1.0263584663749459e-07
Rt3241 T395 T396 21289268.120367792
Rt3242 T395 T418 486890.02761118842
Rt3243 T395 T419 11726497.831952389
Rt3244 T395 T869 3202743.9576166561
Rt3245 T395 T2014 3184395.3239610423
Gcorr1114 T395 T2687 T395 T2687 -2.2455154260280478e-07
Gcorr1115 T395 T2906 T395 T2906 -1.5467146079076738e-07
Rt3246 T395 T4175 3042859.9619056475
Rt3247 T396 T397 25251694.874737836
Rt3248 T396 T419 88496.31817068145
Rt3249 T396 T420 14514364.408611348
Rt3250 T396 T869 10905986.724282419
Rt3251 T396 T2444 101662.68933695994
Gcorr1116 T396 T3798 T396 T3798 -9.3592242387964542e-06
Rt3252 T397 T398 16260435.478708286
Rt3253 T397 T420 386716.33933527995
Rt3254 T397 T421 12304108.794876328
Rt3255 T397 T882 3425575.7506668237
Rt3256 T397 T2444 4091664.9705777243
Gcorr1117 T397 T3167 T397 T3167 -9.041870720809918e-08
Rt3257 T398 T421 433636.48930338473
Rt3258 T398 T882 4980389.2722977269
Rt3259 T398 T2646 5314225.7572443793
Rt3260 T398 T4080 21920439.598929144
Rt3261 T399 T400 6736982.8842830611
Rt3262 T399 T488 423948.95357154263
Rt3263 T399 T489 12717917.569640769
Gcorr1118 T399 T881 T399 T881 -1.261745275119023e-07
Rt3264 T399 T2533 2527931.8885152196
Rt3265 T399 T3070 1194585.6781686179
Gcorr1119 T399 T3897 T399 T3897 -2.940305660418774e-07
Gcorr1120 T399 T4235 T399 T4235 -1.2617452751190334e-07
Rt3266 T399 T5887 2527931.8885152335
Rt3267 T400 T401 2249484.3445063378
Rt3268 T400 T489 316793.82568802201
Gcorr1121 T400 T490 T400 T490 -4.1974228121997562e-08
Gcorr1122 T400 T1935 T400 T1935 -6.1277084171050657e-07
Rt3269 T400 T3070 3402004.735161202
Rt3270 T400 T3727 563625.50121906376
Gcorr1123 T400 T5291 T400 T5291 -6.1277084171050943e-07
Rt3271 T401 T402 6869382.5820162324
Rt3272 T401 T490 291959.02993275295
Gcorr1124 T401 T491 T401 T491 -1.0464266462728771e-07
Gcorr1125 T401 T868 T401 T868 -7.0938012741051722e-07
Gcorr1126 T401 T1935 T401 T1935 -5.3357848751199744e-08
Gcorr1127 T401 T3727 T401 T3727 -2.5396025393981286e-07
Rt3273 T401 T3728 507735.09653186693
Rt3274 T401 T3821 842171.8459342852
Gcorr1128 T401 T4222 T401 T4222 -7.0938012741052103e-07
Gcorr1129 T401 T5291 T401 T5291 -5.3357848751202444e-08
Rt3275 T402 T403 8309676.981360374
Rt3276 T402 T491 465100.3291415734
Gcorr1130 T402 T492 T402 T492 -1.0189600655989608e-07
Rt3277 T402 T3776 1886337.3660470592
Rt3278 T402 T3821 1699137.6414859479
Rt3279 T403 T404 2742245.5390621433
Rt3280 T403 T492 404762.43752541766
Gcorr1131 T403 T493 T403 T493 -1.3138035344489515e-07
Gcorr1132 T403 T2514 T403 T2514 -1.1228629170929616e-06
Rt3281 T403 T2693 1233539.4558728368
Gcorr1133 T403 T2944 T403 T2944 -4.468765262769076e-07
Rt3282 T403 T3776 333408.93946877657
Gcorr1134 T403 T5868 T403 T5868 -1.1228629170897916e-06
Rt3283 T403 T6047 1233539.4558727082
Rt3284 T404 T405 7956859.2151430817
Rt3285 T404 T493 423422.6003091383
Gcorr1135 T404 T494 T404 T494 -3.1571363785512162e-08
Gcorr1136 T404 T2576 T404 T2576 -1.7231303231946721e-07
Rt3286 T404 T2693 19982917.978385556
Rt3287 T404 T2944 8396500.3683919925
Rt3288 T404 T3495 806625.98276809987
Gcorr1137 T404 T5930 T404 T5930 -1.7231303231962693e-07
Rt3289 T404 T6047 19982917.977761261
Rt3290 T405 T406 7383661.2849618718
Rt3291 T405 T494 379307.86914738244
Gcorr1138 T405 T495 T405 T495 -4.6584446432395191e-08
Rt3292 T405 T2635 12436374.960442031
Rt3293 T405 T2932 983430.94965318381
Rt3294 T405 T3495 1860612.3597732719
Gcorr1139 T405 T3946 T405 T3946 -4.908210635053876e-07
Rt3295 T405 T5989 12436374.960303789
Rt3296 T406 T407 1388589.349041553
Rt3297 T406 T495 567381.57647066284
Gcorr1140 T406 T496 T406 T496 -1.2293629637326939e-07
Rt3298 T406 T2619 1895494.3253936972
Rt3299 T406 T2932 2118758.126282692
Gcorr1141 T406 T3456 T406 T3456 -3.3498733568958718e-07
Rt3300 T406 T5973 1895494.3253959089
Rt3301 T407 T408 6726971.3400293216
Rt3302 T407 T496 350807.22017294116
Rt3303 T407 T497 12781822.352339242
Gcorr1142 T407 T855 T407 T855 -9.2500779457424613e-08
Gcorr1143 T407 T2220 T407 T2220 -4.3545997650355545e-07
Gcorr1144 T407 T2619 T407 T2619 -6.0184082594807516e-07
Rt3304 T407 T2951 1195607.8610044869
Rt3305 T407 T3456 472262.42924130225
Gcorr1145 T407 T4209 T407 T4209 -9.2500779457425434e-08
Gcorr1146 T407 T5576 T407 T5576 -4.3545997650355826e-07
Gcorr1147 T407 T5973 T407 T5973 -6.0184082594795573e-07
Gcorr1148 T408 T409 T408 T409 -2.9202893629343414e-07
Rt3306 T408 T497 942397.3653715516
Rt3307 T408 T852 3548775.2788251182
Rt3308 T408 T2951 3296569.1808408694
Rt3309 T408 T3984 1376518.498142421
Rt3310 T408 T4206 3548775.2788251443
Gcorr1149 T409 T410 T409 T410 -3.6179658963452925e-07
Rt3311 T409 T498 1038649.3061382568
Rt3312 T409 T850 1250315.0612509409
Rt3313 T409 T852 3594535.7652438916
Gcorr1150 T409 T873 T409 T873 -1.6020443194604363e-07
Gcorr1151 T409 T2728 T409 T2728 -3.0977724398801434e-08
Rt3314 T409 T2996 1840918.5396343123
Gcorr1152 T409 T3963 T409 T3963 -4.0091697110935096e-08
Rt3315 T409 T3984 955725.39343202661
Rt3316 T409 T4204 1250315.0612509493
Rt3317 T409 T4206 3594535.7652439177
Gcorr1153 T409 T4227 T409 T4227 -1.602044319460453e-07
Gcorr1154 T409 T6083 T409 T6083 -3.0977724398802229e-08
Gcorr1155 T410 T411 T410 T411 -3.2835978034141839e-07
Rt3318 T410 T499 1298052.5634058008
Rt3319 T410 T848 2028297.7719699242
Rt3320 T410 T850 1882424.8053505307
Rt3321 T410 T2996 3342379.1502432246
Rt3322 T410 T3372 2478010.1160360808
Rt3323 T410 T4202 2028297.7719699193
Rt3324 T410 T4204 1882424.8053505558
Gcorr1156 T411 T412 T411 T412 -3.2143467406440775e-07
Rt3325 T411 T500 4445066.9978990685
Rt3326 T411 T845 887372.38932558475
Rt3327 T411 T848 1473892.6049305804
Gcorr1157 T411 T2051 T411 T2051 -4.8592525428008658e-07
Rt3328 T411 T2659 1345995.7225890022
Rt3329 T411 T3012 1690153.5494616807
Rt3330 T411 T3372 21655425.872791335
Gcorr1158 T411 T4124 T411 T4124 -7.6024813036205223e-08
Rt3331 T411 T4199 887372.38932543551
Rt3332 T411 T4202 1473892.6049304735
Gcorr1159 T411 T5405 T411 T5405 -4.8592525428016726e-07
Rt3333 T411 T6013 1345995.7225891496
Gcorr1160 T412 T413 T412 T413 -3.0660644697659695e-07
Rt3334 T412 T501 493664.10034297523
Rt3335 T412 T845 1269154.5667681368
Rt3336 T412 T846 2138787.6296846829
Gcorr1161 T412 T2051 T412 T2051 -1.469550566855384e-06
Rt3337 T412 T3012 330612.72099238599
Rt3338 T412 T3481 2556511.4973023166
Rt3339 T412 T4199 1269154.5667687992
Rt3340 T412 T4200 1856277.1298911157
Gcorr1162 T412 T5405 T412 T5405 -1.469550566859041e-06
Gcorr1163 T413 T414 T413 T414 -2.9032803617432023e-07
Rt3341 T413 T502 893849.76016960503
Rt3342 T413 T846 1371647.5532055618
Rt3343 T413 T847 2468081.5706378482
Gcorr1164 T413 T853 T413 T853 -2.7662835214159211e-07
Rt3344 T413 T3481 2833570.5774381063
Rt3345 T413 T3613 1940956.6853025998
Rt3346 T413 T3807 3185717.4863693784
Rt3347 T413 T4200 1582355.1912366075
Rt3348 T413 T4201 2120127.7413250557
Gcorr1165 T413 T4207 T413 T4207 -2.6391165937562848e-07
Gcorr1166 T414 T415 T414 T415 -3.5322322162683352e-07
Rt3349 T414 T503 1469829.896917186
Rt3350 T414 T847 2454472.8617238658
Rt3351 T414 T849 1892382.7274504048
Rt3352 T414 T3003 4021587.559317444
Rt3353 T414 T3807 1855796.0361125085
Rt3354 T414 T4201 2870747.9695730559
Rt3355 T414 T4203 1660070.1777642327
Gcorr1167 T415 T416 T415 T416 -2.9424398799535903e-07
Rt3356 T415 T504 1409826.4167767412
Rt3357 T415 T849 1253729.9568635053
Rt3358 T415 T851 2485575.0849465192
Gcorr1168 T415 T872 T415 T872 -1.8703304086042141e-07
Rt3359 T415 T3003 2808674.1143548992
Rt3360 T415 T4033 978493.72484929056
Rt3361 T415 T4203 1440291.9454867737
Rt3362 T415 T4205 2485575.0849465537
Gcorr1169 T415 T4226 T415 T4226 -1.7352439341697641e-07
Rt3363 T416 T417 6695134.3776552044
Rt3364 T416 T505 508565.91465296986
Rt3365 T416 T851 3324955.4109553583
Gcorr1170 T416 T1914 T416 T1914 -6.3559709508312395e-07
Rt3366 T416 T2958 4459421.7814432587
Rt3367 T416 T3866 1024585.1962308843
Rt3368 T416 T4033 941530.38012889621
Rt3369 T416 T4205 3324955.4109554137
Gcorr1171 T416 T5271 T416 T5271 -6.3559709508312786e-07
Rt3370 T417 T418 9121402.7455256861
Rt3371 T417 T505 12567793.487634124
Rt3372 T417 T506 646101.5742495358
Gcorr1172 T417 T860 T417 T860 -1.2573990570364815e-07
Rt3373 T417 T2958 1799042.7286911772
Rt3374 T417 T3523 1334803.0809378424
Gcorr1173 T417 T4214 T417 T4214 -1.2573990570364915e-07
Rt3375 T418 T419 7586291.0296343621
Rt3376 T418 T506 14966735.854997613
Rt3377 T418 T507 486890.0276111688
Gcorr1174 T418 T2014 T418 T2014 -1.7563909753397215e-07
Rt3378 T418 T2906 9925047.902177209
Rt3379 T418 T3523 2954435.3227841598
Rt3380 T418 T4175 980312.43030900927
Gcorr1175 T418 T5367 T418 T5367 -1.7563909753406135e-07
Rt3381 T419 T420 10083834.691465735
Rt3382 T419 T507 11726497.831952352
Rt3383 T419 T508 88496.318171312232
Gcorr1176 T419 T869 T419 T869 -2.9643347215055032e-09
Gcorr1177 T419 T2444 T419 T2444 -9.3509612301748057e-06
Rt3384 T419 T2906 1929646.015393595
Rt3385 T419 T3798 52415.197971521971
Gcorr1178 T419 T4223 T419 T4223 -2.9643347215343487e-09
Gcorr1179 T419 T5798 T419 T5798 -9.3509612300942461e-06
Rt3386 T420 T421 6534836.2372888234
Rt3387 T420 T508 14514364.408608835
Rt3388 T420 T509 386716.33933529974
Gcorr1180 T420 T2444 T420 T2444 -5.4547741085335247e-08
Rt3389 T420 T3167 1606387.9453778917
Rt3390 T420 T3798 1938781.5514877592
Gcorr1181 T420 T5798 T420 T5798 -5.4547741085232055e-08
Rt3391 T421 T509 12304108.794876279
Rt3392 T421 T510 433636.48930338747
Gcorr1182 T421 T882 T421 T882 -1.4587466782081811e-07
Rt3393 T421 T3167 2156054.7051894451
Rt3394 T421 T4080 1072707.6701455819
Gcorr1183 T421 T4236 T421 T4236 -1.4587466782081933e-07
Gcorr1184 T422 T423 T422 T423 -3.4842283448296743e-08
Rt3395 T422 T436 273902.9769307368
Rt3396 T422 T437 4311455.2459291844
Rt3397 T422 T2271 11473821.467396198
Rt3398 T422 T2646 523644.14666637406
Rt3399 T422 T3777 6780340.6907173945
Gcorr1185 T422 T4080 T422 T4080 -1.6689589025334374e-06
Gcorr1186 T423 T424 T423 T424 -7.3877187509056091e-08
Rt3400 T423 T437 450855.08808381954
Rt3401 T423 T438 2733940.2417575885
Rt3402 T423 T878 13132032.994798312
Rt3403 T423 T2271 5457062.2214442976
Rt3404 T423 T2857 6823281.3116692072
Gcorr1187 T424 T425 T424 T425 -8.7068193547769703e-08
Rt3405 T424 T438 431108.45869800856
Rt3406 T424 T439 954132.97056964668
Gcorr1188 T424 T878 T424 T878 -8.7904203343921356e-08
Gcorr1189 T424 T2424 T424 T2424 -5.4499174739963787e-07
Rt3407 T424 T2617 606284.33077373041
Gcorr1190 T424 T3355 T424 T3355 -5.8163786194877133e-07
Gcorr1191 T425 T426 T425 T426 -1.2574880121167532e-07
Rt3408 T425 T439 671029.17056960834
Rt3409 T425 T440 1636779.8024038337
Rt3410 T425 T865 34588559.974981278
Rt3411 T425 T2424 3310121.8726907433
Rt3412 T425 T2924 7874617.0400379188
Gcorr1192 T426 T427 T426 T427 -1.2223934439295245e-07
Rt3413 T426 T440 633538.39153779368
Rt3414 T426 T441 1606258.5593586545
Rt3415 T426 T865 21860513.931601778
Rt3416 T426 T1967 4893560.3409487978
Rt3417 T426 T3444 5372265.6794728478
Gcorr1193 T427 T428 T427 T428 -1.2376026096989098e-07
Rt3418 T427 T441 740762.05110883527
Rt3419 T427 T442 1207137.0817636687
Gcorr1194 T427 T1906 T427 T1906 -7.176760559645218e-09
Rt3420 T427 T1967 70360113.934269533
Gcorr1195 T427 T2402 T427 T2402 -6.5827271194428368e-08
Rt3421 T427 T2940 2019960.7382001926
Gcorr1196 T428 T429 T428 T429 -1.2875840989172558e-07
Rt3422 T428 T442 1151961.0641485392
Rt3423 T428 T443 1001787.9560731243
Rt3424 T428 T858 50177673.258399524
Rt3425 T428 T1906 7752323.4402875481
Rt3426 T428 T3862 3103201.4663844821
Gcorr1197 T429 T430 T429 T430 -1.1329850593882538e-07
Rt3427 T429 T443 716646.4004299154
Rt3428 T429 T444 1042180.3095670695
Rt3429 T429 T858 4029894.6351648727
Rt3430 T429 T2350 1345093.6661569851
Gcorr1198 T429 T3715 T429 T3715 -5.2640640431659687e-07
Rt3431 T429 T3906 6784963.4266703231
Gcorr1199 T430 T431 T430 T431 -1.02227811374693e-07
Rt3432 T430 T444 1164513.4050288491
Rt3433 T430 T445 678830.98034317419
Gcorr1200 T430 T2350 T430 T2350 -3.1010471099918547e-08
Rt3434 T430 T2546 4544574.9943502471
Gcorr1201 T430 T2658 T430 T2658 -1.5602033144383105e-07
Rt3435 T430 T2946 3349641.2496667756
Gcorr1202 T431 T432 T431 T432 -1.2799935970277441e-07
Rt3436 T431 T445 1874379.661575034
Rt3437 T431 T446 346087.50419670087
Rt3438 T431 T863 7818449.9578462718
Rt3439 T431 T2658 421153.56059788587
Gcorr1203 T431 T3712 T431 T3712 -5.5812466959689673e-07
Gcorr1204 T431 T4108 T431 T4108 -8.8398651937766726e-07
Gcorr1205 T432 T433 T432 T433 -8.7242952961447597e-08
Rt3440 T432 T446 1629447.8159946559
Rt3441 T432 T447 613228.26434710703
Rt3442 T432 T863 76393646.410953209
Rt3443 T432 T2556 4079489.0166157493
Rt3444 T432 T2928 6522162.7721738359
Gcorr1206 T433 T434 T433 T434 -7.3877193430987998e-08
Rt3445 T433 T447 1748489.0529566871
Rt3446 T433 T448 476104.58216594416
Rt3447 T433 T879 6823336.2311259536
Gcorr1207 T433 T2361 T433 T2361 -1.2492224314740347e-07
Gcorr1208 T433 T2556 T433 T2556 -1.9004661636303561e-07
Rt3448 T433 T3496 1571694.4379687386
Gcorr1209 T434 T435 T434 T435 -5.6652871846804519e-08
Rt3449 T434 T448 2733938.9123234614
Rt3450 T434 T449 558093.25618506095
Rt3451 T434 T879 8799049.484446371
Rt3452 T434 T2719 3194998.8008581987
Rt3453 T434 T2858 10246486.294675104
Gcorr1210 T435 T449 T435 T449 -1.1052717208640539e-08
Rt3454 T435 T450 206210.67093326835
Rt3455 T435 T2611 357310.01500328985
Rt3456 T435 T2719 2183122.6959671262
Gcorr1211 T435 T4107 T435 T4107 -2.9117308035039457e-06
Rt3457 T436 T437 15166568.619836463
Rt3458 T436 T511 273902.97693073703
Gcorr1212 T436 T2646 T436 T2646 -1.441515925261936e-06
Rt3459 T436 T3777 7516846.8018658273
Rt3460 T436 T4080 263118.15217854496
Gcorr1213 T436 T6000 T436 T6000 -1.4415159252619459e-06
Gcorr1214 T437 T438 T437 T438 -1.4402235362783858e-08
Rt3461 T437 T511 4311455.2459291983
Rt3462 T437 T512 450855.08808382228
Gcorr1215 T437 T2271 T437 T2271 -1.7260724867651611e-08
Rt3463 T437 T2857 2386015.6994032734
Rt3464 T437 T3777 1649178.0001966511
Gcorr1216 T437 T5625 T437 T5625 -1.7260724867653282e-08
Gcorr1217 T438 T439 T438 T439 -9.0409873709662616e-08
Rt3465 T438 T512 2733940.241757601
Rt3466 T438 T513 431108.45869801083
Rt3467 T438 T878 152492925.62840253
Gcorr1218 T438 T2617 T438 T2617 -2.0023171478192071e-07
Rt3468 T438 T2857 1308995.3905786735
Rt3469 T438 T3355 1670685.558708482
Rt3470 T438 T4232 152492925.62845421
Gcorr1219 T438 T5971 T438 T5971 -2.0023171478192154e-07
Gcorr1220 T439 T440 T439 T440 -1.4162194928056171e-07
Rt3471 T439 T513 954132.97056975646
Rt3472 T439 T514 671029.17056958238
Rt3473 T439 T2424 1226217.7572217463
Gcorr1221 T439 T2617 T439 T2617 -1.0275979061491006e-06
Rt3474 T439 T2924 3850083.5285326117
Rt3475 T439 T3355 774038.11715772387
Rt3476 T439 T5777 1226217.7572216706
Gcorr1222 T439 T5971 T439 T5971 -1.0275979061491036e-06
Gcorr1223 T440 T441 T440 T441 -1.6165485093489955e-07
Rt3477 T440 T514 1636779.8024038426
Rt3478 T440 T515 633538.39153779764
Rt3479 T440 T865 7780581.6338801933
Rt3480 T440 T2924 2303632.0219182251
Rt3481 T440 T3444 3312589.4442287753
Rt3482 T440 T4219 7780581.6338803358
Gcorr1224 T441 T442 T441 T442 -1.7272917685589298e-07
Rt3483 T441 T515 1606258.559358662
Rt3484 T441 T516 740762.05110884004
Rt3485 T441 T1967 17033475.885459941
Rt3486 T441 T2940 4671643.8736272343
Rt3487 T441 T3444 1424099.413021659
Rt3488 T441 T5321 17033475.885460634
Gcorr1225 T442 T443 T442 T443 -1.3909816879779468e-07
Rt3489 T442 T516 1207137.0817636759
Rt3490 T442 T517 1151961.0641485446
Rt3491 T442 T1906 31064031.26907986
Rt3492 T442 T2940 9784480.9233485032
Rt3493 T442 T3862 1018120.1645956424
Rt3494 T442 T5263 31064031.269082248
Gcorr1226 T443 T444 T443 T444 -1.3414187276603494e-07
Rt3495 T443 T517 1001787.9560731306
Rt3496 T443 T518 716646.40042991925
Rt3497 T443 T858 4192132.4153875224
Rt3498 T443 T3715 1113818.2578031945
Rt3499 T443 T3862 15372180.354119223
Gcorr1227 T443 T3906 T443 T3906 -6.9857597184192973e-07
Rt3500 T443 T4212 4192132.4153875876
Gcorr1228 T444 T445 T444 T445 -1.7287426010536093e-07
Rt3501 T444 T518 1042180.3095669521
Rt3502 T444 T519 1164513.4050287493
Rt3503 T444 T2350 15398646.276809402
Rt3504 T444 T2946 16273736.249455359
Rt3505 T444 T3906 1243746.5631316835
Rt3506 T444 T5703 15398646.276855571
Gcorr1229 T445 T446 T445 T446 -1.5387837436688978e-07
Rt3507 T445 T519 678830.98034326464
Rt3508 T445 T520 1874379.6615756557
Gcorr1230 T445 T2546 T445 T2546 -3.552107642631457e-07
Rt3509 T445 T2658 3994676.9158418388
Rt3510 T445 T2946 2121624.1283481806
Rt3511 T445 T3712 866740.76700446685
Gcorr1231 T445 T5899 T445 T5899 -3.5521076426316878e-07
Rt3512 T445 T6012 3994676.91583572
Gcorr1232 T446 T447 T446 T447 -1.4573582243314297e-07
Rt3513 T446 T520 346087.50419673981
Rt3514 T446 T521 1629447.8159946646
Rt3515 T446 T863 42892977.052710451
Gcorr1233 T446 T2658 T446 T2658 -1.1154857478194434e-06
Rt3516 T446 T2928 5509605.2124377387
Rt3517 T446 T3712 2430164.6328466297
Rt3518 T446 T4108 511678.78886459512
Rt3519 T446 T4217 42892977.052716173
Gcorr1234 T446 T6012 T446 T6012 -1.1154857478191292e-06
Gcorr1235 T447 T448 T447 T448 -8.986995157055081e-08
Rt3520 T447 T521 613228.2643470926
Rt3521 T447 T522 1748489.0529561872
Rt3522 T447 T2556 6908108.88732001
Rt3523 T447 T2928 2280954.9508322054
Rt3524 T447 T3496 3833752.0000927909
Rt3525 T447 T5910 6908108.8873303877
Gcorr1236 T448 T449 T448 T449 -1.4402235362839584e-08
Rt3526 T448 T522 476104.58216594718
Rt3527 T448 T523 2733938.912323473
Rt3528 T448 T879 29977147.199313264
Rt3529 T448 T2858 1779020.1577059866
Rt3530 T448 T3496 2788556.4244631859
Rt3531 T448 T4233 29977147.199314933
Rt3532 T449 T450 3286641.3795537343
Rt3533 T449 T523 558093.25618506444
Gcorr1237 T449 T524 T449 T524 -1.1052717208641929e-08
Rt3534 T449 T2719 1561786.2124877505
Rt3535 T449 T2858 2334640.252733117
Gcorr1238 T449 T3781 T449 T3781 -2.7892084725084464e-07
Rt3536 T449 T6074 1561786.2124877586
Rt3537 T450 T524 206210.67093326812
Gcorr1239 T450 T2611 T450 T2611 -2.9978619912860926e-06
Rt3538 T450 T2719 5054099.8586097611
Gcorr1240 T450 T3781 T450 T3781 -2.151661021943933e-07
Rt3539 T450 T4107 130570.78142940481
Gcorr1241 T450 T5965 T450 T5965 -2.9978619912861099e-06
Rt3540 T450 T6074 5054099.858609803
Rt3541 T451 T452 969228306.64185119
Gcorr1242 T451 T3177 T451 T3177 -5.3657078931901056e-08
Gcorr1243 T451 T4107 T451 T4107 -1.7948615306407482e-06
Rt3542 T451 T5403 7570427.2606088202
Rt3543 T451 T5965 502794.26457370084
Gcorr1244 T452 T453 T452 T453 -2.6482479967226849e-08
Rt3544 T452 T3446 15023946.63232471
Rt3545 T452 T4229 7698881.5393372783
Rt3546 T452 T5403 4710105.7577439994
Gcorr1245 T453 T454 T453 T454 -4.2095105854119123e-08
Rt3547 T453 T2910 1499564.6153510637
Gcorr1246 T453 T3446 T453 T3446 -2.5449524869236352e-06
Rt3548 T453 T4229 394782.77806962596
Rt3549 T453 T5214 12584458.424041498
Gcorr1247 T453 T5799 T453 T5799 -3.6890072516642896e-07
Gcorr1248 T454 T455 T454 T455 -4.0901442020594625e-08
Rt3550 T454 T3424 14721970.728169208
Rt3551 T454 T4220 7799560.4135185136
Rt3552 T454 T5214 4284127.3110386087
Gcorr1249 T455 T456 T455 T456 -3.6654269596640242e-08
Rt3553 T455 T2964 30331703.407295391
Gcorr1250 T455 T4190 T455 T4190 -2.3268019751370676e-07
Rt3554 T455 T4220 4081497.1282593883
Rt3555 T455 T5348 2683601.6110531925
Gcorr1251 T456 T457 T456 T457 -2.9203312544188024e-08
Rt3556 T456 T3402 60501704.770396397
Gcorr1252 T456 T5301 T456 T5301 -6.8454489470828428e-09
Gcorr1253 T456 T5348 T456 T5348 -8.2292900663241742e-08
Rt3557 T456 T5761 2240795.9217540468
Gcorr1254 T457 T458 T457 T458 -3.8405135235786132e-08
Rt3558 T457 T3002 11364326.514494199
Rt3559 T457 T4210 7496754.1528264517
Rt3560 T457 T5301 6259353.4420736572
Gcorr1255 T458 T459 T458 T459 -4.2947772408955999e-08
Rt3561 T458 T4198 1682639.0665282924
Rt3562 T458 T4210 3500364.6636574413
Rt3563 T458 T5253 22710624.864892248
Gcorr1256 T458 T5771 T458 T5771 -1.9269091138268576e-07
Gcorr1257 T459 T460 T459 T460 -4.5965700699456355e-08
Rt3564 T459 T3463 35222310.601734146
Rt3565 T459 T4225 6243827.7846110836
Rt3566 T459 T5253 4592715.6360574365
Gcorr1258 T460 T461 T460 T461 -5.0038892819136679e-08
Gcorr1259 T460 T3004 T460 T3004 -4.2295062470514333e-07
Gcorr1260 T460 T4225 T460 T4225 -1.314600501227916e-07
Gcorr1261 T460 T5183 T460 T5183 -1.9616496342897233e-07
Rt3567 T460 T6036 816322.67757831118
Gcorr1262 T461 T462 T461 T462 -5.3542282795653895e-08
Rt3568 T461 T3385 9383019.8237019312
Rt3569 T461 T4208 8056002.7790673589
Rt3570 T461 T5183 5552749.4810994184
Gcorr1263 T462 T463 T462 T463 -5.9813199572370591e-08
Rt3571 T462 T2994 11920680.058949349
Rt3572 T462 T4208 7776515.677327727
Rt3573 T462 T5185 4944793.4460923495
Gcorr1264 T463 T464 T463 T464 -6.9338588037042535e-08
Rt3574 T463 T4007 1478434.4006641014
Rt3575 T463 T4224 8723802.2845572364
Rt3576 T463 T5185 12757738.584565369
Gcorr1265 T463 T5912 T463 T5912 -1.1786733880044406e-07
Gcorr1266 T464 T465 T464 T465 -8.251628199241392e-08
Rt3577 T464 T2947 8475020.031921532
Rt3578 T464 T4224 8449381.7003407478
Rt3579 T464 T5171 5235781.3974159136
Gcorr1267 T465 T466 T465 T466 -1.058837719297524e-07
Rt3580 T465 T3473 2775016.7720992379
Gcorr1268 T465 T4170 T465 T4170 -2.5929094569569032e-07
Rt3581 T465 T4211 5761383.3121679602
Rt3582 T465 T5171 10453782.617063887
Rt3583 T465 T5949 27189428.132421568
Gcorr1269 T466 T467 T466 T467 -9.9995705172328568e-08
Rt3584 T466 T2930 7430438.805326649
Rt3585 T466 T4211 19991964.683406539
Gcorr1270 T466 T5619 T466 T5619 -1.8704331582204454e-07
Rt3586 T466 T5922 2639696.0972010703
Gcorr1271 T467 T468 T467 T468 -8.3775075281414654e-08
Gcorr1272 T467 T3462 T467 T3462 -1.1870046992205987e-07
Rt3587 T467 T5619 2838933.9549584184
Rt3588 T467 T5817 3995023.9296332123
Rt3589 T468 T469 25507693.178664219
Gcorr1273 T468 T2942 T468 T2942 -8.1634003542988096e-07
Gcorr1274 T468 T3799 T468 T3799 -3.0802031188582112e-07
Gcorr1275 T468 T4221 T468 T4221 -1.6630929790333674e-07
Gcorr1276 T468 T5817 T468 T5817 -4.8390297951169148e-07
Rt3590 T468 T6061 353975.02526321064
Gcorr1277 T469 T470 T469 T470 -4.7710266588372915e-08
Rt3591 T469 T3799 4530736.2876063939
Rt3592 T469 T3810 6906316.9241344677
Rt3593 T469 T4221 10627441.490823133
Rt3594 T469 T4237 8317123.8671267182
Gcorr1278 T469 T5986 T469 T5986 -1.031100989747978e-07
Gcorr1279 T470 T471 T470 T471 -2.2747555857202491e-08
Gcorr1280 T470 T3778 T470 T3778 -4.4473433922226293e-07
Rt3595 T470 T4231 6011814.8497913769
Rt3596 T470 T4237 1518439.3796687375
Gcorr1281 T471 T472 T471 T472 -3.2218663724302334e-08
Gcorr1282 T471 T3709 T471 T3709 -6.6680018817776358e-07
Rt3597 T471 T3710 1345177.3475512592
Rt3598 T471 T4231 873316784.32520533
Gcorr1283 T471 T5200 T471 T5200 -3.0436124631422908e-07
Rt3599 T471 T6039 1006886.8031600056
Gcorr1284 T472 T3988 T472 T3988 -8.4132125895409042e-07
Rt3600 T472 T5946 1146013.9462017545
Rt3601 T472 T6039 1566220.9954688118
Rt3602 T473 T474 7297176.7084701927
Rt3603 T473 T4079 3551092.6750142439
Gcorr1285 T473 T4234 T473 T4234 -2.1281672431796341e-07
Rt3604 T473 T5946 1962524.9408802418
Rt3605 T474 T475 6057821.6965746423
Rt3606 T474 T3881 6091218.5240608659
Gcorr1286 T474 T3968 T474 T3968 -1.6604576760903864e-07
Rt3607 T474 T4079 3564601.2540977509
Rt3608 T474 T4234 4767574.5529213361
Rt3609 T474 T5315 8793427.3219040409
Rt3610 T475 T476 5950685.8395633912
Gcorr1287 T475 T3881 T475 T3881 -3.5681582591864009e-07
Rt3611 T475 T4087 4917886.0353667298
Gcorr1288 T475 T4228 T475 T4228 -1.760833004634859e-07
Rt3612 T475 T5315 1301325.0713300412
Rt3613 T476 T477 3199892.0257738424
Rt3614 T476 T3920 1420765.4768709014
Rt3615 T476 T4087 2284099.563429879
Gcorr1289 T476 T4228 T476 T4228 -4.6707115938297475e-08
Gcorr1290 T476 T5296 T476 T5296 -2.1168142764093224e-07
Rt3616 T477 T478 5927135.4115485894
Rt3617 T477 T3888 2858891.6986909704
Gcorr1291 T477 T3920 T477 T3920 -3.015473422272043e-07
Rt3618 T477 T4011 4122100.5262960335
Gcorr1292 T477 T4216 T477 T4216 -3.1707649332771854e-08
Rt3619 T477 T5296 4605901.712970458
Rt3620 T478 T479 19124326.435976248
Gcorr1293 T478 T3610 T478 T3610 -3.4605192092898517e-07
Rt3621 T478 T3888 13788674.941418381
Rt3622 T478 T4216 12510798.707238762
Rt3623 T478 T5343 1448266.7348138713
Rt3624 T479 T480 17947528.992830899
Gcorr1294 T479 T4066 T479 T4066 -4.5282394402582171e-07
Rt3625 T479 T5343 2261132.205987596
Rt3626 T479 T5616 2050436.9561127578
Rt3627 T480 T481 5730121.9316505231
Rt3628 T480 T3978 5912730.1763221286
Gcorr1295 T480 T4213 T480 T4213 -1.2448201758996099e-07
Rt3629 T480 T5616 3536920.0339710158
Rt3630 T481 T482 39711532.969318852
Rt3631 T481 T3978 3155046.3618584354
Gcorr1296 T481 T4213 T481 T4213 -1.3410120215008056e-07
Rt3632 T481 T5954 2439232.7494558552
Rt3633 T482 T483 4623555.0730186338
Gcorr1297 T482 T3753 T482 T3753 -4.6430955940395562e-09
Gcorr1298 T482 T5642 T482 T5642 -2.2039985047353268e-07
Rt3634 T482 T5894 1988260.5646333145
Rt3635 T482 T5954 3544340.1276588934
Rt3636 T483 T484 4672441.9931977065
Gcorr1299 T483 T3753 T483 T3753 -3.0491508352313402e-07
Rt3637 T483 T3924 5485930.5974642895
Gcorr1300 T483 T4218 T483 T4218 -2.0047629234276808e-07
Rt3638 T483 T5642 1339444.7635437925
Rt3639 T484 T485 5165969.7978491895
Rt3640 T484 T3439 36471032.089846328
Gcorr1301 T484 T3924 T484 T3924 -1.4948228693126108e-07
Rt3641 T484 T3944 1952847.3085423994
Rt3642 T484 T4218 5327331.616797071
Rt3643 T484 T5280 5309850.3610888645
Gcorr1302 T484 T6053 T484 T6053 -1.3851306684495975e-07
Rt3644 T485 T486 6282245.4342416329
Gcorr1303 T485 T3439 T485 T3439 -1.6367867239784685e-06
Rt3645 T485 T3867 2646792.2225291589
Gcorr1304 T485 T4230 T485 T4230 -1.3808994329421895e-07
Rt3646 T485 T5280 536078.84873410698
Rt3647 T486 T487 19629829.250897665
Gcorr1305 T486 T3515 T486 T3515 -8.4498997172553719e-07
Rt3648 T486 T3867 1821238.8252406274
Gcorr1306 T486 T4230 T486 T4230 -1.3942744029108685e-07
Rt3649 T486 T5292 843097.2690962241
Gcorr1307 T487 T3897 T487 T3897 -5.3666932169215887e-07
Rt3650 T487 T5292 3835539.0975445574
Rt3651 T487 T5887 1336267.200588671
Rt3652 T488 T489 16754353.523975251
Rt3653 T488 T4235 10788541.175023476
Rt3654 T488 T5887 3046968.5411253925
Rt3655 T489 T490 19761047.633361343
Gcorr1308 T489 T3070 T489 T3070 -1.1733548869661977e-07
Gcorr1309 T489 T3727 T489 T3727 -5.8499131491993215e-07
Rt3656 T489 T4235 2498494.6374094444
Rt3657 T489 T5291 1304541.1951682931
Rt3658 T490 T491 3133570.4449319597
Gcorr1310 T490 T3728 T490 T3728 -3.4459841713208497e-07
Gcorr1311 T490 T3821 T490 T3821 -7.1873250001830951e-07
Rt3659 T490 T4222 1105882.3205770825
Rt3660 T490 T5291 2242855.4227320761
Rt3661 T491 T492 4299563.3815230345
Rt3662 T491 T3776 20653901.428917743
Rt3663 T491 T3821 1338025.94701873
Gcorr1312 T491 T4222 T491 T4222 -2.0913236374378452e-07
Gcorr1313 T491 T5377 T491 T5377 -4.1950896783313216e-08
Gcorr1314 T491 T5868 T491 T5868 -4.0577755668447769e-08
Gcorr1315 T492 T493 T492 T493 -1.1675812111553603e-08
Gcorr1316 T492 T3776 T492 T3776 -8.5108074808402486e-07
Rt3664 T492 T5868 891973.53406061884
Rt3665 T492 T6047 4400174.8508796422
Rt3666 T493 T494 5686423.3763503898
Gcorr1317 T493 T3495 T493 T3495 -7.9641884806466073e-08
Gcorr1318 T493 T4215 T493 T4215 -7.4644199780116375e-08
Rt3667 T493 T5930 3205044.9644925282
Rt3668 T493 T6047 2306498.5728623145
Rt3669 T494 T495 2807162.3919364968
Gcorr1319 T494 T2932 T494 T2932 -7.131931701525049e-07
Gcorr1320 T494 T3495 T494 T3495 -5.9181679694186488e-08
Rt3670 T494 T4215 28061791.357854195
Rt3671 T494 T5989 738840.52481695416
Rt3672 T495 T496 21410625.742986809
Rt3673 T495 T2932 3119879.478921622
Gcorr1321 T495 T5261 T495 T5261 -4.1041542998936763e-08
Rt3674 T495 T5973 1880393.3031747662
Gcorr1322 T495 T5989 T495 T5989 -3.2234321084311331e-07
Rt3675 T496 T497 18487774.422227111
Gcorr1323 T496 T3456 T496 T3456 -7.8401836009491357e-07
Rt3676 T496 T4209 9303435.2860645205
Rt3677 T496 T5576 1464847.6230553281
Rt3678 T496 T5973 1973484.351995799
Gcorr1324 T497 T498 T497 T498 -1.9866530048532234e-07
Rt3679 T497 T2951 168269677.09570363
Gcorr1325 T497 T3984 T497 T3984 -3.5512764007758226e-08
Rt3680 T497 T4206 1300802.3412419388
Rt3681 T497 T4209 4121674.5866834191
Rt3682 T497 T5275 5486717.6216540094
Gcorr1326 T498 T499 T498 T499 -1.8491609019417592e-07
Gcorr1327 T498 T3984 T498 T3984 -1.323370747541186e-07
Rt3683 T498 T4204 2065078.1597848565
Rt3684 T498 T4206 1271836.959185089
Rt3685 T498 T4227 10965759.007742515
Gcorr1328 T498 T5275 T498 T5275 -2.9350297824723913e-08
Rt3686 T498 T6083 3816516.844922795
Gcorr1329 T499 T500 T499 T500 -1.2980136754489163e-07
Gcorr1330 T499 T2996 T499 T2996 -2.0080337876384581e-07
Gcorr1331 T499 T3372 T499 T3372 -5.4367785684646754e-08
Rt3687 T499 T4202 929171.37276492
Rt3688 T499 T4204 1286493.7227428169
Rt3689 T499 T4227 3038788.6304583177
Rt3690 T499 T5376 2883984.2409100085
Gcorr1332 T499 T6013 T499 T6013 -2.9651078303813182e-07
Gcorr1333 T500 T501 T500 T501 -1.7091122224494827e-07
Rt3691 T500 T4199 974058.39022041799
Rt3692 T500 T4202 2926902.4065481634
Gcorr1334 T500 T5405 T500 T5405 -3.3046368130958315e-07
Rt3693 T500 T6013 1220772.4501655253
Gcorr1335 T501 T502 T501 T502 -1.7800630388047148e-07
Gcorr1336 T501 T3012 T501 T3012 -1.4158185288704853e-06
Rt3694 T501 T3481 6233112.3608243
Rt3695 T501 T4199 2195192.7984239282
Rt3696 T501 T4200 1182436.778049601
Rt3697 T501 T4207 6943063.3644852834
Rt3698 T501 T5405 569395.33363459585
Gcorr1337 T501 T5859 T501 T5859 -1.8902370334946721e-07
Gcorr1338 T502 T503 T502 T503 -1.7188303673087805e-07
Gcorr1339 T502 T3613 T502 T3613 -2.8969914439149781e-07
Gcorr1340 T502 T3807 T502 T3807 -2.0025598504257181e-07
Rt3699 T502 T4200 2373639.7142238375
Rt3700 T502 T4201 1080784.532254125
Rt3701 T502 T4207 2204670.4132395135
Rt3702 T502 T5266 2877716.1634753835
Gcorr1341 T503 T504 T503 T504 -1.7843234297919297e-07
Gcorr1342 T503 T3003 T503 T3003 -2.4724823955200762e-07
Rt3703 T503 T3807 11850595.380190194
Rt3704 T503 T4201 1714393.3706206013
Rt3705 T503 T4203 1128412.5410457365
Rt3706 T503 T4226 2998082.6206691349
Rt3707 T503 T5266 8419106.3470733967
Gcorr1343 T504 T505 T504 T505 -1.888792305805464e-07
Rt3708 T504 T4033 14102939.505735703
Rt3709 T504 T4203 2425011.6167047117
Rt3710 T504 T4205 1227459.6397630847
Rt3711 T504 T4226 4226974.2961357925
Gcorr1344 T504 T5271 T504 T5271 -7.2537256753022698e-09
Rt3712 T505 T506 18421588.563547395
Gcorr1345 T505 T2958 T505 T2958 -1.0136374187079813e-07
Gcorr1346 T505 T3866 T505 T3866 -3.0983313239678903e-07
Gcorr1347 T505 T4033 T505 T4033 -6.0246752402055335e-07
Rt3713 T505 T4205 1207353.2901550911
Rt3714 T505 T4214 2985870.1655694852
Rt3715 T505 T5271 1085865.4459864162
Rt3716 T506 T507 25550709.945923589
Gcorr1348 T506 T3523 T506 T3523 -1.0263584663720707e-07
Rt3717 T506 T4214 4290719.1438511135
Rt3718 T506 T5367 3202569.492346636
Rt3719 T507 T508 21289268.120367575
Gcorr1349 T507 T2906 T507 T2906 -1.5467146079076867e-07
Rt3720 T507 T4175 3042859.9619072359
Rt3721 T507 T4223 3202743.9576164982
Rt3722 T507 T5367 3184395.3239611015
Gcorr1350 T507 T6041 T507 T6041 -2.2455154260274273e-07
Rt3723 T508 T509 25251694.874745071
Gcorr1351 T508 T3798 T508 T3798 -9.359224238716269e-06
Rt3724 T508 T4223 10905986.724286756
Rt3725 T508 T5798 101662.68933777556
Rt3726 T509 T510 16260435.478708148
Gcorr1352 T509 T3167 T509 T3167 -9.0418707208078189e-08
Rt3727 T509 T4236 3425575.7506665527
Rt3728 T509 T5798 4091664.9705777299
Rt3729 T510 T4080 21920439.598929156
Rt3730 T510 T4236 4980389.2722976925
Rt3731 T510 T6000 5314225.7572443364
Gcorr1353 T511 T512 T511 T512 -3.4842283448295697e-08
Rt3732 T511 T3777 6780340.6907174569
Gcorr1354 T511 T4080 T511 T4080 -1.6689589025334478e-06
Rt3733 T511 T5625 11473821.467395911
Rt3734 T511 T6000 523644.14666637057
Gcorr1355 T512 T513 T512 T513 -7.3877187509054675e-08
Rt3735 T512 T2857 6823281.3116693394
Rt3736 T512 T4232 13132032.994797822
Rt3737 T512 T5625 5457062.2214442203
Gcorr1356 T513 T514 T513 T514 -8.7068193547781694e-08
Gcorr1357 T513 T3355 T513 T3355 -5.816378619487726e-07
Gcorr1358 T513 T4232 T513 T4232 -8.7904203343919887e-08
Gcorr1359 T513 T5777 T513 T5777 -5.4499174739959732e-07
Rt3738 T513 T5971 606284.33077374322
Gcorr1360 T514 T515 T514 T515 -1.257488012116736e-07
Rt3739 T514 T2924 7874617.040034255
Rt3740 T514 T4219 34588559.974952124
Rt3741 T514 T5777 3310121.8726917617
Gcorr1361 T515 T516 T515 T516 -1.222393443929508e-07
Rt3742 T515 T3444 5372265.6794729391
Rt3743 T515 T4219 21860513.931600522
Rt3744 T515 T5321 4893560.340948727
Gcorr1362 T516 T517 T516 T517 -1.2376026096988934e-07
Rt3745 T516 T2940 2019960.7381994724
Gcorr1363 T516 T5263 T516 T5263 -7.1767605596279862e-09
Rt3746 T516 T5321 70360113.934027866
Gcorr1364 T516 T5757 T516 T5757 -6.5827271194617322e-08
Gcorr1365 T517 T518 T517 T518 -1.2875840989172383e-07
Rt3747 T517 T3862 3103201.4663845217
Rt3748 T517 T4212 50177673.258391961
Rt3749 T517 T5263 7752323.4402873572
Gcorr1366 T518 T519 T518 T519 -1.1329850593881162e-07
Gcorr1367 T518 T3715 T518 T3715 -5.2640640431661286e-07
Rt3750 T518 T3906 6784963.426680401
Rt3751 T518 T4212 4029894.6351657147
Rt3752 T518 T5703 1345093.6661563772
Gcorr1368 T519 T520 T519 T520 -1.0222781137470004e-07
Rt3753 T519 T2946 3349641.2496672384
Gcorr1369 T519 T5703 T519 T5703 -3.1010471100022136e-08
Rt3754 T519 T5899 4544574.9943498317
Gcorr1370 T519 T6012 T519 T6012 -1.5602033144371654e-07
Gcorr1371 T520 T521 T520 T521 -1.2799935970277266e-07
Gcorr1372 T520 T3712 T520 T3712 -5.5812466959722887e-07
Gcorr1373 T520 T4108 T520 T4108 -8.8398651937694008e-07
Rt3755 T520 T4217 7818449.95784296
Rt3756 T520 T6012 421153.56059790443
Gcorr1374 T521 T522 T521 T522 -8.7242952961427004e-08
Rt3757 T521 T2928 6522162.7721772203
Rt3758 T521 T4217 76393646.411094666
Rt3759 T521 T5910 4079489.0166147193
Gcorr1375 T522 T523 T522 T523 -7.3877193430986622e-08
Rt3760 T522 T3496 1571694.4379681114
Rt3761 T522 T4233 6823336.2311274251
Gcorr1376 T522 T5714 T522 T5714 -1.249222431473783e-07
Gcorr1377 T522 T5910 T522 T5910 -1.9004661636323271e-07
Gcorr1378 T523 T524 T523 T524 -5.6652871846804076e-08
Rt3762 T523 T2858 10246486.294675332
Rt3763 T523 T4233 8799049.4844461642
Rt3764 T523 T6074 3194998.8008581651
Gcorr1379 T524 T4107 T524 T4107 -2.911730803503963e-06
Rt3765 T524 T5965 357310.01500328764
Rt3766 T524 T6074 2183122.695967115
Rt3767 T525 T691 370759.60505575658
Rt3768 T525 T710 14116910.09538772
Rt3769 T525 T801 489246.44765081996
Rt3770 T525 T836 304107.35764885606
Rt3771 T525 T1453 111637961.56248407
Gcorr1380 T525 T2184 T525 T2184 -5.4065067731211012e-08
Rt3772 T525 T2229 2873569.9661980961
Rt3773 T525 T4807 111637961.55977701
Gcorr1381 T525 T5541 T525 T5541 -5.4065067730872854e-08
Rt3774 T525 T5584 2873569.9662026991
Rt3775 T526 T679 476618.77167199471
Rt3776 T526 T700 489515.72905419127
Rt3777 T526 T703 590653.20386327989
Rt3778 T526 T771 426836.76315985405
Gcorr1382 T526 T898 T526 T898 -4.0613765529057404e-08
Rt3779 T526 T1068 3132976.5429434963
Rt3780 T526 T2156 3457503.0776603902
Gcorr1383 T526 T2163 T526 T2163 -1.5591000958645303e-07
Gcorr1384 T526 T4252 T526 T4252 -4.0613765529058834e-08
Rt3781 T526 T4422 3132976.5429435
Rt3782 T526 T5512 3457503.0776603925
Gcorr1385 T526 T5519 T526 T5519 -1.5591000958645377e-07
Rt3783 T527 T674 566421.03078682208
Rt3784 T527 T701 580783.50882905407
Rt3785 T527 T702 362042.33624319342
Rt3786 T527 T770 435232.26327722269
Rt3787 T527 T1393 13827619.712291634
Rt3788 T527 T1527 3069557.3145725979
Gcorr1386 T527 T1703 T527 T1703 -4.1767557202250275e-07
Rt3789 T527 T2127 2317689.1878077723
Rt3790 T527 T4747 13827619.712280288
Rt3791 T527 T4881 3069557.3145795874
Gcorr1387 T527 T5057 T527 T5057 -4.1767557202305999e-07
Rt3792 T527 T5483 2317689.1878011283
Rt3793 T528 T678 487947.40472949133
Rt3794 T528 T679 475377.57780052884
Rt3795 T528 T705 552372.52982730127
Rt3796 T528 T706 506006.15989502391
Rt3797 T528 T1785 11760730.647267118
Rt3798 T528 T1794 3313142.8346214318
Gcorr1388 T528 T2163 T528 T2163 -1.5845939603296423e-07
Rt3799 T528 T2265 2995014.44637297
Gcorr1389 T528 T2567 T528 T2567 -1.4098931931565195e-07
Rt3800 T528 T5139 11760730.647262217
Rt3801 T528 T5149 3313142.8346207049
Gcorr1390 T528 T5519 T528 T5519 -1.5845939603290878e-07
Rt3802 T528 T5620 2995014.4463733309
Gcorr1391 T528 T5921 T528 T5921 -1.4098931931577159e-07
Rt3803 T529 T674 494605.64678069693
Rt3804 T529 T684 566382.61396615754
Rt3805 T529 T704 483868.91442705021
Rt3806 T529 T707 455202.1537419057
Rt3807 T529 T1673 19539703.774175595
Rt3808 T529 T1701 5899068.6232336015
Rt3809 T529 T1702 2625391.2802903722
Gcorr1392 T529 T1786 T529 T1786 -1.8029529919707067e-07
Rt3810 T529 T5027 19539703.774127681
Rt3811 T529 T5055 5899068.6231966047
Rt3812 T529 T5056 2625391.2802969716
Gcorr1393 T529 T5140 T529 T5140 -1.8029529919730464e-07
Rt3813 T530 T678 501373.62087468972
Rt3814 T530 T687 558375.78313574265
Rt3815 T530 T708 539939.64617475925
Rt3816 T530 T712 518910.93394119246
Rt3817 T530 T1943 4176811.7460003486
Rt3818 T530 T2106 13020727.521732662
Rt3819 T530 T2597 9461199.2281361036
Rt3820 T530 T5299 4176811.7460021209
Rt3821 T530 T5472 13020727.521730797
Rt3822 T530 T5951 9461199.2281282507
Rt3823 T531 T684 488347.91878886352
Rt3824 T531 T688 491858.22422955546
Rt3825 T531 T709 470447.48064043612
Rt3826 T531 T711 607286.87485679821
Rt3827 T531 T1104 12662934.131749619
Gcorr1394 T531 T2002 T531 T2002 -1.5362186414792888e-07
Rt3828 T531 T2038 8517218.0621059369
Rt3829 T531 T2189 2637447.0573835112
Rt3830 T531 T4458 12662934.131746087
Gcorr1395 T531 T5354 T531 T5354 -1.5362186414802664e-07
Rt3831 T531 T5391 8517218.0620339271
Rt3832 T531 T5546 2637447.0573899089
Rt3833 T532 T673 484348.35827377188
Rt3834 T532 T687 486430.50125686743
Rt3835 T532 T720 531996.42971337412
Rt3836 T532 T722 508517.43987204559
Rt3837 T532 T1232 4136855.0917640985
Gcorr1396 T532 T1253 T532 T1253 -1.278388660443251e-07
Rt3838 T532 T1344 2371366.2286788537
Gcorr1397 T532 T2107 T532 T2107 -1.1307191861491383e-07
Rt3839 T532 T4586 4136855.0917667113
Gcorr1398 T532 T4607 T532 T4607 -1.2783886604464245e-07
Rt3840 T532 T4698 2371366.2286764979
Gcorr1399 T532 T5463 T532 T5463 -1.1307191861486555e-07
Rt3841 T533 T676 483004.19371209887
Rt3842 T533 T688 560448.24523866863
Rt3843 T533 T719 469050.5282998117
Rt3844 T533 T721 629756.7541746723
Rt3845 T533 T1090 9245344.5575972367
Rt3846 T533 T1285 5178888.4909602217
Rt3847 T533 T2162 8246579.4539975524
Rt3848 T533 T4444 9245344.5575855505
Rt3849 T533 T4639 5178888.4909768701
Rt3850 T533 T5518 8246579.4539648304
Rt3851 T534 T676 550050.2577054298
Rt3852 T534 T682 348379.15391693159
Rt3853 T534 T725 463761.03044308018
Rt3854 T534 T729 650513.0903917253
Gcorr1400 T534 T1085 T534 T1085 -4.0346931783076585e-07
Rt3855 T534 T1086 2886572.8292603977
Rt3856 T534 T1089 16477062.044263048
Rt3857 T534 T2111 2384041.1333358465
Gcorr1401 T534 T4439 T534 T4439 -4.0346931783073991e-07
Rt3858 T534 T4440 2886572.8292597304
Rt3859 T534 T4443 16477062.044118062
Rt3860 T534 T5465 2384041.133339501
Rt3861 T535 T673 484435.58935301931
Rt3862 T535 T686 559337.35687526141
Rt3863 T535 T726 524425.09858071024
Rt3864 T535 T728 549099.91634055751
Rt3865 T535 T1224 3059224.4108741852
Gcorr1402 T535 T1225 T535 T1225 -1.6046329820923444e-07
Rt3866 T535 T1226 6788952.4650831688
Rt3867 T535 T1227 9141312.6310533471
Rt3868 T535 T4578 3059224.4108740343
Gcorr1403 T535 T4579 T535 T4579 -1.6046329820934869e-07
Rt3869 T535 T4580 6788952.4650841998
Rt3870 T535 T4581 9141312.6310435161
Rt3871 T536 T675 549600.80105158209
Rt3872 T536 T682 349208.33715244086
Rt3873 T536 T730 519816.49448522757
Rt3874 T536 T732 569414.8711283619
Rt3875 T536 T1080 13921679.006945707
Rt3876 T536 T1082 2547555.0622704998
Gcorr1404 T536 T1085 T536 T1085 -4.1238441978920223e-07
Rt3877 T536 T2113 2690274.7261303766
Rt3878 T536 T4434 13921679.007058535
Rt3879 T536 T4436 2547555.0622678082
Gcorr1405 T536 T4439 T536 T4439 -4.1238441978925257e-07
Rt3880 T536 T5464 2690274.7261288208
Rt3881 T537 T685 482492.28688234481
Rt3882 T537 T686 558520.23057436722
Rt3883 T537 T731 442784.05746658222
Rt3884 T537 T733 615752.85282927356
Rt3885 T537 T1220 9096181.3928987607
Rt3886 T537 T1221 9060291.8218895607
Rt3887 T537 T1222 2885158.3407270983
Gcorr1406 T537 T2394 T537 T2394 -1.4322092110324234e-07
Rt3888 T537 T4574 8256620.0351704573
Rt3889 T537 T4575 9060291.8219009433
Rt3890 T537 T4576 5202864.538167241
Rt3891 T538 T675 482249.49641474907
Rt3892 T538 T683 553895.50573214563
Rt3893 T538 T734 511597.80881581036
Rt3894 T538 T737 574046.3712071582
Rt3895 T538 T1069 7393597.3138066763
Rt3896 T538 T1070 6149460.5567659549
Rt3897 T538 T1079 7912125.7282839082
Rt3898 T538 T4423 7393597.3138405997
Rt3899 T538 T4424 6149460.5567393741
Rt3900 T538 T4433 7912125.7282892419
Rt3901 T539 T680 552539.23453104659
Rt3902 T539 T685 481598.20194942114
Rt3903 T539 T735 507878.21612909727
Rt3904 T539 T738 363700.3907037375
Gcorr1407 T539 T1214 T539 T1214 -5.4102704482847747e-07
Rt3905 T539 T1216 1243233.4688867547
Rt3906 T539 T1217 3980454.9475663314
Gcorr1408 T539 T1219 T539 T1219 -9.0298335409515168e-08
Gcorr1409 T539 T4568 T539 T4568 -5.4102704482854512e-07
Rt3907 T539 T4570 1243233.4688866118
Rt3908 T539 T4571 3980454.9475649837
Gcorr1410 T539 T4573 T539 T4573 -9.0298335409627942e-08
Rt3909 T540 T681 552736.12844067451
Rt3910 T540 T683 484615.89406021172
Rt3911 T540 T739 446012.84273180692
Rt3912 T540 T742 514976.94924359751
Rt3913 T540 T1060 2499869.9382994683
Gcorr1411 T540 T1062 T540 T1062 -1.9297510920215523e-07
Rt3914 T540 T1063 7110675.4247262487
Rt3915 T540 T2131 12964649.434078149
Rt3916 T540 T4414 2499869.9383025854
Gcorr1412 T540 T4416 T540 T4416 -1.9297510920234134e-07
Rt3917 T540 T4417 7110675.4246914415
Rt3918 T540 T5487 12964649.434079215
Rt3919 T541 T677 453217.76709915127
Rt3920 T541 T680 551297.20667641482
Rt3921 T541 T740 437170.36108237482
Rt3922 T541 T741 698858.7392885664
Rt3923 T541 T1211 2759863.9173948746
Rt3924 T541 T1213 8307400.4578180341
Rt3925 T541 T1215 8879209.9839434419
Gcorr1413 T541 T2128 T541 T2128 -1.7052179663480368e-07
Rt3926 T541 T4565 2759863.917391581
Rt3927 T541 T4567 8307400.4578294819
Rt3928 T541 T4569 8879209.9839586243
Gcorr1414 T541 T5484 T541 T5484 -1.7052179663488057e-07
Rt3929 T542 T629 3475786.5018221233
Rt3930 T542 T677 469041.26983930689
Rt3931 T542 T743 348929.86380071746
Rt3932 T542 T839 254647.38152948453
Rt3933 T542 T1206 20689924.194373194
Rt3934 T542 T1209 13975543.952040397
Rt3935 T542 T2126 2291563.7435105918
Gcorr1415 T542 T2128 T542 T2128 -1.4490509077704486e-07
Rt3936 T542 T4560 20689924.194388386
Rt3937 T542 T4563 13975543.952050542
Rt3938 T542 T5482 2291563.7435097857
Gcorr1416 T542 T5484 T542 T5484 -1.4490509077711371e-07
Rt3939 T543 T649 333955.5427420552
Rt3940 T543 T693 446322.71839364019
Rt3941 T543 T806 295704.47461400047
Rt3942 T543 T824 26743511.544296596
Rt3943 T543 T1812 834194.48738235328
Gcorr1417 T543 T2337 T543 T2337 -4.7683139637403434e-07
Gcorr1418 T543 T2631 T543 T2631 -4.1249739598627939e-07
Rt3944 T543 T5167 834194.48738236097
Gcorr1419 T543 T5690 T543 T5690 -4.7683139637394916e-07
Gcorr1420 T543 T5985 T543 T5985 -4.1249739598635573e-07
Rt3945 T544 T630 1243314.630333252
Rt3946 T544 T698 744584.00590286101
Rt3947 T544 T809 311942.55501077836
Rt3948 T544 T823 527712.58842159633
Rt3949 T544 T830 437826.39671650878
Gcorr1421 T544 T1815 T544 T1815 -3.9020883276078241e-08
Gcorr1422 T544 T2091 T544 T2091 -5.806171731494032e-07
Rt3950 T544 T2274 943025.56929524918
Gcorr1423 T544 T2495 T544 T2495 -9.7458773430244188e-08
Gcorr1424 T544 T5170 T544 T5170 -3.9020883276022747e-08
Gcorr1425 T544 T5444 T544 T5444 -5.8061717314951797e-07
Rt3951 T544 T5628 943025.56929530622
Gcorr1426 T544 T5849 T544 T5849 -9.7458773430123009e-08
Rt3952 T545 T648 407918.56218210672
Rt3953 T545 T760 386336.29947011062
Rt3954 T545 T811 313996.95521926397
Rt3955 T545 T832 6272449.3993556295
Rt3956 T545 T1140 37273968.763877504
Rt3957 T545 T2144 12009840.31735485
Rt3958 T545 T2259 3475944.110692319
Gcorr1427 T545 T2644 T545 T2644 -6.5547343141433986e-08
Rt3959 T545 T4494 37273968.763624504
Rt3960 T545 T5501 12009840.317385603
Rt3961 T545 T5614 3475944.1106912261
Gcorr1428 T545 T5998 T545 T5998 -6.5547343141495449e-08
Rt3962 T546 T621 7460965.0909597781
Rt3963 T546 T697 242235.70842989991
Rt3964 T546 T698 776574.2901035354
Rt3965 T546 T834 112084.79933473447
Rt3966 T546 T844 631920.77211588027
Gcorr1429 T546 T1233 T546 T1233 -2.4924212713521178e-06
Rt3967 T546 T1517 300671.9488223177
Gcorr1430 T546 T2158 T546 T2158 -3.7804000102272693e-09
Gcorr1431 T546 T2246 T546 T2246 -4.5104309654174327e-07
Gcorr1432 T546 T4587 T546 T4587 -2.4924212713580733e-06
Rt3968 T546 T4871 300671.94882176025
Gcorr1433 T546 T5514 T546 T5514 -3.7804000103069532e-09
Gcorr1434 T546 T5601 T546 T5601 -4.5104309654187742e-07
Gcorr1435 T547 T631 T547 T631 -2.6102668961471551e-08
Rt3969 T547 T640 442828.74924475455
Rt3970 T547 T716 351564.74045350705
Rt3971 T547 T800 210953.27458692837
Gcorr1436 T547 T1693 T547 T1693 -1.7226774295021533e-07
Rt3972 T547 T1700 983460.80515227455
Gcorr1437 T547 T1865 T547 T1865 -5.3032405265296016e-07
Gcorr1438 T547 T5047 T547 T5047 -1.722677429503448e-07
Rt3973 T547 T5054 983460.80515123799
Gcorr1439 T547 T5220 T547 T5220 -5.3032405265390439e-07
Rt3974 T548 T620 325315.36958579905
Rt3975 T548 T646 722386.46593230113
Rt3976 T548 T789 315187.14382128161
Rt3977 T548 T819 823359.17961634952
Gcorr1440 T548 T1195 T548 T1195 -1.5539066843226532e-07
Rt3978 T548 T1198 3558445.6441925247
Rt3979 T548 T1199 1643790.1938252307
Gcorr1441 T548 T1200 T548 T1200 -4.1852054029276568e-07
Gcorr1442 T548 T4549 T548 T4549 -1.553906684322779e-07
Rt3980 T548 T4552 3558445.6441920511
Rt3981 T548 T4553 1643790.1938242002
Gcorr1443 T548 T4554 T548 T4554 -4.185205402931739e-07
Rt3982 T549 T622 1635248.2141247187
Rt3983 T549 T634 1234719.0488346282
Rt3984 T549 T764 212404.5068297195
Rt3985 T549 T796 501664.72654072742
Rt3986 T549 T822 579717.95963246841
Gcorr1444 T549 T1047 T549 T1047 -1.0002715068240439e-07
Rt3987 T549 T1048 1706452353.2161868
Gcorr1445 T549 T1472 T549 T1472 -8.1836945362456294e-07
Rt3988 T549 T2235 757389.15776308649
Gcorr1446 T549 T4401 T549 T4401 -1.000271506826726e-07
Rt3989 T549 T4402 1706452352.2689381
Gcorr1447 T549 T4826 T549 T4826 -8.1836945362482319e-07
Rt3990 T549 T5590 757389.15776297147
Rt3991 T550 T664 589565.13806993316
Rt3992 T550 T691 538453.37067253527
Rt3993 T550 T710 525775.75679146696
Rt3994 T550 T742 328902.17170088313
Gcorr1448 T550 T1062 T550 T1062 -4.1365504690621656e-07
Rt3995 T550 T1066 2843237.20881104
Rt3996 T550 T2100 18107853.283836532
Rt3997 T550 T2157 2353188.1694473731
Gcorr1449 T550 T4416 T550 T4416 -4.1365504690606637e-07
Rt3998 T550 T4420 2843237.2088086978
Rt3999 T550 T5453 18107853.283867087
Rt4000 T550 T5513 2353188.169449308
Rt4001 T551 T631 2385489.6708491188
Rt4002 T551 T717 447983.08466057939
Rt4003 T551 T800 304635.63250677602
Rt4004 T551 T809 377631.54318005027
Gcorr1450 T551 T1865 T551 T1865 -6.0782802026535893e-08
Rt4005 T551 T2034 1871542.3621074343
Gcorr1451 T551 T2373 T551 T2373 -3.5555887277492379e-08
Gcorr1452 T551 T2495 T551 T2495 -1.3774813234454526e-07
Gcorr1453 T551 T5220 T551 T5220 -6.0782802026385783e-08
Rt4006 T551 T5387 1871542.3621071454
Gcorr1454 T551 T5727 T551 T5727 -3.5555887277594837e-08
Gcorr1455 T551 T5849 T551 T5849 -1.3774813234467751e-07
Rt4007 T552 T642 1073866.0088168997
Rt4008 T552 T671 550787.68391505338
Rt4009 T552 T718 452550.6680095655
Rt4010 T552 T806 338952.65683862963
Gcorr1456 T552 T1374 T552 T1374 -9.3403416711845741e-08
Rt4011 T552 T1545 4002733.1324394858
Rt4012 T552 T1674 3548994.945902749
Gcorr1457 T552 T2631 T552 T2631 -1.2141589252394516e-07
Gcorr1458 T552 T4728 T552 T4728 -9.3403416711920902e-08
Rt4013 T552 T4899 4002733.1324335835
Rt4014 T552 T5028 3548994.9459071024
Gcorr1459 T552 T5985 T552 T5985 -1.2141589252389489e-07
Rt4015 T553 T645 905744.68606176483
Rt4016 T553 T772 386826.29240953538
Rt4017 T553 T773 371535.00570626429
Rt4018 T553 T805 617416.60046117648
Rt4019 T553 T1789 7911805.5891684694
Gcorr1460 T553 T1946 T553 T1946 -4.453720179786384e-07
Gcorr1461 T553 T2085 T553 T2085 -2.1709492978431638e-07
Rt4020 T553 T2723 1163635.8958787068
Rt4021 T553 T5144 7911805.5891618086
Gcorr1462 T553 T5302 T553 T5302 -4.4537201797878027e-07
Gcorr1463 T553 T5439 T553 T5439 -2.1709492978399054e-07
Rt4022 T553 T6078 1163635.8958791029
Rt4023 T554 T655 483341.289346112
Rt4024 T554 T700 391799.32238387835
Rt4025 T554 T747 296361.65751195775
Rt4026 T554 T840 1597323.4787135958
Rt4027 T554 T899 4065854.647287095
Gcorr1464 T554 T900 T554 T900 -1.4002478273985923e-07
Rt4028 T554 T901 3804102.3770424416
Rt4029 T554 T2140 37438689.568491414
Rt4030 T554 T4253 4065854.6472871085
Gcorr1465 T554 T4254 T554 T4254 -1.4002478273986011e-07
Rt4031 T554 T4255 3804102.3770424402
Rt4032 T554 T5496 37438689.568492986
Rt4033 T555 T659 493108.38190217572
Rt4034 T555 T701 392988.80502311495
Rt4035 T555 T748 288215.72446783184
Rt4036 T555 T841 1540059.0837485739
Rt4037 T555 T1500 1776382.7311537638
Gcorr1466 T555 T2032 T555 T2032 -1.7962336558136201e-07
Gcorr1467 T555 T2161 T555 T2161 -6.7351893754735859e-08
Rt4038 T555 T2213 12571671.400740873
Rt4039 T555 T4854 1776382.7311507021
Gcorr1468 T555 T5385 T555 T5385 -1.7962336558146019e-07
Gcorr1469 T555 T5517 T555 T5517 -6.7351893754918937e-08
Rt4040 T555 T5569 12571671.40085021
Rt4041 T556 T765 367369.59023639467
Rt4042 T556 T793 351698.21618502517
Rt4043 T556 T796 370299.48226333986
Rt4044 T556 T831 29522698.140565179
Gcorr1470 T556 T1050 T556 T1050 -6.9536336719389207e-08
Rt4045 T556 T1051 7660582.9123350494
Rt4046 T556 T1052 4299696.3358985763
Gcorr1471 T556 T4404 T556 T4404 -6.953633671935477e-08
Rt4047 T556 T4405 7660582.9123763293
Rt4048 T556 T4406 4299696.3358862465
Rt4049 T557 T657 495518.53159632784
Rt4050 T557 T659 565830.99394179427
Rt4051 T557 T702 383151.29779843224
Rt4052 T557 T704 489658.84889330924
Gcorr1472 T557 T1103 T557 T1103 -1.9365234002171465e-07
Gcorr1473 T557 T1703 T557 T1703 -3.2500198368913082e-07
Rt4053 T557 T2209 1162580.4753934119
Rt4054 T557 T2391 12575360.230350785
Gcorr1474 T557 T4457 T557 T4457 -1.9365234002198687e-07
Gcorr1475 T557 T5057 T557 T5057 -3.2500198368918143e-07
Rt4055 T557 T5565 1162580.4753916196
Rt4056 T557 T5747 12575360.230509901
Rt4057 T558 T655 481985.54712601478
Rt4058 T558 T666 483065.89053539146
Rt4059 T558 T703 566391.87272933067
Rt4060 T558 T705 564558.60714771494
Rt4061 T558 T902 9131694.2038617972
Gcorr1476 T558 T905 T558 T905 -4.8563476142858071e-08
Rt4062 T558 T2136 2777187.3052181294
Rt4063 T558 T4256 9131694.2038690113
Gcorr1477 T558 T4259 T558 T4259 -4.8563476142944131e-08
Rt4064 T558 T5492 2777187.3052168204
Rt4065 T559 T656 487616.42295061733
Rt4066 T559 T666 485565.98912143148
Rt4067 T559 T706 478131.13089007372
Rt4068 T559 T708 562817.75755929574
Rt4069 T559 T1394 3432358.6972099817
Gcorr1478 T559 T1488 T559 T1488 -1.3764120338616407e-07
Rt4070 T559 T1532 3026451.6726578739
Gcorr1479 T559 T1704 T559 T1704 -6.3726787507445627e-08
Rt4071 T559 T4748 3432358.6972099841
Gcorr1480 T559 T4842 T559 T4842 -1.3764120338616497e-07
Rt4072 T559 T4886 3026451.6726578777
Gcorr1481 T559 T5058 T559 T5058 -6.372678750744699e-08
Rt4073 T560 T657 576229.95964449283
Rt4074 T560 T661 506249.94776060589
Rt4075 T560 T707 322702.89551006816
Rt4076 T560 T709 561923.08393867349
Rt4077 T560 T1097 13089134.750425067
Gcorr1482 T560 T1786 T560 T1786 -5.1259149413353901e-07
Rt4078 T560 T2262 1706706.5613441532
Rt4079 T560 T2309 3694600.7065251311
Rt4080 T560 T4451 13089134.750426736
Gcorr1483 T560 T5140 T560 T5140 -5.1259149413292248e-07
Rt4081 T560 T5617 1706706.5613438492
Rt4082 T560 T5663 3694600.706534877
Rt4083 T561 T653 661762.22144203354
Rt4084 T561 T744 707843.11558031454
Rt4085 T561 T746 507728.38797080284
Rt4086 T561 T789 356155.63617018383
Gcorr1484 T561 T1193 T561 T1193 -1.5650984487493901e-07
Rt4087 T561 T1194 1693361.055349747
Rt4088 T561 T1195 20236874.528845981
Gcorr1485 T561 T2275 T561 T2275 -1.6140841063763853e-07
Gcorr1486 T561 T4547 T561 T4547 -1.5650984487506606e-07
Rt4089 T561 T4548 1693361.0553494385
Rt4090 T561 T4549 20236874.528844934
Gcorr1487 T561 T5629 T561 T5629 -1.6140841063762368e-07
Rt4091 T562 T661 579553.5542729419
Rt4092 T562 T668 502634.13098509941
Rt4093 T562 T711 485330.35435214511
Rt4094 T562 T719 558816.61936218361
Rt4095 T562 T1092 7636837.5233137179
Rt4096 T562 T1093 7579427.5298903929
Rt4097 T562 T1094 6373339.4173338003
Rt4098 T562 T4446 7636837.5233518546
Rt4099 T562 T4447 7579427.5298822559
Rt4100 T562 T4448 6373339.4173131064
Rt4101 T563 T656 513291.00512619852
Rt4102 T563 T669 580309.84605305071
Rt4103 T563 T712 484013.523328493
Rt4104 T563 T720 483145.00501713739
Rt4105 T563 T1868 4786107.5153262485
Rt4106 T563 T2005 17093737.398838259
Gcorr1488 T563 T2386 T563 T2386 -1.456048134424885e-07
Rt4107 T563 T2696 3356270.5692892889
Rt4108 T563 T5223 4786107.5153314341
Rt4109 T563 T5357 17093737.398730833
Gcorr1489 T563 T5742 T563 T5742 -1.456048134428e-07
Rt4110 T563 T6050 3356270.569287403
Rt4111 T564 T727 211070.12151836485
Rt4112 T564 T762 401341.02696311305
Rt4113 T564 T829 359337.31360405177
Rt4114 T564 T1745 1447075.3414074942
Gcorr1490 T564 T1912 T564 T1912 -6.5070679823343049e-07
Rt4115 T564 T2168 4453671.5652846051
Rt4116 T564 T5099 1447075.3414056434
Gcorr1491 T564 T5269 T564 T5269 -6.5070679823379164e-07
Rt4117 T564 T5524 4453671.5652950061
Rt4118 T565 T658 269048.46691843483
Rt4119 T565 T668 575927.04833972792
Rt4120 T565 T721 488598.5979374561
Rt4121 T565 T725 558858.51826028724
Gcorr1492 T565 T1087 T565 T1087 -7.3954042356804842e-07
Rt4122 T565 T1088 3117931.2173422193
Rt4123 T565 T1091 33243380.96088931
Gcorr1493 T565 T2039 T565 T2039 -2.7817653000393647e-06
Rt4124 T565 T2716 278576.18397823191
Gcorr1494 T565 T4441 T565 T4441 -7.3954042356697237e-07
Rt4125 T565 T4442 3117931.2173484694
Rt4126 T565 T4445 33243380.960371014
Gcorr1495 T565 T5392 T565 T5392 -2.781765299978892e-06
Rt4127 T565 T6071 278576.18398299511
Rt4128 T566 T654 427109.4493922845
Rt4129 T566 T669 509399.98352934333
Rt4130 T566 T722 468158.69361123332
Rt4131 T566 T726 558520.45395858039
Rt4132 T566 T1790 3054440.2648882451
Gcorr1496 T566 T2204 T566 T2204 -1.1943624991939702e-07
Rt4133 T566 T2479 2865022.5907167089
Gcorr1497 T566 T2535 T566 T2535 -1.3781011595956051e-07
Rt4134 T566 T5145 2746559.9619554006
Gcorr1498 T566 T5527 T566 T5527 -3.9371184462314982e-07
Gcorr1499 T566 T5781 T566 T5781 -9.3263413179416599e-09
Rt4135 T566 T5846 1673510.122044134
Gcorr1500 T566 T5908 T566 T5908 -1.3941681072207611e-07
Rt4136 T567 T658 507464.77382931497
Rt4137 T567 T662 571818.29041796096
Rt4138 T567 T729 488269.08862175711
Rt4139 T567 T730 486524.81041103008
Rt4140 T567 T1083 13313022.399009457
Rt4141 T567 T1084 4569198.1328683542
Gcorr1501 T567 T1087 T567 T1087 -7.8213011231280414e-08
Rt4142 T567 T2022 10648322.216917686
Rt4143 T567 T2700 9180631.4066098575
Rt4144 T567 T4437 13313022.399107171
Rt4145 T567 T4438 4569198.1328769615
Gcorr1502 T567 T4441 T567 T4441 -7.8213011231064077e-08
Rt4146 T567 T5375 10648322.216923626
Rt4147 T567 T6054 9180631.4065426979
Rt4148 T568 T654 572895.25164664548
Rt4149 T568 T665 535729.40428144438
Rt4150 T568 T728 479682.6236528568
Rt4151 T568 T731 466974.37239978724
Gcorr1503 T568 T1670 T568 T1670 -1.3636881189455284e-07
Rt4152 T568 T1978 2547361.3248046404
Rt4153 T568 T2090 3667714.8137039444
Gcorr1504 T568 T2407 T568 T2407 -1.1024892643912579e-07
Gcorr1505 T568 T4637 T568 T4637 -1.1514272976693051e-07
Gcorr1506 T568 T5116 T568 T5116 -4.492941351491933e-07
Rt4154 T568 T5462 14657976.45070806
Rt4155 T568 T5527 6192025.7584429225
Rt4156 T568 T5717 1327472.5240323832
Rt4157 T569 T660 583876.96257541061
Rt4158 T569 T662 500293.73978815088
Rt4159 T569 T732 552931.94333284732
Rt4160 T569 T734 484896.10124752414
Rt4161 T569 T1081 10364034.09534912
Rt4162 T569 T1534 2420503.9702217965
Rt4163 T569 T2119 3067596.2014189744
Gcorr1507 T569 T2254 T569 T2254 -4.1759454687529256e-07
Rt4164 T569 T4435 10364034.095360542
Rt4165 T569 T4888 2420503.9702183451
Rt4166 T569 T5476 3067596.2014227863
Gcorr1508 T569 T5609 T569 T5609 -4.1759454687537329e-07
Rt4167 T570 T663 503061.45368857885
Rt4168 T570 T665 504234.77313604142
Rt4169 T570 T733 556634.77297302766
Rt4170 T570 T735 478746.96771207137
Rt4171 T570 T1283 2905119.4423958124
Rt4172 T570 T1953 5817909.9538841536
Gcorr1509 T570 T2366 T570 T2366 -6.6205007686935794e-08
Gcorr1510 T570 T2405 T570 T2405 -3.1879721449492412e-08
Rt4173 T570 T5274 5232552.4115449516
Gcorr1511 T570 T5364 T570 T5364 -1.6044111782569816e-08
Gcorr1512 T570 T5721 T570 T5721 -6.5432262344046688e-08
Rt4174 T570 T5741 3242717.9330306184
Rt4175 T571 T644 430503.31328311516
Rt4176 T571 T745 272583.5186700031
Rt4177 T571 T764 325401.42199316644
Rt4178 T571 T1261 2797716.0312903449
Gcorr1513 T571 T1472 T571 T1472 -8.3675520726589501e-08
Rt4179 T571 T1762 6658849.4794586292
Gcorr1514 T571 T1974 T571 T1974 -1.483070428881975e-07
Rt4180 T571 T4615 2797716.0312868645
Gcorr1515 T571 T4826 T571 T4826 -8.3675520726264346e-08
Rt4181 T571 T5117 6658849.4794726344
Gcorr1516 T571 T5328 T571 T5328 -1.4830704288865331e-07
Rt4182 T572 T660 510440.65702052956
Rt4183 T572 T664 512150.44625710236
Rt4184 T572 T737 543510.11042480543
Rt4185 T572 T739 484465.68787028495
Rt4186 T572 T1064 6243578.2093860684
Rt4187 T572 T1065 20434498.441859551
Gcorr1517 T572 T1067 T572 T1067 -1.7951753428757098e-07
Rt4188 T572 T2198 2578183.1886306792
Rt4189 T572 T4418 6243578.2094109003
Rt4190 T572 T4419 20434498.441861935
Gcorr1518 T572 T4421 T572 T4421 -1.7951753428740353e-07
Rt4191 T572 T5555 2578183.1886275392
Rt4192 T573 T663 517093.24608972587
Rt4193 T573 T667 503804.42910963926
Rt4194 T573 T738 340406.17672576971
Rt4195 T573 T740 475064.55421703152
Rt4196 T573 T1212 19922018.721433364
Gcorr1519 T573 T1214 T573 T1214 -4.435597708437536e-07
Rt4197 T573 T1218 1091548.8322503252
Gcorr1520 T573 T2389 T573 T2389 -1.0531144978149807e-07
Rt4198 T573 T4566 19922018.721514031
Gcorr1521 T573 T4568 T573 T4568 -4.4355977084371083e-07
Rt4199 T573 T4572 747622.43274735101
Gcorr1522 T573 T5745 T573 T5745 -1.0531144978134963e-07
Gcorr1523 T573 T6067 T573 T6067 -4.2144414017297835e-07
Rt4200 T574 T625 906281.7088898489
Rt4201 T574 T724 348727.94598421291
Rt4202 T574 T763 432776.21419825172
Rt4203 T574 T828 356308.96932975616
Gcorr1524 T574 T1155 T574 T1155 -6.3767881872830093e-07
Rt4204 T574 T2123 636480.17992652324
Gcorr1525 T574 T2331 T574 T2331 -6.0548999298105164e-07
Gcorr1526 T574 T4509 T574 T4509 -6.3767881872893493e-07
Rt4205 T574 T5479 636480.17992661521
Gcorr1527 T574 T5684 T574 T5684 -6.0548999298019285e-07
Rt4206 T575 T651 864727.11555952439
Rt4207 T575 T667 504729.93235119421
Rt4208 T575 T741 551380.76108221209
Rt4209 T575 T743 426765.25470122811
Rt4210 T575 T1208 7630665.1493793596
Rt4211 T575 T1210 8510288.5840328243
Rt4212 T575 T2436 5233520.7512037717
Rt4213 T575 T4562 7630665.1493791724
Rt4214 T575 T4564 8510288.5840291642
Rt4215 T575 T5790 5233520.7512053251
Rt4216 T576 T752 266665.24371005979
Rt4217 T576 T754 331933.31606335554
Rt4218 T576 T781 353321.70238965307
Gcorr1528 T576 T1174 T576 T1174 -2.6395945141772542e-07
Rt4219 T576 T1831 16859051.945076786
Rt4220 T576 T1923 4248161.3454692643
Rt4221 T576 T2574 2904609.2359073544
Gcorr1529 T576 T2711 T576 T2711 -1.0199001399161404e-07
Gcorr1530 T576 T4528 T576 T4528 -2.6395945141815561e-07
Rt4222 T576 T5186 16859051.945043512
Rt4223 T576 T5279 4248161.3454634193
Rt4224 T576 T5928 2904609.235906844
Gcorr1531 T576 T6065 T576 T6065 -1.0199001399168718e-07
Rt4225 T577 T626 571409.23639448441
Rt4226 T577 T652 615738.56363397848
Rt4227 T577 T715 519621.13002664997
Rt4228 T577 T772 439050.14667419106
Gcorr1532 T577 T1033 T577 T1033 -1.4041728550517308e-07
Rt4229 T577 T1911 3705004.8810145329
Rt4230 T577 T2036 3433308.7669427614
Gcorr1533 T577 T2037 T577 T2037 -9.9243417846184248e-08
Gcorr1534 T577 T4387 T577 T4387 -1.4041728550503345e-07
Rt4231 T577 T5268 3705004.8810161673
Rt4232 T577 T5389 3433308.7669412117
Gcorr1535 T577 T5390 T577 T5390 -9.9243417846338395e-08
Rt4233 T578 T638 1373766.8397804112
Rt4234 T578 T648 429169.21162995038
Rt4235 T578 T775 463759.96955679328
Rt4236 T578 T832 266013.01241922559
Rt4237 T578 T1139 3335785.589524643
Gcorr1536 T578 T1140 T578 T1140 -3.560978764978385e-08
Rt4238 T578 T1141 20466434.576758068
Rt4239 T578 T4493 3335785.5895233098
Gcorr1537 T578 T4494 T578 T4494 -3.5609787649924034e-08
Rt4240 T578 T4495 20466434.576750401
Rt4241 T579 T641 738841.32908992376
Rt4242 T579 T653 425672.16031369346
Rt4243 T579 T778 452135.59137178631
Rt4244 T579 T825 445934.06729982642
Gcorr1538 T579 T1190 T579 T1190 -2.1499172389350803e-07
Rt4245 T579 T1192 17547691.171973243
Rt4246 T579 T1228 1431072.7104380801
Gcorr1539 T579 T2313 T579 T2313 -1.880942869766014e-07
Gcorr1540 T579 T4544 T579 T4544 -2.1499172389359959e-07
Rt4247 T579 T4546 17547691.172010668
Rt4248 T579 T4582 1431072.7104377148
Gcorr1541 T579 T5667 T579 T5667 -1.8809428697656884e-07
Rt4249 T580 T624 1260518.1534174955
Rt4250 T580 T753 308727.37370739959
Rt4251 T580 T759 321210.67202711571
Rt4252 T580 T818 293848.99151590443
Gcorr1542 T580 T1418 T580 T1418 -5.8285170660473028e-07
Rt4253 T580 T1419 613028.76591751736
Gcorr1543 T580 T1421 T580 T1421 -4.3127331274618565e-07
Gcorr1544 T580 T2186 T580 T2186 -2.8162294949278239e-07
Gcorr1545 T580 T4772 T580 T4772 -5.8285170660518736e-07
Rt4254 T580 T4773 613028.76591740607
Gcorr1546 T580 T4775 T580 T4775 -4.3127331274639502e-07
Gcorr1547 T580 T5543 T580 T5543 -2.8162294949241451e-07
Rt4255 T581 T701 1774204.0535416084
Rt4256 T581 T748 308263.51468895422
Rt4257 T581 T770 325074.96637148614
Rt4258 T581 T843 477459.46204785979
Gcorr1548 T581 T1314 T581 T1314 -1.3469048764280016e-07
Rt4259 T581 T1316 3185052.7659355993
Gcorr1549 T581 T2137 T581 T2137 -7.1091660218040187e-08
Rt4260 T581 T2161 3684876.0570959221
Gcorr1550 T581 T4668 T581 T4668 -1.3469048764247951e-07
Rt4261 T581 T4670 3185052.7659298051
Gcorr1551 T581 T5493 T581 T5493 -7.1091660218612172e-08
Rt4262 T581 T5517 3684876.0571003007
Rt4263 T582 T700 1072375.6416504725
Rt4264 T582 T747 242922.12646089852
Rt4265 T582 T771 365554.97022483376
Rt4266 T582 T842 545549.98059890454
Rt4267 T582 T897 645748.31139609392
Gcorr1552 T582 T899 T582 T899 -3.5934274090911255e-07
Gcorr1553 T582 T1076 T582 T1076 -4.0026815501559367e-07
Gcorr1554 T582 T2165 T582 T2165 -4.0941612648634477e-07
Rt4268 T582 T4251 645748.31139609194
Gcorr1555 T582 T4253 T582 T4253 -3.5934274090911456e-07
Gcorr1556 T582 T4430 T582 T4430 -4.0026815501559631e-07
Gcorr1557 T582 T5521 T582 T5521 -4.0941612648634726e-07
Rt4269 T583 T694 465663.15548997431
Rt4270 T583 T695 897594.36212687404
Rt4271 T583 T758 434526.13988584362
Rt4272 T583 T769 475540.94512725913
Rt4273 T583 T1254 7471745.6476040287
Rt4274 T583 T2354 18040651.795864768
Rt4275 T583 T2355 6552100.0375942513
Rt4276 T583 T4608 7471745.6476063048
Rt4277 T583 T5707 18040651.795976561
Rt4278 T583 T5708 6552100.0375778554
Rt4279 T584 T761 370954.46049041022
Rt4280 T584 T777 344336.80000987783
Rt4281 T584 T835 286973.19039129681
Rt4282 T584 T1149 6611878.8889634702
Gcorr1558 T584 T1151 T584 T1151 -1.0744161736490206e-07
Rt4283 T584 T1274 16964356.664879624
Rt4284 T584 T2720 6582888.2517022425
Rt4285 T584 T4503 6611878.8889859421
Gcorr1559 T584 T4505 T584 T4505 -1.0744161736493459e-07
Rt4286 T584 T4628 16964356.664747711
Rt4287 T584 T6075 6582888.2516984958
Rt4288 T585 T633 1772043.8173763514
Rt4289 T585 T751 296937.89918043488
Rt4290 T585 T786 431527.12010050478
Rt4291 T585 T816 372330.88996604836
Gcorr1560 T585 T1619 T585 T1619 -1.1838275089896651e-07
Rt4292 T585 T1806 11320204.622171788
Gcorr1561 T585 T2087 T585 T2087 -3.4205234168712482e-07
Rt4293 T585 T2548 10956273.451039759
Rt4294 T585 T2649 1613593.8431062836
Gcorr1562 T585 T4973 T585 T4973 -1.1838275089884973e-07
Rt4295 T585 T5161 11320204.622163681
Gcorr1563 T585 T5441 T585 T5441 -3.4205234168720677e-07
Rt4296 T585 T5901 10956273.451052438
Rt4297 T585 T6003 1613593.8431062701
Rt4298 T586 T696 4017945.3366406951
Rt4299 T586 T755 449910.37729997851
Rt4300 T586 T780 285922.19637129694
Rt4301 T586 T833 254002.15166521946
Rt4302 T586 T1774 2554441.5622430984
Rt4303 T586 T1775 16067049.378610276
Rt4304 T586 T1776 4093674.1197944349
Gcorr1564 T586 T2459 T586 T2459 -3.7298115420336848e-07
Rt4305 T586 T5128 2554441.5622411855
Rt4306 T586 T5129 16067049.378609149
Rt4307 T586 T5130 4093674.1198024531
Gcorr1565 T586 T5813 T586 T5813 -3.7298115420318965e-07
Rt4308 T587 T624 3973931.6589831002
Rt4309 T587 T757 381643.00919619354
Rt4310 T587 T759 277111.16278572899
Rt4311 T587 T784 307754.74453819945
Gcorr1566 T587 T1418 T587 T1418 -3.0409616950241836e-08
Gcorr1567 T587 T1420 T587 T1420 -4.6083172462481871e-07
Gcorr1568 T587 T1787 T587 T1787 -7.1395646885207292e-08
Rt4312 T587 T2179 1105388.711824873
Gcorr1569 T587 T4772 T587 T4772 -3.0409616949832243e-08
Gcorr1570 T587 T4774 T587 T4774 -4.6083172462509982e-07
Gcorr1571 T587 T5141 T587 T5141 -7.1395646885127962e-08
Rt4313 T587 T5536 1105388.7118251296
Rt4314 T588 T628 5168512.9939213507
Rt4315 T588 T636 907678.11808407842
Rt4316 T588 T671 537740.48562196922
Rt4317 T588 T795 412856.77626904822
Rt4318 T588 T814 365610.76766530465
Rt4319 T588 T997 3282582.5124609843
Gcorr1572 T588 T1078 T588 T1078 -1.7599194969149399e-07
Rt4320 T588 T2142 4066430.2626265041
Rt4321 T588 T2249 12054894.705327684
Rt4322 T588 T4351 3282582.5124635049
Gcorr1573 T588 T4432 T588 T4432 -1.7599194969152104e-07
Rt4323 T588 T5498 4066430.2626199424
Rt4324 T588 T5604 12054894.705347868
Rt4325 T589 T644 426027.00071347633
Rt4326 T589 T713 587311.93118960736
Rt4327 T589 T723 448991.37187707756
Rt4328 T589 T826 360744.17549381277
Gcorr1574 T589 T1508 T589 T1508 -1.3038538196966195e-07
Gcorr1575 T589 T1974 T589 T1974 -4.4394053640539614e-07
Rt4329 T589 T1998 1537831.1091800311
Rt4330 T589 T2205 3840096.1219349233
Gcorr1576 T589 T4862 T589 T4862 -1.3038538197016702e-07
Gcorr1577 T589 T5328 T589 T5328 -4.4394053640541266e-07
Rt4331 T589 T5350 1537831.1091775517
Rt4332 T589 T5561 3840096.121942725
Rt4333 T590 T672 9975622.8239928223
Rt4334 T590 T767 382495.5766003952
Rt4335 T590 T797 375489.35249472479
Rt4336 T590 T837 277761.96735002828
Rt4337 T590 T1137 889207.65128005901
Gcorr1578 T590 T1240 T590 T1240 -4.1624400381463784e-07
Gcorr1579 T590 T2145 T590 T2145 -3.7734375199518549e-07
Rt4338 T590 T4491 889207.65128018684
Gcorr1580 T590 T4594 T590 T4594 -4.1624400381445626e-07
Gcorr1581 T590 T5500 T590 T5500 -3.7734375199520761e-07
Rt4339 T591 T768 269270.16763597768
Rt4340 T591 T776 333160.25056905294
Rt4341 T591 T838 289920.4988135788
Gcorr1582 T591 T1302 T591 T1302 -2.9645343404021829e-07
Rt4342 T591 T1528 852809.24521240359
Gcorr1583 T591 T2344 T591 T2344 -5.241841881035822e-07
Gcorr1584 T591 T2470 T591 T2470 -9.5620894447912497e-08
Gcorr1585 T591 T4656 T591 T4656 -2.964534340407479e-07
Rt4343 T591 T4882 852809.24521298881
Gcorr1586 T591 T5697 T591 T5697 -5.2418418810260102e-07
Gcorr1587 T591 T5824 T591 T5824 -9.5620894447561336e-08
Rt4344 T592 T650 741277.44848645537
Rt4345 T592 T714 505212.62355393195
Rt4346 T592 T757 504482.10326140415
Rt4347 T592 T769 397121.33145194646
Rt4348 T592 T1036 11276294.209551992
Gcorr1588 T592 T1801 T592 T1801 -4.9413724614143287e-07
Rt4349 T592 T2221 2395434.8246621718
Rt4350 T592 T2296 3104340.558285268
Rt4351 T592 T4390 11276294.209550267
Gcorr1589 T592 T5156 T592 T5156 -4.9413724614061273e-07
Rt4352 T592 T5577 2395434.8246653145
Rt4353 T592 T5650 3104340.5582880452
Rt4354 T593 T638 7834932.8226755103
Rt4355 T593 T775 347926.80044273258
Rt4356 T593 T787 318035.27867291227
Rt4357 T593 T837 310935.85460303444
Gcorr1590 T593 T1133 T593 T1133 -3.9975061038376964e-10
Rt4358 T593 T1135 9043318.7835191153
Gcorr1591 T593 T2145 T593 T2145 -1.496719343603335e-07
Rt4359 T593 T2178 2765038.3956574309
Gcorr1592 T593 T4487 T593 T4487 -3.9975061052058133e-10
Rt4360 T593 T4489 9043318.7835127283
Gcorr1593 T593 T5500 T593 T5500 -1.4967193436024591e-07
Rt4361 T593 T5535 2765038.3956576684
Rt4362 T594 T625 3780519.6572060781
Rt4363 T594 T779 231808.52431623297
Rt4364 T594 T782 460085.40758684074
Rt4365 T594 T828 377231.42441142257
Gcorr1594 T594 T1157 T594 T1157 -4.4849647557137047e-07
Rt4366 T594 T1173 1845246.0290214357
Rt4367 T594 T1436 2865239.8046306237
Gcorr1595 T594 T1437 T594 T1437 -1.02990044141818e-07
Gcorr1596 T594 T4511 T594 T4511 -4.4849647557183708e-07
Rt4368 T594 T4527 1845246.029020559
Rt4369 T594 T4790 2865239.8046298968
Gcorr1597 T594 T4791 T594 T4791 -1.029900441416998e-07
Rt4370 T595 T750 339959.14872770919
Rt4371 T595 T792 410539.06957238994
Rt4372 T595 T815 294879.85386956669
Gcorr1598 T595 T987 T595 T987 -2.0945887752721538e-08
Rt4373 T595 T990 4188654.0072040777
Rt4374 T595 T1072 20177087.192764327
Gcorr1599 T595 T4341 T595 T4341 -2.0945887752627044e-08
Rt4375 T595 T4344 4188654.0072076917
Rt4376 T595 T4426 20177087.192719646
Rt4377 T596 T670 300891.60136147426
Rt4378 T596 T699 577515.39507438079
Rt4379 T596 T749 524232.99269706692
Rt4380 T596 T816 503229.92177578015
Rt4381 T596 T1628 3189277.5880692299
Gcorr1600 T596 T2089 T596 T2089 -6.6593321349502198e-07
Rt4382 T596 T2167 1149246.2061218787
Gcorr1601 T596 T2173 T596 T2173 -1.8140643607184763e-07
Rt4383 T596 T4982 3189277.5880688084
Gcorr1602 T596 T5443 T596 T5443 -6.6593321349517032e-07
Rt4384 T596 T5523 1149246.2061223267
Gcorr1603 T596 T5530 T596 T5530 -1.8140643607140366e-07
Rt4385 T597 T623 4585005.0679690391
Rt4386 T597 T627 5717861.3742417265
Rt4387 T597 T788 298235.04666119168
Rt4388 T597 T790 307744.21597260155
Rt4389 T597 T794 389600.56147167919
Gcorr1604 T597 T994 T597 T994 -6.5894034256379766e-09
Rt4390 T597 T2150 4037970.3982145931
Rt4391 T597 T2193 1633913.6659677944
Gcorr1605 T597 T2245 T597 T2245 -4.1070050863350656e-07
Gcorr1606 T597 T4348 T597 T4348 -6.5894034258938219e-09
Rt4392 T597 T5506 4037970.3982106992
Rt4393 T597 T5550 1633913.6659685599
Gcorr1607 T597 T5600 T597 T5600 -4.1070050863320571e-07
Rt4394 T598 T643 533277.22067916847
Rt4395 T598 T749 423897.76345958887
Rt4396 T598 T766 438186.82610180537
Rt4397 T598 T781 485109.33942042233
Rt4398 T598 T1694 11856329.153552627
Gcorr1608 T598 T2109 T598 T2109 -4.4532220939725833e-07
Rt4399 T598 T2201 3720926.987808628
Rt4400 T598 T2400 2311119.7768662022
Rt4401 T598 T5048 11856329.153549796
Gcorr1609 T598 T5460 T598 T5460 -4.4532220939737348e-07
Rt4402 T598 T5558 3720926.9878119682
Rt4403 T598 T5755 2311119.7768644188
Rt4404 T599 T637 1643496.1058718122
Rt4405 T599 T692 457551.34041173907
Rt4406 T599 T754 389575.47440361819
Rt4407 T599 T774 350430.24701677571
Rt4408 T599 T1239 4177295.0430614967
Gcorr1610 T599 T2379 T599 T2379 -1.1545725452974699e-07
Rt4409 T599 T2522 4240123.2047748696
Rt4410 T599 T2711 64935260.671860687
Rt4411 T599 T4593 4177295.0430625286
Gcorr1611 T599 T5733 T599 T5733 -1.154572545298341e-07
Rt4412 T599 T5876 4240123.2047705688
Rt4413 T599 T6065 64935260.672263667
Rt4414 T600 T647 790071.98638301005
Rt4415 T600 T696 473537.33668357
Rt4416 T600 T762 452323.78775442339
Rt4417 T600 T833 494948.96770398715
Gcorr1612 T600 T1737 T600 T1737 -9.3886757911065802e-07
Rt4418 T600 T1752 789897.39096389781
Gcorr1613 T600 T5091 T600 T5091 -9.3886757911066194e-07
Rt4419 T600 T5106 789897.39096389711
Rt4420 T601 T623 1958852.7463083302
Rt4421 T601 T639 386985.5469997818
Rt4422 T601 T790 391957.0990520143
Rt4423 T601 T808 314854.175278913
Gcorr1614 T601 T2061 T601 T2061 -1.740014827652196e-07
Rt4424 T601 T2062 3004770.690240033
Gcorr1615 T601 T2245 T601 T2245 -1.6189633306698514e-07
Rt4425 T601 T2349 2581008.1025855886
Gcorr1616 T601 T5415 T601 T5415 -1.7400148276489423e-07
Rt4426 T601 T5416 3004770.6902416856
Gcorr1617 T601 T5600 T601 T5600 -1.6189633306714208e-07
Rt4427 T601 T5702 2581008.102585509
Rt4428 T602 T632 545628.03908413497
Rt4429 T602 T713 454626.22360792803
Rt4430 T602 T723 475389.6018999177
Rt4431 T602 T736 563449.92358872434
Gcorr1618 T602 T1697 T602 T1697 -1.6888889701559059e-07
Rt4432 T602 T1791 2355390.6628846717
Rt4433 T602 T2205 24623702.705648005
Rt4434 T602 T2212 19197158.419924539
Gcorr1619 T602 T5051 T602 T5051 -1.6888889701512824e-07
Rt4435 T602 T5146 2355390.6628884594
Rt4436 T602 T5561 24623702.705373608
Rt4437 T602 T5568 19197158.420010995
Rt4438 T603 T672 809989.78400106297
Rt4439 T603 T783 435940.55094930553
Rt4440 T603 T797 446874.9564437946
Rt4441 T603 T835 390457.05199780251
Rt4442 T603 T1138 33906470.884955935
Gcorr1620 T603 T1146 T603 T1146 -1.7208196829534753e-07
Rt4443 T603 T1147 2216728.8464744287
Rt4444 T603 T4492 33906470.885136709
Gcorr1621 T603 T4500 T603 T4500 -1.7208196829566501e-07
Rt4445 T603 T4501 2216728.8464721064
Rt4446 T604 T627 1203043.9363939778
Rt4447 T604 T794 491754.39105541178
Rt4448 T604 T799 205276.36512944565
Rt4449 T604 T803 273216.00049494207
Rt4450 T604 T985 551729.39684779395
Gcorr1622 T604 T995 T604 T995 -6.4200377844773516e-07
Gcorr1623 T604 T1461 T604 T1461 -5.4826103031451148e-07
Gcorr1624 T604 T2182 T604 T2182 -2.4800095255570619e-07
Rt4451 T604 T4339 551729.39684775553
Gcorr1625 T604 T4349 T604 T4349 -6.4200377844768423e-07
Gcorr1626 T604 T4815 T604 T4815 -5.4826103031455965e-07
Gcorr1627 T604 T5539 T604 T5539 -2.4800095255583738e-07
Rt4452 T605 T690 690972.18414202088
Rt4453 T605 T773 613818.39162330574
Rt4454 T605 T785 302770.62408920296
Rt4455 T605 T798 366149.95370315085
Rt4456 T605 T1075 2276406.0803006757
Gcorr1628 T605 T2159 T605 T2159 -4.0276217328955904e-07
Gcorr1629 T605 T2187 T605 T2187 -5.1148667773161693e-07
Rt4457 T605 T2588 2067776.7440193575
Rt4458 T605 T2691 2847983.8949417099
Rt4459 T605 T4429 2276406.0803006478
Gcorr1630 T605 T5515 T605 T5515 -4.0276217329027457e-07
Gcorr1631 T605 T5544 T605 T5544 -5.1148667773129759e-07
Rt4460 T605 T5942 2067776.7440194562
Rt4461 T605 T6045 2847983.8949383716
Rt4462 T606 T724 823740.62831020262
Rt4463 T606 T761 383019.89367161674
Rt4464 T606 T763 440397.47327360424
Rt4465 T606 T777 615833.39706252248
Rt4466 T606 T1151 2711865.3486398887
Gcorr1632 T606 T1152 T606 T1152 -9.4546185774335234e-08
Rt4467 T606 T1153 3800394.6175703024
Gcorr1633 T606 T2130 T606 T2130 -1.5140920822765741e-07
Rt4468 T606 T4505 2711865.3486398626
Gcorr1634 T606 T4506 T606 T4506 -9.4546185774457313e-08
Rt4469 T606 T4507 3800394.617570376
Gcorr1635 T606 T5486 T606 T5486 -1.5140920822753641e-07
Rt4470 T607 T619 50347567.303189114
Rt4471 T607 T628 1842294.9845132867
Rt4472 T607 T795 452206.80383380665
Rt4473 T607 T804 287495.52655985614
Rt4474 T607 T810 465451.24669328943
Gcorr1636 T607 T984 T607 T984 -1.4226386913690981e-07
Rt4475 T607 T989 14864535.858001828
Rt4476 T607 T993 1833874.5443796453
Gcorr1637 T607 T996 T607 T996 -1.7929950941206537e-08
Gcorr1638 T607 T4338 T607 T4338 -1.4226386913712242e-07
Rt4477 T607 T4343 14864535.857934467
Rt4478 T607 T4347 1833874.544380123
Gcorr1639 T607 T4350 T607 T4350 -1.7929950941159817e-08
Rt4479 T608 T689 632093.09233405965
Rt4480 T608 T756 183474.49273006245
Rt4481 T608 T782 560334.85238984495
Rt4482 T608 T802 558524.90173362975
Rt4483 T608 T1792 544636.70558304968
Gcorr1640 T608 T2096 T608 T2096 -1.1492889142696645e-07
Gcorr1641 T608 T2120 T608 T2120 -1.5551338393787728e-06
Rt4484 T608 T2237 5201858.4790262934
Rt4485 T608 T5147 544636.70558515599
Gcorr1642 T608 T5449 T608 T5449 -1.1492889142685039e-07
Gcorr1643 T608 T5475 T608 T5475 -1.5551338393720789e-06
Rt4486 T608 T5592 5201858.4790184926
Rt4487 T609 T695 420550.34599072475
Rt4488 T609 T758 981879.15952327102
Rt4489 T609 T791 326850.94798546459
Rt4490 T609 T798 468995.10786021146
Gcorr1644 T609 T1018 T609 T1018 -1.2501785433844987e-07
Gcorr1645 T609 T1020 T609 T1020 -4.8918951263287716e-07
Rt4491 T609 T2152 876496.40001379244
Rt4492 T609 T2187 1053286382.9330657
Gcorr1646 T609 T2499 T609 T2499 -1.427354125223348e-07
Gcorr1647 T609 T4372 T609 T4372 -1.2501785433826019e-07
Gcorr1648 T609 T4374 T609 T4374 -4.8918951263333911e-07
Rt4493 T609 T5508 876496.40001328452
Rt4494 T609 T5544 1053286383.1826538
Gcorr1649 T609 T5853 T609 T5853 -1.4273541252250133e-07
Rt4495 T610 T755 265933.62582879729
Rt4496 T610 T768 414084.87344015233
Rt4497 T610 T776 476706.4006370508
Rt4498 T610 T780 1039794.262399224
Gcorr1650 T610 T1776 T610 T1776 -7.9926334603243875e-07
Rt4499 T610 T1814 196258199.72682035
Gcorr1651 T610 T2206 T610 T2206 -1.644548698156751e-07
Rt4500 T610 T2344 2255723.3377298815
Rt4501 T610 T2726 1115201.4550377333
Gcorr1652 T610 T5130 T610 T5130 -7.9926334603169591e-07
Rt4502 T610 T5169 196258199.73081568
Gcorr1653 T610 T5562 T610 T5562 -1.6445486981553251e-07
Rt4503 T610 T5697 2255723.3377320422
Rt4504 T610 T6081 1115201.4550381808
Rt4505 T611 T635 664780.03894845408
Rt4506 T611 T812 292633.34098253655
Rt4507 T611 T817 544144.97597618902
Rt4508 T611 T820 246210.8664709141
Gcorr1654 T611 T1165 T611 T1165 -8.4340736987571633e-07
Gcorr1655 T611 T1167 T611 T1167 -6.7336650256114865e-07
Gcorr1656 T611 T2217 T611 T2217 -7.5186136194248781e-07
Rt4509 T611 T2320 323603.02327622479
Gcorr1657 T611 T2330 T611 T2330 -4.290721893712419e-07
Gcorr1658 T611 T4519 T611 T4519 -8.4340736987495146e-07
Gcorr1659 T611 T4521 T611 T4521 -6.7336650256120551e-07
Gcorr1660 T611 T5573 T611 T5573 -7.5186136194380315e-07
Rt4510 T611 T5674 323603.02327618474
Gcorr1661 T611 T5683 T611 T5683 -4.2907218937101972e-07
Rt4511 T612 T613 872107.68529406993
Rt4512 T612 T681 448960.09298776585
Rt4513 T612 T710 539385.84032347985
Rt4514 T612 T836 317574.2454403225
Rt4515 T612 T1057 1620159.2672330919
Gcorr1662 T612 T1058 T612 T1058 -1.7310409097559364e-07
Rt4516 T612 T1059 9451967.7707513366
Gcorr1663 T612 T1453 T612 T1453 -1.583134432325657e-07
Rt4517 T612 T4411 1620159.2672346481
Gcorr1664 T612 T4412 T612 T4412 -1.7310409097564177e-07
Rt4518 T612 T4413 9451967.7706923075
Gcorr1665 T612 T4807 T612 T4807 -1.5831344323258809e-07
Rt4519 T613 T793 656250.18363412609
Rt4520 T613 T801 482921.72661316447
Rt4521 T613 T831 228395.3600433837
Rt4522 T613 T836 377733.21003699407
Gcorr1666 T613 T1052 T613 T1052 -4.6498016572874272e-07
Gcorr1667 T613 T1054 T613 T1054 -9.7570881484162629e-08
Rt4523 T613 T1057 18829653.627543211
Rt4524 T613 T2141 1167629.8490198529
Gcorr1668 T613 T4406 T613 T4406 -4.6498016572863525e-07
Gcorr1669 T613 T4408 T613 T4408 -9.757088148446895e-08
Rt4525 T613 T4411 18829653.627426881
Rt4526 T613 T5497 1167629.849020032
Rt4527 T614 T649 708336.89524177229
Rt4528 T614 T760 344433.85870766791
Rt4529 T614 T811 604803.11223570781
Rt4530 T614 T824 405877.34290306433
Rt4531 T614 T1280 3854488.3497903296
Gcorr1670 T614 T2144 T614 T2144 -3.2381624652933565e-08
Rt4532 T614 T2336 10197083.339768216
Rt4533 T614 T4634 3854488.3497886313
Gcorr1671 T614 T5501 T614 T5501 -3.2381624652689613e-08
Rt4534 T614 T5689 10197083.339805692
Rt4535 T615 T807 514128.94758091803
Rt4536 T615 T827 219438.09259605772
Rt4537 T615 T839 301677.96764725767
Gcorr1672 T615 T1202 T615 T1202 -4.2155150046255998e-07
Rt4538 T615 T1203 2416759.9852567227
Rt4539 T615 T1204 2413581.4857439692
Gcorr1673 T615 T1443 T615 T1443 -9.3206480508810589e-08
Gcorr1674 T615 T4556 T615 T4556 -4.2155150046247941e-07
Rt4540 T615 T4557 2416759.9852553434
Rt4541 T615 T4558 2413581.4857459622
Gcorr1675 T615 T4797 T615 T4797 -9.3206480508787441e-08
Rt4542 T616 T633 19185709.869934525
Rt4543 T616 T778 279454.76178002707
Rt4544 T616 T786 372262.33926609199
Rt4545 T616 T825 331254.87033345777
Gcorr1676 T616 T1228 T616 T1228 -1.0156646201370246e-07
Rt4546 T616 T2079 18777629.373559382
Rt4547 T616 T2080 3259366.7893607058
Rt4548 T616 T2371 11538091.099095142
Gcorr1677 T616 T4582 T616 T4582 -1.015664620137984e-07
Rt4549 T616 T5433 18777629.373505797
Rt4550 T616 T5434 3259366.7893618876
Rt4551 T616 T5725 11538091.099088095
Rt4552 T617 T776 656938.51644248527
Rt4553 T617 T792 292783.40386750619
Rt4554 T617 T815 546237.67376204825
Rt4555 T617 T838 392960.22114800353
Rt4556 T617 T986 53358305.019102104
Gcorr1678 T617 T990 T617 T990 -1.6166143676932943e-07
Gcorr1679 T617 T1528 T617 T1528 -3.6288487458314431e-07
Rt4557 T617 T2151 938078.76640341152
Gcorr1680 T617 T2196 T617 T2196 -1.4896655900414874e-07
Rt4558 T617 T4340 53358305.017844684
Gcorr1681 T617 T4344 T617 T4344 -1.616614367692001e-07
Gcorr1682 T617 T4882 T617 T4882 -3.6288487458336544e-07
Rt4559 T617 T5507 938078.7664038915
Gcorr1683 T617 T5553 T617 T5553 -1.4896655900395583e-07
Rt4560 T618 T640 1558078.7874882666
Rt4561 T618 T799 481784.17141242221
Rt4562 T618 T803 275505.75807484717
Rt4563 T618 T813 481305.84310756531
Gcorr1684 T618 T1116 T618 T1116 -4.4268847364772538e-07
Rt4564 T618 T2182 1872105.0904303303
Rt4565 T618 T2197 3936268.7574008284
Rt4566 T618 T2214 20056211.085033957
Gcorr1685 T618 T4470 T618 T4470 -4.4268847364770251e-07
Rt4567 T618 T5539 1872105.0904293333
Rt4568 T618 T5554 3936268.7574018175
Rt4569 T618 T5570 20056211.085133012
Rt4570 T619 T639 1273457.0850970577
Rt4571 T619 T804 425869.71392724011
Rt4572 T619 T810 282375.38444534381
Rt4573 T619 T821 386336.38697238913
Gcorr1686 T619 T993 T619 T993 -2.5670635508180502e-08
Rt4574 T619 T1113 70429152.905379191
Rt4575 T619 T2236 1202733.7492868472
Gcorr1687 T619 T2434 T619 T2434 -4.4096233162849907e-07
Rt4576 T619 T2562 13221259.180058083
Gcorr1688 T619 T4347 T619 T4347 -2.5670635508118202e-08
Rt4577 T619 T4467 70429152.904098943
Rt4578 T619 T5591 1202733.7492883715
Gcorr1689 T619 T5788 T619 T5788 -4.409623316277595e-07
Rt4579 T619 T5916 13221259.180059694
Rt4580 T620 T807 324939.30949776724
Rt4581 T620 T819 281398.15161706874
Rt4582 T620 T827 1106843.1567062051
Gcorr1690 T620 T1198 T620 T1198 -5.2059694645608233e-07
Gcorr1691 T620 T1199 T620 T1199 -3.4393384064513311e-07
Rt4583 T620 T1200 557511.66426138277
Gcorr1692 T620 T2185 T620 T2185 -5.4139843959871853e-07
Gcorr1693 T620 T4552 T620 T4552 -5.2059694645603256e-07
Gcorr1694 T620 T4553 T620 T4553 -3.4393384064535328e-07
Rt4584 T620 T4554 557511.66426093108
Gcorr1695 T620 T5542 T620 T5542 -5.4139843960000401e-07
Rt4585 T621 T697 508956.31327040464
Rt4586 T621 T750 342942.75177250378
Rt4587 T621 T815 795902.44648237946
Rt4588 T621 T834 475064.73860749992
Rt4589 T621 T976 15998006.141422953
Rt4590 T621 T987 6401466.4544624435
Gcorr1696 T621 T1233 T621 T1233 -2.4193817448225509e-07
Rt4591 T621 T2158 2026783.1038182308
Rt4592 T621 T4330 15998006.14147744
Rt4593 T621 T4341 6401466.4544691006
Gcorr1697 T621 T4587 T621 T4587 -2.4193817448246319e-07
Rt4594 T621 T5514 2026783.1038158475
Rt4595 T622 T745 366708.15735014522
Rt4596 T622 T764 344731.7068024918
Rt4597 T622 T822 267803.0223708573
Rt4598 T622 T1472 1098808.0626140644
Rt4599 T622 T1884 12186276.100113705
Gcorr1698 T622 T1885 T622 T1885 -1.2267728836509528e-07
Gcorr1699 T622 T2235 T622 T2235 -5.2077673979679517e-07
Rt4600 T622 T4826 1098808.0626142153
Rt4601 T622 T5241 12186276.100169305
Gcorr1700 T622 T5242 T622 T5242 -1.2267728836490316e-07
Gcorr1701 T622 T5590 T622 T5590 -5.2077673979649045e-07
Rt4602 T623 T788 463115.53186989255
Rt4603 T623 T790 282090.75945398904
Rt4604 T623 T808 432787.79985757108
Rt4605 T623 T1466 2866198.7025235016
Rt4606 T623 T2150 4948741.2554192524
Rt4607 T623 T2245 15982580.544337444
Gcorr1702 T623 T2349 T623 T2349 -1.6213615855711073e-07
Rt4608 T623 T4820 2866198.7025222573
Rt4609 T623 T5506 4948741.2554290108
Rt4610 T623 T5600 15982580.54427899
Gcorr1703 T623 T5702 T623 T5702 -1.6213615855709556e-07
Rt4611 T624 T753 301248.54265168367
Rt4612 T624 T759 323364.82125929481
Rt4613 T624 T784 306190.72478208132
Rt4614 T624 T1416 4015661.899437096
Gcorr1704 T624 T1417 T624 T1417 -1.4742493019728506e-07
Rt4615 T624 T1418 726563.1717010634
Gcorr1705 T624 T1419 T624 T1419 -5.8529759805545885e-07
Gcorr1706 T624 T1787 T624 T1787 -4.6079930861063481e-07
Rt4616 T624 T4770 4015661.8994362941
Gcorr1707 T624 T4771 T624 T4771 -1.4742493019702314e-07
Rt4617 T624 T4772 726563.17170081555
Gcorr1708 T624 T4773 T624 T4773 -5.8529759805606067e-07
Gcorr1709 T624 T5141 T624 T5141 -4.6079930861081719e-07
Rt4618 T625 T724 436546.49863608909
Rt4619 T625 T779 397420.39032008225
Rt4620 T625 T828 271699.01779524196
Rt4621 T625 T1155 794663.7930298422
Gcorr1710 T625 T1157 T625 T1157 -9.4624723229242892e-08
Gcorr1711 T625 T1173 T625 T1173 -5.8291524270466657e-08
Gcorr1712 T625 T2123 T625 T2123 -6.9704992425740516e-07
Rt4622 T625 T4509 794663.79302951007
Gcorr1713 T625 T4511 T625 T4511 -9.4624723229267867e-08
Gcorr1714 T625 T4527 T625 T4527 -5.8291524270385143e-08
Gcorr1715 T625 T5479 T625 T5479 -6.9704992425799035e-07
Rt4623 T626 T715 504990.13662862399
Rt4624 T626 T727 453797.8120668995
Rt4625 T626 T829 429935.24554722942
Rt4626 T626 T1911 2675566.4099604199
Gcorr1716 T626 T1912 T626 T1912 -1.9660167267881411e-07
Rt4627 T626 T2579 5346163.0763247572
Rt4628 T626 T5268 2675566.4099584385
Gcorr1717 T626 T5269 T626 T5269 -1.9660167267877642e-07
Rt4629 T626 T5933 5346163.0763338134
Rt4630 T627 T788 429637.63941915991
Rt4631 T627 T794 293326.92921435088
Rt4632 T627 T799 536561.26522667345
Gcorr1718 T627 T985 T627 T985 -1.8244892282963513e-07
Rt4633 T627 T994 3226451.065885148
Rt4634 T627 T995 4186301.416310613
Rt4635 T627 T1114 11113885.408087321
Gcorr1719 T627 T4339 T627 T4339 -1.8244892282975549e-07
Rt4636 T627 T4348 3226451.0658824244
Rt4637 T627 T4349 4186301.4163149567
Rt4638 T627 T4468 11113885.408074528
Rt4639 T628 T795 283996.50421647128
Rt4640 T628 T804 537783.57205157331
Rt4641 T628 T814 445458.95144046558
Rt4642 T628 T996 1574805.3241645235
Rt4643 T628 T997 21638952.316097148
Gcorr1720 T628 T1077 T628 T1077 -2.1732431917733708e-07
Rt4644 T628 T4350 1574805.3241650008
Rt4645 T628 T4351 21638952.316044055
Gcorr1721 T628 T4431 T628 T4431 -2.1732431917726125e-07
Rt4646 T629 T651 403108.71303418069
Rt4647 T629 T743 1719756.9095598471
Rt4648 T629 T827 1139293.6422999506
Rt4649 T629 T839 216944.31267392801
Gcorr1722 T629 T1204 T629 T1204 -8.1462561617987035e-08
Rt4650 T629 T1205 3291609.3117670692
Rt4651 T629 T1206 2448452.6319963043
Gcorr1723 T629 T1207 T629 T1207 -1.0968583917800776e-07
Gcorr1724 T629 T4558 T629 T4558 -8.1462561617910788e-08
Rt4652 T629 T4559 3291609.3117655697
Rt4653 T629 T4560 2448452.631997196
Gcorr1725 T629 T4561 T629 T4561 -1.0968583917807713e-07
Rt4654 T630 T717 256672.36403776027
Rt4655 T630 T809 475604.20301542326
Rt4656 T630 T823 275122.24349506851
Gcorr1726 T630 T1683 T630 T1683 -1.5242714069275905e-07
Rt4657 T630 T1773 21952558.557755411
Rt4658 T630 T1815 979775.8028924861
Gcorr1727 T630 T2034 T630 T2034 -5.6869048016534542e-07
Gcorr1728 T630 T5037 T630 T5037 -1.5242714069284627e-07
Rt4659 T630 T5127 21952558.557692375
Rt4660 T630 T5170 979775.80289345072
Gcorr1729 T630 T5387 T630 T5387 -5.6869048016438648e-07
Rt4661 T631 T716 370817.29759124131
Rt4662 T631 T717 397468.34717163903
Rt4663 T631 T800 356765.22673019132
Gcorr1730 T631 T1530 T631 T1530 -1.4602303510149353e-07
Rt4664 T631 T1693 3028832.2289348622
Gcorr1731 T631 T2034 T631 T2034 -1.7646712980423226e-08
Rt4665 T631 T2347 4036053.994364162
Gcorr1732 T631 T4884 T631 T4884 -1.4602303510141809e-07
Rt4666 T631 T5047 3028832.2289296254
Gcorr1733 T631 T5387 T631 T5387 -1.7646712980758565e-08
Rt4667 T631 T5700 4036053.9943692712
Rt4668 T632 T736 366205.36138945917
Rt4669 T632 T753 552422.34492360428
Rt4670 T632 T818 454026.86686732236
Rt4671 T632 T1791 16150966.361621607
Gcorr1734 T632 T2063 T632 T2063 -1.6896273967767732e-07
Rt4672 T632 T2186 1365513.0410437887
Gcorr1735 T632 T2212 T632 T2212 -2.4235214087770235e-07
Rt4673 T632 T5146 16150966.361488253
Gcorr1736 T632 T5417 T632 T5417 -1.689627396776796e-07
Rt4674 T632 T5543 1365513.0410447859
Gcorr1737 T632 T5568 T632 T5568 -2.4235214087767911e-07
Rt4675 T633 T751 439204.45803035569
Rt4676 T633 T778 531932.17993108253
Rt4677 T633 T786 292668.44982505048
Rt4678 T633 T1336 12920218.783071619
Rt4679 T633 T2080 650456223.46860707
Gcorr1738 T633 T2443 T633 T2443 -2.3395122990992329e-08
Rt4680 T633 T2548 2632034.328388175
Rt4681 T633 T4690 12920218.783105513
Rt4682 T633 T5434 650456223.4322083
Gcorr1739 T633 T5797 T633 T5797 -2.3395122991144543e-08
Rt4683 T633 T5901 2632034.32838633
Rt4684 T634 T765 121175.7528181293
Rt4685 T634 T796 382565.60613233835
Rt4686 T634 T822 297221.30419598613
Gcorr1740 T634 T1051 T634 T1051 -5.6147097147493252e-08
Gcorr1741 T634 T1053 T634 T1053 -3.131187847052407e-06
Rt4687 T634 T2235 24496279.607666988
Rt4688 T634 T2308 283501.75658872462
Gcorr1742 T634 T4405 T634 T4405 -5.614709714713871e-08
Gcorr1743 T634 T4407 T634 T4407 -3.1311878470523003e-06
Rt4689 T634 T5590 24496279.60788114
Rt4690 T634 T5662 283501.75658873323
Rt4691 T635 T756 726321.57798488915
Rt4692 T635 T802 536001.42426339653
Rt4693 T635 T817 219988.43375964186
Rt4694 T635 T1242 939682.91021600552
Gcorr1744 T635 T2217 T635 T2217 -7.1706202437869612e-07
Rt4695 T635 T2320 22194543.314916305
Rt4696 T635 T4596 939682.91021708632
Gcorr1745 T635 T5573 T635 T5573 -7.1706202437758736e-07
Rt4697 T635 T5674 22194543.31486088
Rt4698 T636 T671 390876.50758625835
Rt4699 T636 T718 482042.69695382164
Rt4700 T636 T814 405900.34662648442
Rt4701 T636 T1078 1346081.7946841228
Gcorr1746 T636 T1373 T636 T1373 -5.0920471923520231e-07
Rt4702 T636 T1374 4138704.4599042875
Gcorr1747 T636 T2142 T636 T2142 -1.1818760759456243e-07
Rt4703 T636 T4432 1346081.7946830764
Gcorr1748 T636 T4727 T636 T4727 -5.0920471923556928e-07
Rt4704 T636 T4728 4138704.4599066046
Gcorr1749 T636 T5498 T636 T5498 -1.1818760759464003e-07
Rt4705 T637 T752 355949.67380929203
Rt4706 T637 T754 342804.96583743935
Rt4707 T637 T774 466158.9054510576
Rt4708 T637 T1171 5557483.0619902397
Gcorr1750 T637 T1174 T637 T1174 -2.1673414303362422e-07
Rt4709 T637 T2711 2394800.5724874893
Rt4710 T637 T4525 5557483.061994534
Gcorr1751 T637 T4528 T637 T4528 -2.1673414303348525e-07
Rt4711 T637 T6065 2394800.5724875038
Rt4712 T638 T648 431687.85539856745
Rt4713 T638 T775 279836.28943706665
Rt4714 T638 T787 757512.1359009014
Gcorr1752 T638 T1131 T638 T1131 -1.5841363823311558e-07
Rt4715 T638 T1132 10884979.298487805
Rt4716 T638 T1133 2227726.8875961481
Rt4717 T638 T1139 21705908.42828276
Gcorr1753 T638 T4485 T638 T4485 -1.5841363823316402e-07
Rt4718 T638 T4486 10884979.298507707
Rt4719 T638 T4487 2227726.887595152
Rt4720 T638 T4493 21705908.428276721
Rt4721 T639 T808 22980430.355059139
Rt4722 T639 T810 350595.06237720005
Rt4723 T639 T821 252155.53150799422
Gcorr1754 T639 T1281 T639 T1281 -5.4064373638081945e-07
Gcorr1755 T639 T2060 T639 T2060 -4.383183290087454e-07
Rt4724 T639 T2061 546540.16780686704
Gcorr1756 T639 T2236 T639 T2236 -1.6162903869065833e-07
Gcorr1757 T639 T2349 T639 T2349 -2.2958448370883315e-07
Gcorr1758 T639 T4635 T639 T4635 -5.4064373638137362e-07
Gcorr1759 T639 T5414 T639 T5414 -4.3831832900881136e-07
Rt4725 T639 T5415 546540.16780669673
Gcorr1760 T639 T5591 T639 T5591 -1.6162903869055762e-07
Gcorr1761 T639 T5702 T639 T5702 -2.2958448370888667e-07
Rt4726 T640 T716 1588549.9795257489
Rt4727 T640 T803 613623.99085171008
Rt4728 T640 T813 354123.40810974484
Gcorr1762 T640 T1692 T640 T1692 -1.6501323083621471e-07
Rt4729 T640 T1700 5771654.5825049076
Rt4730 T640 T2214 1972488.2186639623
Gcorr1763 T640 T2413 T640 T2413 -8.0631759541151645e-08
Gcorr1764 T640 T5046 T640 T5046 -1.6501323083638745e-07
Rt4731 T640 T5054 5771654.5825127391
Rt4732 T640 T5570 1972488.2186624559
Gcorr1765 T640 T5766 T640 T5766 -8.0631759541134069e-08
Rt4733 T641 T653 503099.96954891487
Rt4734 T641 T744 506975.49066368438
Rt4735 T641 T825 197559.40363245769
Gcorr1766 T641 T1228 T641 T1228 -4.6168181095073873e-07
Rt4736 T641 T1982 5325830.764963977
Rt4737 T641 T2313 883474.0489904593
Gcorr1767 T641 T2371 T641 T2371 -5.217807009740935e-07
Gcorr1768 T641 T4582 T641 T4582 -4.6168181095083942e-07
Rt4738 T641 T5334 5325830.7649615863
Rt4739 T641 T5667 883474.048990504
Gcorr1769 T641 T5725 T641 T5725 -5.2178070097402214e-07
Rt4740 T642 T693 366868.63142682513
Rt4741 T642 T718 407867.63645731303
Rt4742 T642 T806 499648.00493411953
Rt4743 T642 T1523 8854387.0194136947
Rt4744 T642 T1545 2833576.6057451149
Gcorr1770 T642 T1811 T642 T1811 -1.0859530082720649e-07
Rt4745 T642 T4877 8854387.0194192622
Rt4746 T642 T4899 2833576.6057464108
Gcorr1771 T642 T5166 T642 T5166 -1.0859530082697649e-07
Rt4747 T643 T752 405971.02500432782
Rt4748 T643 T766 304470.4952162847
Rt4749 T643 T781 278267.15602548333
Gcorr1772 T643 T1175 T643 T1175 -7.3224187207569818e-07
Gcorr1773 T643 T1178 T643 T1178 -7.4379260760201294e-07
Rt4750 T643 T2109 307114.21530238306
Gcorr1774 T643 T2201 T643 T2201 -6.1833003299359979e-07
Gcorr1775 T643 T2400 T643 T2400 -4.9649337138695982e-07
Gcorr1776 T643 T2574 T643 T2574 -2.867508018826214e-07
Gcorr1777 T643 T4529 T643 T4529 -7.3224187207732766e-07
Gcorr1778 T643 T4532 T643 T4532 -7.4379260760205731e-07
Rt4751 T643 T5460 307114.21530218131
Gcorr1779 T643 T5558 T643 T5558 -6.183300329941871e-07
Gcorr1780 T643 T5755 T643 T5755 -4.9649337138690773e-07
Gcorr1781 T643 T5928 T643 T5928 -2.8675080188255517e-07
Rt4752 T644 T713 349614.58411166799
Gcorr1782 T644 T745 T644 T745 -1.0698523725341245e-08
Rt4753 T644 T826 347723.44927823852
Gcorr1783 T644 T1762 T644 T1762 -2.33216975194238e-07
Rt4754 T644 T1974 580921.68292468111
Gcorr1784 T644 T1998 T644 T1998 -5.8488905427100967e-07
Gcorr1785 T644 T2205 T644 T2205 -4.7571003900263602e-07
Gcorr1786 T644 T5117 T644 T5117 -2.3321697519402915e-07
Rt4755 T644 T5328 580921.68292453198
Gcorr1787 T644 T5350 T644 T5350 -5.8488905427108358e-07
Gcorr1788 T644 T5561 T644 T5561 -4.7571003900321592e-07
Rt4756 T645 T773 419294.94749165641
Rt4757 T645 T785 556594.79653296771
Rt4758 T645 T805 349427.16419195762
Rt4759 T645 T1725 8077200.9406143799
Rt4760 T645 T1789 7656438.4558570459
Rt4761 T645 T2159 8755010.4317275193
Rt4762 T645 T5079 8077200.9406286608
Rt4763 T645 T5144 7656438.455864355
Rt4764 T645 T5515 8755010.4317013789
Rt4765 T646 T746 446399.48175995791
Rt4766 T646 T789 759510.84843203309
Rt4767 T646 T819 371689.56855723832
Rt4768 T646 T1199 12330050.867236272
Rt4769 T646 T2203 5997595.7835770445
Rt4770 T646 T2275 9296994.4024548363
Rt4771 T646 T4553 12330050.867231386
Rt4772 T646 T5560 5997595.783579696
Rt4773 T646 T5629 9296994.4024514537
Rt4774 T647 T696 717973.60074345884
Rt4775 T647 T727 213506.75328874274
Rt4776 T647 T762 212074.11013475311
Gcorr1789 T647 T1752 T647 T1752 -1.6496999350650503e-07
Gcorr1790 T647 T1912 T647 T1912 -1.1196637865739542e-06
Gcorr1791 T647 T2168 T647 T2168 -6.1779311866715032e-07
Rt4777 T647 T2260 438011.51697971462
Gcorr1792 T647 T5106 T647 T5106 -1.6496999350668945e-07
Gcorr1793 T647 T5269 T647 T5269 -1.1196637865774585e-06
Gcorr1794 T647 T5524 T647 T5524 -6.1779311866707313e-07
Rt4778 T647 T5615 438011.5169790223
Rt4779 T648 T832 1072323.821191608
Rt4780 T648 T1132 2707182.287125526
Gcorr1795 T648 T1139 T648 T1139 -1.1216281725397914e-07
Rt4781 T648 T1140 4278604.7725373385
Gcorr1796 T648 T2259 T648 T2259 -1.2841812458284774e-07
Rt4782 T648 T4486 2707182.2871253388
Gcorr1797 T648 T4493 T648 T4493 -1.1216281725385908e-07
Rt4783 T648 T4494 4278604.772537943
Gcorr1798 T648 T5614 T648 T5614 -1.2841812458296289e-07
Rt4784 T649 T811 248279.41206507184
Rt4785 T649 T824 523215.38755699235
Gcorr1799 T649 T1812 T649 T1812 -7.5223515681744778e-08
Rt4786 T649 T2336 2977002.4623805392
Rt4787 T649 T2337 2213020.9699631026
Gcorr1800 T649 T2644 T649 T2644 -3.9399617619528668e-07
Gcorr1801 T649 T5167 T649 T5167 -7.5223515681920762e-08
Rt4788 T649 T5689 2977002.462377565
Rt4789 T649 T5690 2213020.9699635562
Gcorr1802 T649 T5998 T649 T5998 -3.9399617619535577e-07
Rt4790 T650 T714 439738.22195398033
Rt4791 T650 T757 328545.49244291167
Rt4792 T650 T784 600543.38246857747
Gcorr1803 T650 T1036 T650 T1036 -1.5640120993429488e-07
Rt4793 T650 T1787 16951471.468148477
Rt4794 T650 T2095 2935538.3901868337
Rt4795 T650 T2221 7496490.9785331627
Gcorr1804 T650 T4390 T650 T4390 -1.5640120993474185e-07
Rt4796 T650 T5141 16951471.468076479
Rt4797 T650 T5448 2935538.3901858572
Rt4798 T650 T5577 7496490.9785286356
Rt4799 T651 T743 347536.67499818682
Gcorr1805 T651 T1206 T651 T1206 -5.0616488826143842e-08
Rt4800 T651 T1207 2919677.2192458664
Rt4801 T651 T1208 3361510.0784338112
Gcorr1806 T651 T1230 T651 T1230 -1.1441113426468391e-07
Gcorr1807 T651 T4560 T651 T4560 -5.0616488826144643e-08
Rt4802 T651 T4561 2919677.2192458711
Rt4803 T651 T4562 3361510.0784338186
Gcorr1808 T651 T4584 T651 T4584 -1.1441113426468525e-07
Rt4804 T652 T715 501986.39075683517
Rt4805 T652 T772 447950.70939420012
Rt4806 T652 T805 472268.05248223874
Rt4807 T652 T1750 3504569.2077574092
Gcorr1809 T652 T2036 T652 T2036 -1.1730157337017844e-07
Rt4808 T652 T2037 3500749.0334168831
Gcorr1810 T652 T2232 T652 T2232 -1.000688678448124e-07
Rt4809 T652 T5104 3504569.2077542339
Gcorr1811 T652 T5389 T652 T5389 -1.1730157336997825e-07
Rt4810 T652 T5390 3500749.0334204137
Gcorr1812 T652 T5587 T652 T5587 -1.0006886784498542e-07
Rt4811 T653 T744 529294.89185353136
Rt4812 T653 T1192 6603483.2353480197
Rt4813 T653 T1194 15915206.046087993
Rt4814 T653 T2313 7302815.5356768593
Rt4815 T653 T4546 6603483.2353538126
Rt4816 T653 T4548 15915206.04610002
Rt4817 T653 T5667 7302815.5356673701
Rt4818 T654 T726 451871.26515159302
Rt4819 T654 T728 548717.03372987767
Gcorr1813 T654 T1670 T654 T1670 -5.3385286513676691e-07
Rt4820 T654 T2090 1283682.732521916
Rt4821 T654 T2204 4108699.9293396343
Gcorr1814 T654 T2479 T654 T2479 -6.9654368053034501e-08
Gcorr1815 T654 T5116 T654 T5116 -2.8406879095254245e-06
Rt4822 T654 T5527 273360.39700749022
Rt4823 T654 T5781 22740231.528298464
Gcorr1816 T654 T5846 T654 T5846 -4.4257394962049203e-07
Rt4824 T655 T700 566865.02064502472
Rt4825 T655 T703 477952.83182549226
Rt4826 T655 T900 2731112.1895828173
Gcorr1817 T655 T901 T655 T901 -5.1933055653785074e-08
Rt4827 T655 T902 3870742.6067847107
Gcorr1818 T655 T2136 T655 T2136 -1.5122769563784542e-07
Rt4828 T655 T4254 2731112.1895834161
Gcorr1819 T655 T4255 T655 T4255 -5.1933055653786503e-08
Rt4829 T655 T4256 3870742.6067844182
Gcorr1820 T655 T5492 T655 T5492 -1.512276956377861e-07
Rt4830 T656 T708 477253.26783714368
Rt4831 T656 T712 507267.0215813028
Gcorr1821 T656 T1532 T656 T1532 -1.3006153451600373e-07
Rt4832 T656 T1704 2566485.142608257
Rt4833 T656 T1778 4934209.9048993383
Gcorr1822 T656 T2005 T656 T2005 -1.2411871809660023e-07
Rt4834 T656 T2696 12200407.634981396
Gcorr1823 T656 T4886 T656 T4886 -1.3006153451606247e-07
Rt4835 T656 T5058 2566485.1426094142
Rt4836 T656 T5132 4934209.904890514
Gcorr1824 T656 T5357 T656 T5357 -1.2411871809633429e-07
Rt4837 T656 T6050 12200407.635040473
Rt4838 T657 T704 563983.56021383498
Rt4839 T657 T707 382354.36155261239
Rt4840 T657 T1103 7395980.6182906404
Gcorr1825 T657 T1786 T657 T1786 -3.2493065793241528e-07
Rt4841 T657 T2262 3605290.0495884139
Rt4842 T657 T2391 3002465.1210406017
Rt4843 T657 T4457 7395980.6182678537
Gcorr1826 T657 T5140 T657 T5140 -3.2493065793284626e-07
Rt4844 T657 T5617 3605290.0495948489
Rt4845 T657 T5747 3002465.121036035
Rt4846 T658 T725 428523.68916728481
Rt4847 T658 T729 545003.37020959042
Rt4848 T658 T1087 734991.80948942457
Gcorr1827 T658 T1088 T658 T1088 -4.1976965114917776e-07
Gcorr1828 T658 T2039 T658 T2039 -1.1096000094262138e-08
Rt4849 T658 T2700 11963422.566240598
Gcorr1829 T658 T2716 T658 T2716 -5.9439440397599139e-07
Rt4850 T658 T4441 734991.80949032551
Gcorr1830 T658 T4442 T658 T4442 -4.1976965114913663e-07
Gcorr1831 T658 T5392 T658 T5392 -1.1096000093807862e-08
Rt4851 T658 T6054 11963422.566240897
Gcorr1832 T658 T6071 T658 T6071 -5.9439440397481973e-07
Rt4852 T659 T701 566661.19819595665
Rt4853 T659 T702 370300.7640623867
Gcorr1833 T659 T1703 T659 T1703 -3.5477354432434446e-07
Rt4854 T659 T2032 6701685.3052888718
Rt4855 T659 T2209 4466746.4879610436
Rt4856 T659 T2213 2481269.1730290609
Gcorr1834 T659 T5057 T659 T5057 -3.5477354432424753e-07
Rt4857 T659 T5385 6701685.3052568464
Rt4858 T659 T5565 4466746.4879700877
Rt4859 T659 T5569 2481269.1730312752
Rt4860 T660 T734 554493.8964773271
Rt4861 T660 T737 415249.86741669627
Gcorr1835 T660 T1065 T660 T1065 -2.0091158202163371e-07
Rt4862 T660 T2119 1501932.1787757978
Rt4863 T660 T2198 8667924.7903910745
Gcorr1836 T660 T2254 T660 T2254 -1.6253075467188876e-07
Gcorr1837 T660 T4419 T660 T4419 -2.0091158202205588e-07
Rt4864 T660 T5476 1501932.1787751911
Rt4865 T660 T5555 8667924.7904031351
Gcorr1838 T660 T5609 T660 T5609 -1.6253075467157785e-07
Rt4866 T661 T709 562809.58848209016
Rt4867 T661 T711 481890.60449230397
Rt4868 T661 T1094 5229525.1704790387
Rt4869 T661 T1097 10544386.65500728
Rt4870 T661 T2309 7461031.7515942799
Rt4871 T661 T4448 5229525.1704950975
Rt4872 T661 T4451 10544386.654942505
Rt4873 T661 T5663 7461031.7515941784
Rt4874 T662 T730 549564.79142321169
Rt4875 T662 T732 416938.5441399485
Gcorr1839 T662 T1081 T662 T1081 -2.1784124717548799e-07
Rt4876 T662 T1083 798841.33578162198
Gcorr1840 T662 T1534 T662 T1534 -1.5773219405994983e-07
Gcorr1841 T662 T2244 T662 T2244 -4.5793466354615896e-07
Gcorr1842 T662 T4435 T662 T4435 -2.1784124717596587e-07
Rt4877 T662 T4437 798841.33578103944
Gcorr1843 T662 T4888 T662 T4888 -1.5773219406028102e-07
Gcorr1844 T662 T5599 T662 T5599 -4.5793466354626558e-07
Rt4878 T663 T735 551393.60351948207
Rt4879 T663 T738 323469.29514636402
Gcorr1845 T663 T1214 T663 T1214 -5.5226948233942456e-07
Rt4880 T663 T1218 4004914.5081497752
Rt4881 T663 T1953 7914817.0903483182
Gcorr1846 T663 T2321 T663 T2321 -2.3080443876248644e-07
Rt4882 T663 T2366 1212459.3051928009
Gcorr1847 T663 T4568 T663 T4568 -5.5119811293861112e-07
Gcorr1848 T663 T4572 T663 T4572 -7.8259808578913422e-08
Gcorr1849 T663 T5274 T663 T5274 -1.4167411559378812e-07
Rt4883 T663 T5721 1333877.9144155597
Rt4884 T663 T6067 2277008.073009395
Rt4885 T664 T739 485066.23429216939
Rt4886 T664 T742 426760.14979566738
Gcorr1850 T664 T1062 T664 T1062 -1.561936739350559e-07
Rt4887 T664 T1064 6433748.6139626065
Rt4888 T664 T1066 2572140.9081758414
Rt4889 T664 T1067 34295417.366232187
Gcorr1851 T664 T4416 T664 T4416 -1.5619367393565669e-07
Rt4890 T664 T4418 6433748.6139490576
Rt4891 T664 T4420 2572140.9081775961
Rt4892 T664 T4421 34295417.365601882
Rt4893 T665 T731 517209.2461459983
Rt4894 T665 T733 478764.95809498482
Gcorr1852 T665 T1283 T665 T1283 -6.0696070038916061e-08
Rt4895 T665 T1978 6936909.2576464601
Rt4896 T665 T2394 10751793.960486477
Rt4897 T665 T2405 4135019.1265358618
Rt4898 T665 T4637 3647927.0979803503
Rt4899 T665 T5364 3414380.6586246905
Gcorr1853 T665 T5717 T665 T5717 -4.7897851465393397e-08
Gcorr1854 T665 T5741 T665 T5741 -1.00804384745511e-07
Rt4900 T666 T705 479081.52625306865
Rt4901 T666 T706 563775.52025905414
Rt4902 T666 T905 3620953.1943910099
Gcorr1855 T666 T1394 T666 T1394 -5.6011292839025453e-08
Rt4903 T666 T1488 2889695.6370911472
Gcorr1856 T666 T2136 T666 T2136 -1.4550852150390077e-07
Rt4904 T666 T4259 3620953.194390757
Gcorr1857 T666 T4748 T666 T4748 -5.6011292839026869e-08
Rt4905 T666 T4842 2889695.6370917745
Gcorr1858 T666 T5492 T666 T5492 -1.455085215038464e-07
Rt4906 T667 T740 546719.05013953045
Rt4907 T667 T741 479191.54952178162
Rt4908 T667 T1210 11555361.390217157
Rt4909 T667 T1212 18968256.362845954
Rt4910 T667 T2389 2357610.8031930868
Gcorr1859 T667 T2436 T667 T2436 -1.4624148277526728e-07
Rt4911 T667 T4564 11555361.390211597
Rt4912 T667 T4566 18968256.362867676
Rt4913 T667 T5745 2357610.8031938476
Gcorr1860 T667 T5790 T667 T5790 -1.4624148277511442e-07
Rt4914 T668 T719 346195.80416117318
Rt4915 T668 T721 431005.69984336151
Gcorr1861 T668 T1090 T668 T1090 -4.3242569790859257e-07
Rt4916 T668 T1091 867555.04358139134
Gcorr1862 T668 T1092 T668 T1092 -1.5438744212706032e-07
Rt4917 T668 T1093 14410841.780735575
Gcorr1863 T668 T2110 T668 T2110 -2.1576158762313081e-07
Gcorr1864 T668 T4444 T668 T4444 -4.3242569790886426e-07
Rt4918 T668 T4445 867555.04358155921
Gcorr1865 T668 T4446 T668 T4446 -1.5438744212708909e-07
Rt4919 T668 T4447 14410841.780597083
Gcorr1866 T668 T5466 T668 T5466 -2.1576158762327681e-07
Rt4920 T669 T720 495551.09895576589
Rt4921 T669 T722 558235.5661344626
Gcorr1867 T669 T1657 T669 T1657 -1.4338120598084624e-07
Rt4922 T669 T1790 9532044.0423102025
Rt4923 T669 T1868 2977958.4882977116
Rt4924 T669 T2535 8186422.3852632418
Gcorr1868 T669 T5012 T669 T5012 -1.4338120598084632e-07
Rt4925 T669 T5145 9566539.8572407439
Rt4926 T669 T5223 2921187.7241981803
Rt4927 T669 T5908 8620260.1906911898
Rt4928 T670 T699 447016.45769454754
Rt4929 T670 T751 463573.70147011703
Rt4930 T670 T816 419751.41393729724
Gcorr1869 T670 T1628 T670 T1628 -1.5381502920886753e-07
Rt4931 T670 T2087 4553780.2604880724
Rt4932 T670 T2089 856549.14699072437
Gcorr1870 T670 T2167 T670 T2167 -6.4293347296459879e-07
Gcorr1871 T670 T2649 T670 T2649 -2.1133156999754631e-07
Gcorr1872 T670 T4982 T670 T4982 -1.5381502920873116e-07
Rt4933 T670 T5441 4553780.260488038
Rt4934 T670 T5443 856549.14699084696
Gcorr1873 T670 T5523 T670 T5523 -6.4293347296464633e-07
Gcorr1874 T670 T6003 T670 T6003 -2.1133156999747214e-07
Rt4935 T671 T718 853065.55747133051
Rt4936 T671 T1374 22433743.156387564
Rt4937 T671 T1674 20366801.11676915
Rt4938 T671 T2142 2319369.4320930517
Gcorr1875 T671 T2272 T671 T2272 -1.5749770725056184e-07
Rt4939 T671 T4728 22433743.156318583
Rt4940 T671 T5028 20366801.116624214
Rt4941 T671 T5498 2319369.4320960245
Gcorr1876 T671 T5626 T671 T5626 -1.5749770725049818e-07
Rt4942 T672 T767 455817.055099955
Rt4943 T672 T783 419256.00409184495
Rt4944 T672 T797 279029.73279112036
Gcorr1877 T672 T1136 T672 T1136 -2.2788493736959562e-07
Gcorr1878 T672 T1137 T672 T1137 -2.7128571349017363e-07
Rt4945 T672 T1138 831264.90372838697
Gcorr1879 T672 T1148 T672 T1148 -3.0225863227387748e-07
Rt4946 T672 T2147 21053496.055157889
Gcorr1880 T672 T4490 T672 T4490 -2.2788493736998626e-07
Gcorr1881 T672 T4491 T672 T4491 -2.7128571349021063e-07
Rt4947 T672 T4492 831264.90372806718
Gcorr1882 T672 T4502 T672 T4502 -3.0225863227384265e-07
Rt4948 T672 T5503 21053496.055190355
Rt4949 T673 T722 530755.504660537
Rt4950 T673 T726 513223.53762502864
Rt4951 T673 T1226 6813473.9722810257
Gcorr1883 T673 T1227 T673 T1227 -1.4913500199186991e-07
Rt4952 T673 T1232 12229545.975444581
Rt4953 T673 T2107 2911955.206219689
Rt4954 T673 T4580 6813473.9722875347
Gcorr1884 T673 T4581 T673 T4581 -1.4913500199167187e-07
Rt4955 T673 T4586 12229545.975459781
Rt4956 T673 T5463 2911955.2062193421
Rt4957 T674 T702 420976.17039065203
Rt4958 T674 T704 518432.40938341094
Rt4959 T674 T1527 1546169.7647787835
Gcorr1885 T674 T1673 T674 T1673 -1.7808340579535653e-07
Rt4960 T674 T1701 7539339.2072716784
Gcorr1886 T674 T1703 T674 T1703 -1.8032985163516586e-07
Rt4961 T674 T4881 1546169.7647773146
Gcorr1887 T674 T5027 T674 T5027 -1.7808340579570998e-07
Rt4962 T674 T5055 7539339.207307728
Gcorr1888 T674 T5057 T674 T5057 -1.8032985163479552e-07
Rt4963 T675 T732 394814.01484731567
Rt4964 T675 T734 568086.11658094695
Rt4965 T675 T1070 18679228.78171549
Gcorr1889 T675 T1079 T675 T1079 -1.8038068043987224e-07
Rt4966 T675 T1080 835434.27636115067
Gcorr1890 T675 T1081 T675 T1081 -2.1799288803177017e-07
Gcorr1891 T675 T1294 T675 T1294 -4.2817017376195536e-07
Rt4967 T675 T4424 18679228.781871594
Gcorr1892 T675 T4433 T675 T4433 -1.8038068044025782e-07
Rt4968 T675 T4434 835434.27636063541
Gcorr1893 T675 T4435 T675 T4435 -2.179928880316919e-07
Gcorr1894 T675 T4648 T675 T4648 -4.281701737619416e-07
Rt4969 T676 T721 410009.99995184509
Rt4970 T676 T725 627153.50102539244
Rt4971 T676 T1089 1371799.3700233721
Gcorr1895 T676 T1090 T676 T1090 -1.8243553452739605e-07
Rt4972 T676 T1285 19253963.916181937
Gcorr1896 T676 T1286 T676 T1286 -1.7565732888506996e-07
Rt4973 T676 T4443 1371799.3700243419
Gcorr1897 T676 T4444 T676 T4444 -1.8243553452702259e-07
Rt4974 T676 T4639 19253963.916019049
Gcorr1898 T676 T4640 T676 T4640 -1.7565732888537047e-07
Rt4975 T677 T741 438268.94153206609
Rt4976 T677 T743 712159.49982218165
Rt4977 T677 T1209 8422044.2763368115
Gcorr1899 T677 T1211 T677 T1211 -5.5718131741859091e-08
Rt4978 T677 T2128 2757804.6955569875
Rt4979 T677 T4563 8422044.2763357889
Gcorr1900 T677 T4565 T677 T4565 -5.5718131741990335e-08
Rt4980 T677 T5484 2757804.6955561209
Rt4981 T678 T706 547902.58139970736
Rt4982 T678 T708 492497.32501162839
Rt4983 T678 T1785 3823331.5909969676
Rt4984 T678 T1943 14410820.243494309
Rt4985 T678 T2567 5687905.2472649431
Gcorr1901 T678 T2597 T678 T2597 -8.5149951324889121e-08
Rt4986 T678 T5139 3823331.5909959436
Rt4987 T678 T5299 14410820.243500181
Rt4988 T678 T5921 5687905.2472746773
Gcorr1902 T678 T5951 T678 T5951 -8.5149951324632801e-08
Rt4989 T679 T703 556729.75242423092
Rt4990 T679 T705 501207.2937922579
Gcorr1903 T679 T1794 T679 T1794 -3.4592620983492452e-08
Rt4991 T679 T2156 7735874.7955089398
Rt4992 T679 T2163 3064583.3654634827
Gcorr1904 T679 T5149 T679 T5149 -3.4592620983494053e-08
Rt4993 T679 T5512 7735874.7955089891
Rt4994 T679 T5519 3064583.3654634873
Rt4995 T680 T738 417911.15624555998
Rt4996 T680 T740 583297.52471575828
Rt4997 T680 T1213 2782604.3955092188
Gcorr1905 T680 T1214 T680 T1214 -1.2873218295664612e-07
Rt4998 T680 T1216 4242793.186910226
Gcorr1906 T680 T2609 T680 T2609 -4.1801416722827972e-08
Rt4999 T680 T4567 2782604.3955073436
Gcorr1907 T680 T4568 T680 T4568 -1.2873218295670875e-07
Rt5000 T680 T4570 4242793.1869116193
Gcorr1908 T680 T5963 T680 T5963 -4.1801416722932977e-08
Rt5001 T681 T710 891001.46653355833
Rt5002 T681 T742 301579.7112818305
Rt5003 T681 T1058 10913849.711878244
Rt5004 T681 T1059 2636372.8958955463
Rt5005 T681 T1060 2538440.2244064203
Gcorr1909 T681 T1062 T681 T1062 -4.2717077209704073e-07
Rt5006 T681 T4412 10913849.711946134
Rt5007 T681 T4413 2636372.8958959905
Rt5008 T681 T4414 2538440.2244058591
Gcorr1910 T681 T4416 T681 T4416 -4.2717077209649693e-07
Rt5009 T682 T729 332803.43558705878
Rt5010 T682 T730 391679.35148306174
Gcorr1911 T682 T1082 T682 T1082 -4.2958857607419256e-07
Gcorr1912 T682 T1084 T682 T1084 -4.2624321240199727e-07
Rt5011 T682 T1085 343671.92599835573
Gcorr1913 T682 T1086 T682 T1086 -3.9978194402127949e-07
Gcorr1914 T682 T2111 T682 T2111 -4.1526671275977058e-07
Gcorr1915 T682 T2112 T682 T2112 -4.0774832016869897e-07
Gcorr1916 T682 T2113 T682 T2113 -4.0772300315427338e-07
Gcorr1917 T682 T4436 T682 T4436 -4.2958857607422734e-07
Gcorr1918 T682 T4438 T682 T4438 -4.2624321240178986e-07
Rt5012 T682 T4439 343671.9259983938
Gcorr1919 T682 T4440 T682 T4440 -3.9978194402100362e-07
Gcorr1920 T682 T5464 T682 T5464 -4.0772300315445136e-07
Gcorr1921 T682 T5465 T682 T5465 -4.1526671275961425e-07
Gcorr1922 T682 T5473 T682 T5473 -4.0774832016880612e-07
Rt5013 T683 T737 326089.34509846324
Rt5014 T683 T739 690394.34252823738
Rt5015 T683 T1063 3193414.2600216265
Gcorr1923 T683 T1065 T683 T1065 -4.1997235110403589e-07
Rt5016 T683 T1069 2195569.5745584485
Rt5017 T683 T2131 13175065.411849432
Rt5018 T683 T4417 3193414.2600230761
Gcorr1924 T683 T4419 T683 T4419 -4.1997235110381699e-07
Rt5019 T683 T4423 2195569.5745560247
Rt5020 T683 T5487 13175065.411950532
Rt5021 T684 T707 343484.87353199115
Rt5022 T684 T709 610896.80520518613
Rt5023 T684 T1702 2559361.9813000616
Gcorr1925 T684 T1786 T684 T1786 -4.076707765255993e-07
Rt5024 T684 T2002 29189494.384160034
Rt5025 T684 T2038 2473438.4181817132
Rt5026 T684 T5056 2559361.9812960383
Gcorr1926 T684 T5140 T684 T5140 -4.0767077652531682e-07
Rt5027 T684 T5354 29189494.384557672
Rt5028 T684 T5391 2473438.4181843619
Rt5029 T685 T733 452188.67866671382
Rt5030 T685 T735 663599.43146167975
Rt5031 T685 T1217 17599396.411593981
Rt5032 T685 T1219 2966341.5901358649
Rt5033 T685 T1220 6334133.6268951232
Gcorr1927 T685 T1221 T685 T1221 -1.2783660070367271e-07
Rt5034 T685 T4571 17599396.411511987
Rt5035 T685 T4573 2966341.5901375464
Rt5036 T685 T4574 6334133.6268962165
Gcorr1928 T685 T4575 T685 T4575 -1.2783660070372192e-07
Rt5037 T686 T728 437687.35609134275
Rt5038 T686 T731 564708.2071318283
Rt5039 T686 T1222 3415622.1782698277
Gcorr1929 T686 T1223 T686 T1223 -1.0849992180121714e-07
Rt5040 T686 T1224 3065841.344644214
Gcorr1930 T686 T2407 T686 T2407 -8.7047229528353538e-08
Rt5041 T686 T4576 3245232.8590033655
Gcorr1931 T686 T4577 T686 T4577 -1.0849992180144277e-07
Rt5042 T686 T4578 2889971.8390431148
Gcorr1932 T686 T5462 T686 T5462 -1.2226849278687122e-07
Rt5043 T687 T712 454588.31933797983
Rt5044 T687 T720 540270.95351956214
Rt5045 T687 T1253 28700597.97912208
Rt5046 T687 T1344 15095616.792471359
Rt5047 T687 T2106 2364482.4989004023
Gcorr1933 T687 T2386 T687 T2386 -1.0179634000500002e-07
Rt5048 T687 T4607 28700597.979359236
Rt5049 T687 T4698 15095616.792451996
Rt5050 T687 T5472 2364482.4989006929
Gcorr1934 T687 T5742 T687 T5742 -1.0179634000474793e-07
Rt5051 T688 T711 413800.60014148295
Rt5052 T688 T719 621961.28269710531
Gcorr1935 T688 T1104 T688 T1104 -1.6713877897281452e-07
Gcorr1936 T688 T2098 T688 T2098 -1.7333410101540825e-07
Rt5053 T688 T2162 1550224.4396301946
Rt5054 T688 T2189 8501879.2699736692
Gcorr1937 T688 T4458 T688 T4458 -1.6713877897268821e-07
Gcorr1938 T688 T5451 T688 T5451 -1.7333410101597939e-07
Rt5055 T688 T5518 1550224.4396297473
Rt5056 T688 T5546 8501879.2699551582
Rt5057 T689 T756 555283.55588476686
Rt5058 T689 T779 609580.57880905818
Rt5059 T689 T782 324720.35006171919
Gcorr1939 T689 T1436 T689 T1436 -9.6929094498875583e-08
Rt5060 T689 T1792 5423570.3857504167
Rt5061 T689 T2118 2351997.8299014168
Gcorr1940 T689 T2120 T689 T2120 -1.1946492131036984e-07
Gcorr1941 T689 T4790 T689 T4790 -9.6929094498781628e-08
Rt5062 T689 T5147 5423570.3857425768
Rt5063 T689 T5471 2351997.8299033563
Gcorr1942 T689 T5475 T689 T5475 -1.1946492131038238e-07
Rt5064 T690 T785 552283.0504388517
Rt5065 T690 T791 565248.51265363337
Rt5066 T690 T798 295149.26825689327
Gcorr1943 T690 T1753 T690 T1753 -3.8200875974357313e-07
Gcorr1944 T690 T2187 T690 T2187 -3.3812662033539079e-07
Rt5067 T690 T2210 3362822.1685561393
Rt5068 T690 T2499 2053958.7721030538
Rt5069 T690 T2588 3164326.706477324
Gcorr1945 T690 T5107 T690 T5107 -3.8200875974304225e-07
Gcorr1946 T690 T5544 T690 T5544 -3.3812662033513504e-07
Rt5070 T690 T5566 3362822.1685592392
Rt5071 T690 T5853 2053958.7721051706
Rt5072 T690 T5942 3164326.7064774581
Rt5073 T691 T710 419984.19842041651
Gcorr1947 T691 T1453 T691 T1453 -8.9776276334174897e-08
Gcorr1948 T691 T2100 T691 T2100 -2.0695493597760121e-07
Rt5074 T691 T2157 13659800.436309179
Rt5075 T691 T2184 1671830.7413836471
Gcorr1949 T691 T4807 T691 T4807 -8.9776276334458124e-08
Gcorr1950 T691 T5453 T691 T5453 -2.0695493597768888e-07
Rt5076 T691 T5513 13659800.436258471
Rt5077 T691 T5541 1671830.7413833772
Rt5078 T692 T774 1002548.81668775
Rt5079 T692 T812 315330.76352908218
Rt5080 T692 T820 432016.31514927599
Gcorr1951 T692 T1239 T692 T1239 -1.3758089958133806e-07
Gcorr1952 T692 T2011 T692 T2011 -1.1877744108813005e-07
Rt5081 T692 T2330 3083564.1318217372
Rt5082 T692 T2379 3121826.3631034987
Gcorr1953 T692 T4593 T692 T4593 -1.3758089958148211e-07
Gcorr1954 T692 T5363 T692 T5363 -1.1877744108827996e-07
Rt5083 T692 T5683 3083564.1318246075
Rt5084 T692 T5733 3121826.363097718
Rt5085 T693 T806 1717052.6980374283
Rt5086 T693 T824 257378.94605284915
Gcorr1955 T693 T1545 T693 T1545 -1.6704345364885069e-07
Rt5087 T693 T1811 2175097.1010236861
Rt5088 T693 T1812 5254492.0190776857
Gcorr1956 T693 T2508 T693 T2508 -1.4506694371176479e-07
Gcorr1957 T693 T4899 T693 T4899 -1.6704345364908831e-07
Rt5089 T693 T5166 2175097.1010240181
Rt5090 T693 T5167 5254492.0190740358
Gcorr1958 T693 T5862 T693 T5862 -1.450669437115915e-07
Rt5091 T694 T695 424151.47060125362
Rt5092 T694 T714 370720.89340452815
Rt5093 T694 T769 583788.87287516519
Rt5094 T694 T1022 1325871.7545130351
Gcorr1959 T694 T1036 T694 T1036 -2.8351949242784851e-07
Gcorr1960 T694 T1254 T694 T1254 -1.4336011127722532e-07
Rt5095 T694 T2355 17232704.169319179
Rt5096 T694 T4376 1325871.7545130122
Gcorr1961 T694 T4390 T694 T4390 -2.8351949242742945e-07
Gcorr1962 T694 T4608 T694 T4608 -1.4336011127748697e-07
Rt5097 T694 T5708 17232704.169370521
Rt5098 T695 T758 405493.81769762904
Rt5099 T695 T1020 3092547.6079632961
Gcorr1963 T695 T1022 T695 T1022 -1.3913286569790096e-07
Rt5100 T695 T1254 3203700.7029071278
Gcorr1964 T695 T2152 T695 T2152 -1.1065554122110048e-07
Rt5101 T695 T4374 3092547.6079643406
Gcorr1965 T695 T4376 T695 T4376 -1.3913286569764544e-07
Rt5102 T695 T4608 3203700.7029078454
Gcorr1966 T695 T5508 T695 T5508 -1.1065554122117938e-07
Rt5103 T696 T780 445335.29090511909
Rt5104 T696 T833 591282.75320595398
Rt5105 T696 T1752 5634205.3182789609
Rt5106 T696 T1774 107907267.57354739
Rt5107 T696 T1959 2396122.857158551
Gcorr1967 T696 T2260 T696 T2260 -1.4239078863415985e-07
Rt5108 T696 T5106 5634205.318271907
Rt5109 T696 T5128 107907267.57765816
Rt5110 T696 T5313 2396122.8571587745
Gcorr1968 T696 T5615 T696 T5615 -1.4239078863399322e-07
Rt5111 T697 T698 849433.25354136282
Rt5112 T697 T830 1052513.8501715446
Gcorr1969 T697 T1517 T697 T1517 -4.6610062358690204e-07
Gcorr1970 T697 T2068 T697 T2068 -8.3400946884862838e-08
Rt5113 T697 T2158 2831064.3505319594
Rt5114 T697 T2246 1815250.6032747831
Gcorr1971 T697 T4871 T697 T4871 -4.6610062358713514e-07
Gcorr1972 T697 T5422 T697 T5422 -8.3400946884783667e-08
Rt5115 T697 T5514 2831064.3505363874
Rt5116 T697 T5601 1815250.603272463
Rt5117 T698 T823 550271.49069433892
Rt5118 T698 T830 236853.30736944525
Rt5119 T698 T844 253046.31558418256
Gcorr1973 T698 T1517 T698 T1517 -1.475517537165008e-07
Rt5120 T698 T2091 2464367.8454725514
Rt5121 T698 T2246 3824413.6599641535
Gcorr1974 T698 T2274 T698 T2274 -2.0910390761063698e-07
Gcorr1975 T698 T4871 T698 T4871 -1.4755175371653397e-07
Rt5122 T698 T5444 2464367.8454719991
Rt5123 T698 T5601 3824413.6599663701
Gcorr1976 T698 T5628 T698 T5628 -2.0910390761054518e-07
Rt5124 T699 T749 434578.68015053979
Rt5125 T699 T766 555387.94534895103
Gcorr1977 T699 T2089 T699 T2089 -1.0282910568951193e-07
Rt5126 T699 T2166 3687072.8916549296
Rt5127 T699 T2167 3058440.27134878
Gcorr1978 T699 T2201 T699 T2201 -1.2558556353504803e-07
Gcorr1979 T699 T5443 T699 T5443 -1.0282910568959255e-07
Rt5128 T699 T5522 3687072.8916567694
Rt5129 T699 T5523 3058440.2713461518
Gcorr1980 T699 T5558 T699 T5558 -1.2558556353511563e-07
Rt5130 T700 T703 483136.09156129061
Rt5131 T700 T747 2236509.1104913685
Rt5132 T700 T771 420820.86065341957
Gcorr1981 T700 T897 T700 T897 -1.9674410233321649e-07
Rt5133 T700 T898 2819405.8258800791
Rt5134 T700 T899 4518808.7836049553
Rt5135 T700 T900 3593282.2211033008
Gcorr1982 T700 T2156 T700 T2156 -1.4537416997751106e-07
Gcorr1983 T700 T4251 T700 T4251 -1.9674410233321771e-07
Rt5136 T700 T4252 2819405.8258800851
Rt5137 T700 T4253 4518808.7836049683
Rt5138 T700 T4254 3593282.2211033017
Gcorr1984 T700 T5512 T700 T5512 -1.4537416997751183e-07
Rt5139 T701 T702 493517.80883957917
Rt5140 T701 T748 2245779.3033462181
Rt5141 T701 T770 417891.00884406618
Rt5142 T701 T2127 7549775.0640701028
Rt5143 T701 T2161 4793239.3462898517
Rt5144 T701 T2213 5845242.9839622201
Rt5145 T701 T5483 7549775.064118403
Rt5146 T701 T5517 4793239.3462749124
Rt5147 T701 T5569 5845242.9839556031
Rt5148 T702 T704 562915.04249437572
Gcorr1985 T702 T1527 T702 T1527 -4.2658204921550294e-07
Rt5149 T702 T1703 589027.5397302825
Gcorr1986 T702 T2127 T702 T2127 -1.9000250034394148e-07
Gcorr1987 T702 T2209 T702 T2209 -4.8760985455392647e-07
Gcorr1988 T702 T2213 T702 T2213 -1.7235075912586452e-07
Gcorr1989 T702 T4881 T702 T4881 -4.2658204921574212e-07
Rt5150 T702 T5057 589027.53973048972
Gcorr1990 T702 T5483 T702 T5483 -1.9000250034382862e-07
Gcorr1991 T702 T5565 T702 T5565 -4.8760985455409355e-07
Gcorr1992 T702 T5569 T702 T5569 -1.7235075912497691e-07
Rt5151 T703 T705 480603.49211460352
Gcorr1993 T703 T900 T703 T900 -4.2176418499959927e-08
Rt5152 T703 T2136 8533267.7371923644
Rt5153 T703 T2156 2888868.0418203077
Gcorr1994 T703 T4254 T703 T4254 -4.2176418499883006e-08
Rt5154 T703 T5492 8533267.7371995002
Rt5155 T703 T5512 2888868.041820155
Rt5156 T704 T707 435303.79519891477
Rt5157 T704 T1701 6867973.5213127863
Rt5158 T704 T1703 26025076.276698783
Gcorr1995 T704 T1786 T704 T1786 -2.1690874225875188e-07
Rt5159 T704 T2391 2202411.2634976101
Rt5160 T704 T5055 6867973.5213313811
Rt5161 T704 T5057 26025076.276179861
Gcorr1996 T704 T5140 T704 T5140 -2.1690874225905777e-07
Rt5162 T704 T5747 2202411.2634979445
Rt5163 T705 T706 482743.43350559031
Gcorr1997 T705 T1488 T705 T1488 -4.3648112715987167e-08
Rt5164 T705 T1794 2939758.9644038598
Rt5165 T705 T2136 3549656.1851983792
Gcorr1998 T705 T2156 T705 T2156 -1.5706635613875726e-07
Gcorr1999 T705 T4842 T705 T4842 -4.3648112715912992e-08
Rt5166 T705 T5149 2939758.9644032903
Rt5167 T705 T5492 3549656.1852007555
Gcorr2000 T705 T5512 T705 T5512 -1.5706635613871163e-07
Rt5168 T706 T708 484411.95029041998
Rt5169 T706 T1488 3361515.5041669654
Gcorr2001 T706 T1532 T706 T1532 -5.1631449742495921e-08
Rt5170 T706 T1785 3077576.3438933915
Gcorr2002 T706 T1794 T706 T1794 -1.4961893814173741e-07
Rt5171 T706 T4842 3361515.5041669672
Gcorr2003 T706 T4886 T706 T4886 -5.1631449742497357e-08
Rt5172 T706 T5139 3077576.3438933957
Gcorr2004 T706 T5149 T706 T5149 -1.4961893814173823e-07
Rt5173 T707 T709 325455.09075545816
Gcorr2005 T707 T1702 T707 T1702 -4.2418784738464239e-07
Rt5174 T707 T1786 386304.72636398941
Gcorr2006 T707 T2038 T707 T2038 -3.9869485473611796e-07
Gcorr2007 T707 T2262 T707 T2262 -4.8025639995767546e-07
Gcorr2008 T707 T2309 T707 T2309 -4.4557417268030926e-07
Gcorr2009 T707 T2391 T707 T2391 -4.1875122076700146e-07
Gcorr2010 T707 T5056 T707 T5056 -4.2418784738470099e-07
Rt5175 T707 T5140 386304.72636402491
Gcorr2011 T707 T5391 T707 T5391 -3.9869485473648907e-07
Gcorr2012 T707 T5617 T707 T5617 -4.8025639995712468e-07
Gcorr2013 T707 T5663 T707 T5663 -4.4557417268062044e-07
Gcorr2014 T707 T5747 T707 T5747 -4.187512207665763e-07
Rt5176 T708 T712 492532.25094653579
Rt5177 T708 T1532 3556511.6573592047
Gcorr2015 T708 T1778 T708 T1778 -1.0423584705150832e-07
Gcorr2016 T708 T1785 T708 T1785 -1.7761881478999948e-07
Rt5178 T708 T2597 2370542.4010737883
Rt5179 T708 T4886 3556511.6573581155
Gcorr2017 T708 T5132 T708 T5132 -1.0423584705149546e-07
Gcorr2018 T708 T5139 T708 T5139 -1.7761881478996853e-07
Rt5180 T708 T5951 2370542.4010745347
Rt5181 T709 T711 447761.85685009597
Gcorr2019 T709 T1104 T709 T1104 -1.5392068468312136e-07
Gcorr2020 T709 T1786 T709 T1786 -4.8600171894224355e-07
Rt5182 T709 T2038 2640534.0451169736
Rt5183 T709 T2309 1465469.3335266898
Gcorr2021 T709 T4458 T709 T4458 -1.5392068468340829e-07
Gcorr2022 T709 T5140 T709 T5140 -4.8600171894201443e-07
Rt5184 T709 T5391 2640534.045119348
Rt5185 T709 T5663 1465469.3335258404
Rt5186 T710 T742 586555.5609574304
Rt5187 T710 T836 400261.74892614508
Rt5188 T710 T1059 8047743.5338034751
Rt5189 T710 T1453 4820396.3517219312
Rt5190 T710 T2157 6642264.0768221654
Rt5191 T710 T4413 8047743.5338076185
Rt5192 T710 T4807 4820396.3517309492
Rt5193 T710 T5513 6642264.0768023636
Rt5194 T711 T719 354340.69336688431
Gcorr2023 T711 T1092 T711 T1092 -1.8424232976473837e-07
Rt5195 T711 T1094 19798816.283810779
Rt5196 T711 T1104 872518.57216304215
Gcorr2024 T711 T2162 T711 T2162 -4.1202087340879117e-07
Gcorr2025 T711 T2309 T711 T2309 -1.7918951946305503e-07
Gcorr2026 T711 T4446 T711 T4446 -1.8424232976504208e-07
Rt5197 T711 T4448 19798816.283678424
Rt5198 T711 T4458 872518.57216318336
Gcorr2027 T711 T5518 T711 T5518 -4.120208734091033e-07
Gcorr2028 T711 T5663 T711 T5663 -1.7918951946259437e-07
Rt5199 T712 T720 574614.94322291191
Rt5200 T712 T1778 3294855.6656352687
Gcorr2029 T712 T2106 T712 T2106 -2.1480032801970597e-08
Rt5201 T712 T2386 3004223.7260015989
Gcorr2030 T712 T2597 T712 T2597 -9.5120130700542969e-08
Gcorr2031 T712 T2696 T712 T2696 -9.8605201628283661e-08
Rt5202 T712 T5132 3294855.6656373772
Gcorr2032 T712 T5472 T712 T5472 -2.1480032802080149e-08
Rt5203 T712 T5742 3004223.7260004319
Gcorr2033 T712 T5951 T712 T5951 -9.5120130700560796e-08
Gcorr2034 T712 T6050 T712 T6050 -9.8605201628094084e-08
Rt5204 T713 T723 628896.76378745516
Rt5205 T713 T1697 13093095.677096633
Gcorr2035 T713 T1974 T713 T1974 -2.9901659542487752e-07
Rt5206 T713 T2205 1745272.5827624912
Rt5207 T713 T5051 13093095.677093476
Gcorr2036 T713 T5328 T713 T5328 -2.9901659542496095e-07
Rt5208 T713 T5561 1745272.5827623003
Rt5209 T714 T769 761702.25123523781
Gcorr2037 T714 T1022 T714 T1022 -2.8753849232804419e-07
Rt5210 T714 T1023 23703324.949917693
Rt5211 T714 T1036 1291346.3241771744
Gcorr2038 T714 T2095 T714 T2095 -1.5003144559046013e-07
Gcorr2039 T714 T4376 T714 T4376 -2.8753849232811036e-07
Rt5212 T714 T4377 23703324.94985998
Rt5213 T714 T4390 1291346.3241776144
Gcorr2040 T714 T5448 T714 T5448 -1.5003144559023551e-07
Rt5214 T715 T829 408181.84151117509
Gcorr2041 T715 T1911 T715 T1911 -1.6766479856306515e-07
Rt5215 T715 T2037 2900910.1760935597
Rt5216 T715 T2426 36825845.779816076
Rt5217 T715 T2579 7717744.6818095995
Gcorr2042 T715 T5268 T715 T5268 -1.6766479856287734e-07
Rt5218 T715 T5390 2900910.1760921278
Rt5219 T715 T5779 36825845.78003069
Rt5220 T715 T5933 7717744.6818216229
Rt5221 T716 T813 387575.62175496388
Rt5222 T716 T1530 41067240.92328421
Rt5223 T716 T1692 2788885.3668009774
Rt5224 T716 T1693 7495662.3473443333
Gcorr2043 T716 T1700 T716 T1700 -1.5647396047692703e-07
Rt5225 T716 T4884 41067240.923360445
Rt5226 T716 T5046 2788885.3667957298
Rt5227 T716 T5047 7495662.3473774921
Gcorr2044 T716 T5054 T716 T5054 -1.5647396047696879e-07
Rt5228 T717 T809 1385960.6307214852
Rt5229 T717 T1773 212711709.29871997
Gcorr2045 T717 T1815 T717 T1815 -5.5473418582074409e-07
Rt5230 T717 T2034 1295740.1813279931
Rt5231 T717 T2347 7006923.5782031501
Rt5232 T717 T5127 212711709.30716464
Gcorr2046 T717 T5170 T717 T5170 -5.5473418581989897e-07
Rt5233 T717 T5387 1295740.1813294941
Rt5234 T717 T5700 7006923.5781917106
Gcorr2047 T718 T1373 T718 T1373 -3.423638429195734e-07
Rt5235 T718 T1374 1284731.7558995925
Rt5236 T718 T1523 19905579.143006567
Gcorr2048 T718 T1545 T718 T1545 -1.1908213330689154e-07
Gcorr2049 T718 T4727 T718 T4727 -3.4236384292090768e-07
Rt5237 T718 T4728 1284731.7558977709
Rt5238 T718 T4877 19905579.142980695
Gcorr2050 T718 T4899 T718 T4899 -1.1908213330672863e-07
Rt5239 T719 T721 571342.10290186678
Rt5240 T719 T1090 3091173.1092266827
Gcorr2051 T719 T1091 T719 T1091 -4.3956472619347867e-07
Rt5241 T719 T1092 1492723.9834473161
Gcorr2052 T719 T1104 T719 T1104 -4.3037686802334644e-07
Rt5242 T719 T2162 3359255.3264480117
Rt5243 T719 T4444 3091173.1092333235
Gcorr2053 T719 T4445 T719 T4445 -4.3956472619348413e-07
Rt5244 T719 T4446 1492723.9834451198
Gcorr2054 T719 T4458 T719 T4458 -4.3037686802318751e-07
Rt5245 T719 T5518 3359255.3264530543
Rt5246 T720 T722 484759.90045308031
Rt5247 T720 T1344 7811650.476544668
Gcorr2055 T720 T1868 T720 T1868 -4.4236011355184102e-08
Rt5248 T720 T2386 3283543.5686746407
Rt5249 T720 T2535 30455783.337546386
Rt5250 T720 T4698 8110894.2158211609
Gcorr2056 T720 T5223 T720 T5223 -4.9710101805362383e-08
Rt5251 T720 T5742 3342464.3847253011
Rt5252 T720 T5908 20661111.914380159
Rt5253 T721 T725 499524.93010012701
Rt5254 T721 T1088 9133652.5218868088
Gcorr2057 T721 T1089 T721 T1089 -1.8529475681756452e-07
Rt5255 T721 T1090 1549360.4417730621
Gcorr2058 T721 T1091 T721 T1091 -1.4845796181655623e-07
Rt5256 T721 T4442 9133652.5219070986
Gcorr2059 T721 T4443 T721 T4443 -1.8529475681797875e-07
Rt5257 T721 T4444 1549360.4417718241
Gcorr2060 T721 T4445 T721 T4445 -1.4845796181641748e-07
Rt5258 T722 T726 491335.92366979929
Gcorr2061 T722 T1344 T722 T1344 -1.6326404928849576e-07
Rt5259 T722 T2107 2925710.7461648695
Gcorr2062 T722 T2479 T722 T2479 -1.5372433375088473e-07
Rt5260 T722 T2535 2523014.9025426866
Gcorr2063 T722 T4698 T722 T4698 -1.6530388173886086e-07
Rt5261 T722 T5463 3199788.3948391313
Gcorr2064 T722 T5846 T722 T5846 -8.6650391678938955e-08
Rt5262 T722 T5908 2773204.1540204803
Rt5263 T723 T736 538859.43064204697
Rt5264 T723 T1508 5996366.7343689576
Rt5265 T723 T2205 9167994.7013013717
Rt5266 T723 T2212 14888307.270845212
Rt5267 T723 T4862 5996366.7343731644
Rt5268 T723 T5561 9167994.7012668177
Rt5269 T723 T5568 14888307.270910926
Rt5270 T724 T763 715769.87836945546
Rt5271 T724 T1153 2966065.9382437831
Gcorr2065 T724 T1154 T724 T1154 -1.2768201430541627e-07
Rt5272 T724 T1155 2928264.945885086
Gcorr2066 T724 T2123 T724 T2123 -1.7903029126354576e-07
Rt5273 T724 T4507 2966065.9382433994
Gcorr2067 T724 T4508 T724 T4508 -1.2768201430565013e-07
Rt5274 T724 T4509 2928264.9458855125
Gcorr2068 T724 T5479 T724 T5479 -1.7903029126330838e-07
Rt5275 T725 T729 501325.44304611871
Rt5276 T725 T1086 6772133.3712031301
Gcorr2069 T725 T1087 T725 T1087 -1.7929906995773111e-07
Rt5277 T725 T1088 2466742.405862872
Rt5278 T725 T1089 21096609.672795344
Rt5279 T725 T4440 6772133.3712369092
Gcorr2070 T725 T4441 T725 T4441 -1.7929906995786944e-07
Rt5280 T725 T4442 2466742.4058569707
Rt5281 T725 T4443 21096609.672838833
Rt5282 T726 T728 491110.32566937053
Rt5283 T726 T1227 2317676.1642671814
Gcorr2071 T726 T2090 T726 T2090 -1.6135971042809499e-07
Gcorr2072 T726 T2107 T726 T2107 -1.2740864397621418e-07
Rt5284 T726 T2479 3591173.4057538295
Rt5285 T726 T4581 2507903.1181816873
Gcorr2073 T726 T5463 T726 T5463 -1.289146363180963e-07
Gcorr2074 T726 T5527 T726 T5527 -1.7488689264199211e-07
Rt5286 T726 T5846 3065407.8247439759
Rt5287 T727 T762 3150835.3875756916
Rt5288 T727 T829 1673826.8253015466
Gcorr2075 T727 T1745 T727 T1745 -4.2388837167625505e-07
Rt5289 T727 T1912 447854.06220076012
Gcorr2076 T727 T2168 T727 T2168 -1.2154354493125246e-07
Gcorr2077 T727 T2260 T727 T2260 -1.0806526421751853e-06
Gcorr2078 T727 T2579 T727 T2579 -1.6453334815025676e-07
Gcorr2079 T727 T5099 T727 T5099 -4.2388837167697365e-07
Rt5290 T727 T5269 447854.06219990377
Gcorr2080 T727 T5524 T727 T5524 -1.2154354493118531e-07
Gcorr2081 T727 T5615 T727 T5615 -1.0806526421789554e-06
Gcorr2082 T727 T5933 T727 T5933 -1.6453334815010718e-07
Rt5291 T728 T731 569880.24341917282
Gcorr2083 T728 T1224 T728 T1224 -1.2885366385757564e-07
Rt5292 T728 T1227 20881400.480738491
Rt5293 T728 T2090 11811042.158360509
Rt5294 T728 T2407 2395466.727768674
Gcorr2084 T728 T4578 T728 T4578 -1.3304882361265714e-07
Rt5295 T728 T4581 12419470.163490806
Rt5296 T728 T5462 2275500.637653796
Rt5297 T728 T5527 29219329.227605075
Rt5298 T729 T730 574897.24311788322
Rt5299 T729 T1084 2461506.360980338
Gcorr2085 T729 T1085 T729 T1085 -3.9745917243322837e-07
Rt5300 T729 T1086 2717840.428390183
Rt5301 T729 T1087 22511242.92435902
Rt5302 T729 T4438 2461506.3609845336
Gcorr2086 T729 T4439 T729 T4439 -3.9745917243335315e-07
Rt5303 T729 T4440 2717840.4283881681
Rt5304 T729 T4441 22511242.92408466
Rt5305 T730 T732 498492.67120987672
Rt5306 T730 T1082 2471089.1416742266
Rt5307 T730 T1083 14227677.757870583
Rt5308 T730 T1084 2836753.100526202
Gcorr2087 T730 T1085 T730 T1085 -4.0632477384831854e-07
Rt5309 T730 T4436 2471089.1416776422
Rt5310 T730 T4437 14227677.757868493
Rt5311 T730 T4438 2836753.1005199389
Gcorr2088 T730 T4439 T730 T4439 -4.0632477384855062e-07
Rt5312 T731 T733 514688.60191558854
Gcorr2089 T731 T1222 T731 T1222 -7.1791109996793927e-08
Gcorr2090 T731 T1978 T731 T1978 -1.2427218700096059e-07
Rt5313 T731 T2394 2454695.0576875419
Rt5314 T731 T2407 4765602.8802527422
Gcorr2091 T731 T4574 T731 T4574 -1.5910352393173334e-07
Rt5315 T731 T4576 10253016.584409498
Rt5316 T731 T4637 2550488.8164333329
Rt5317 T731 T5462 11031942.358480176
Rt5318 T732 T734 568504.71635328757
Gcorr2092 T732 T1080 T732 T1080 -1.9034811472654573e-07
Rt5319 T732 T1081 1395667.6834268898
Rt5320 T732 T1082 10567665.383912083
Gcorr2093 T732 T1083 T732 T1083 -1.9962800332582909e-07
Gcorr2094 T732 T4434 T732 T4434 -1.9034811472708503e-07
Rt5321 T732 T4435 1395667.683426565
Rt5322 T732 T4436 10567665.383900873
Gcorr2095 T732 T4437 T732 T4437 -1.9962800332555974e-07
Rt5323 T733 T735 468069.10090984008
Gcorr2096 T733 T1217 T733 T1217 -1.4416192775211384e-07
Rt5324 T733 T1220 5561724.3695679158
Rt5325 T733 T1283 3482292.4939304055
Rt5326 T733 T2394 10167816.563273365
Gcorr2097 T733 T4571 T733 T4571 -1.59073042546034e-07
Rt5327 T733 T4574 3044645.4699602439
Gcorr2098 T733 T4637 T733 T4637 -8.6547653384807624e-08
Rt5328 T733 T5741 2955691.2342193839
Rt5329 T734 T737 355379.05464774888
Gcorr2099 T734 T1065 T734 T1065 -4.2241482932350102e-07
Rt5330 T734 T1070 2270239.8175329366
Rt5331 T734 T1081 11751371.108963247
Rt5332 T734 T2119 3144751.1321496344
Gcorr2100 T734 T4419 T734 T4419 -4.2241482932362421e-07
Rt5333 T734 T4424 2270239.8175359555
Rt5334 T734 T4435 11751371.108898968
Rt5335 T734 T5476 3144751.132147254
Rt5336 T735 T738 308081.29236070754
Gcorr2101 T735 T1214 T735 T1214 -6.3998100881239983e-07
Rt5337 T735 T1217 1087863.9038893392
Gcorr2102 T735 T1283 T735 T1283 -1.0870389595428016e-07
Rt5338 T735 T2366 3990324.5490599517
Gcorr2103 T735 T4568 T735 T4568 -6.401405670838946e-07
Rt5339 T735 T4571 1086874.5459842961
Rt5340 T735 T5721 4160483.9701093519
Gcorr2104 T735 T5741 T735 T5741 -9.9131565439624063e-08
Rt5341 T736 T818 347276.80429799896
Gcorr2105 T736 T1423 T736 T1423 -4.7999492243154006e-07
Gcorr2106 T736 T1425 T736 T1425 -4.1294546943665711e-07
Gcorr2107 T736 T2186 T736 T2186 -4.2010021331598738e-07
Rt5342 T736 T2212 606948.63623706438
Gcorr2108 T736 T4777 T736 T4777 -4.7999492243168204e-07
Gcorr2109 T736 T4779 T736 T4779 -4.1294546943663551e-07
Gcorr2110 T736 T5543 T736 T5543 -4.2010021331606784e-07
Rt5343 T736 T5568 606948.63623699127
Rt5344 T737 T739 437966.09727546596
Gcorr2111 T737 T1063 T737 T1063 -3.8955242857891161e-07
Rt5345 T737 T1065 614192.60769050475
Gcorr2112 T737 T1069 T737 T1069 -2.0045659178593297e-07
Gcorr2113 T737 T1070 T737 T1070 -1.9438060548176965e-07
Gcorr2114 T737 T2119 T737 T2119 -4.2261138904927752e-07
Gcorr2115 T737 T4417 T737 T4417 -3.8955242857922819e-07
Rt5346 T737 T4419 614192.60769054422
Gcorr2116 T737 T4423 T737 T4423 -2.0045659178620445e-07
Gcorr2117 T737 T4424 T737 T4424 -1.9438060548137779e-07
Gcorr2118 T737 T5476 T737 T5476 -4.2261138904897895e-07
Rt5347 T738 T740 554178.21369004331
Rt5348 T738 T1214 364804.21573325334
Gcorr2119 T738 T1216 T738 T1216 -5.5407229941073656e-07
Gcorr2120 T738 T1217 T738 T1217 -6.3301847184884358e-07
Gcorr2121 T738 T1218 T738 T1218 -5.8995377076576043e-07
Gcorr2122 T738 T2366 T738 T2366 -5.4299911081714876e-07
Rt5349 T738 T4568 364946.00983354135
Gcorr2123 T738 T4570 T738 T4570 -5.5407229941074016e-07
Gcorr2124 T738 T4571 T738 T4571 -6.3301847184811355e-07
Gcorr2125 T738 T4572 T738 T4572 -5.8995377076576424e-07
Gcorr2126 T738 T5721 T738 T5721 -5.419340615622007e-07
Rt5350 T739 T742 559235.64087587467
Rt5351 T739 T1062 20076026.824722964
Rt5352 T739 T1063 2512391.5470918287
Rt5353 T739 T1064 6860811.5619802428
Gcorr2127 T739 T1065 T739 T1065 -1.7244154288598837e-07
Rt5354 T739 T4416 20076026.824980095
Rt5355 T739 T4417 2512391.5470928755
Rt5356 T739 T4418 6860811.5619597239
Gcorr2128 T739 T4419 T739 T4419 -1.724415428856233e-07
Rt5357 T740 T741 467420.46544022684
Gcorr2129 T740 T1211 T740 T1211 -1.2225517157685952e-07
Rt5358 T740 T1212 2122460.47738634
Rt5359 T740 T1213 17306294.215347961
Rt5360 T740 T1214 69094056.844733566
Gcorr2130 T740 T4565 T740 T4565 -1.22255171576805e-07
Rt5361 T740 T4566 2122460.4773854017
Rt5362 T740 T4567 17306294.215428356
Rt5363 T740 T4568 69094056.844720542
Rt5364 T741 T743 472935.69139488233
Gcorr2131 T741 T1209 T741 T1209 -9.4637118960241435e-08
Rt5365 T741 T1210 2742035.2529763933
Rt5366 T741 T1211 3598554.1940197549
Gcorr2132 T741 T1212 T741 T1212 -1.2615247141839078e-07
Gcorr2133 T741 T4563 T741 T4563 -9.4637118960166976e-08
Rt5367 T741 T4564 2742035.2529760557
Rt5368 T741 T4565 3598554.1940230057
Gcorr2134 T741 T4566 T741 T4566 -1.2615247141826192e-07
Gcorr2135 T742 T1059 T742 T1059 -1.471215671968827e-07
Gcorr2136 T742 T1060 T742 T1060 -4.2374613036964365e-07
Rt5369 T742 T1062 624053.03738819808
Gcorr2137 T742 T1066 T742 T1066 -4.1588511019786848e-07
Gcorr2138 T742 T2157 T742 T2157 -1.8144642349564508e-07
Gcorr2139 T742 T4413 T742 T4413 -1.4712156719750294e-07
Gcorr2140 T742 T4414 T742 T4414 -4.2374613036960178e-07
Rt5370 T742 T4416 624053.03738790052
Gcorr2141 T742 T4420 T742 T4420 -4.1588511019752046e-07
Gcorr2142 T742 T5513 T742 T5513 -1.8144642349618157e-07
Rt5371 T743 T1206 10535581.621437831
Rt5372 T743 T1208 7048328.8397679776
Rt5373 T743 T1209 2727766.3071360518
Gcorr2143 T743 T1210 T743 T1210 -1.3854219436697164e-07
Rt5374 T743 T4560 10535581.621437922
Rt5375 T743 T4562 7048328.8397680083
Rt5376 T743 T4563 2727766.3071360574
Gcorr2144 T743 T4564 T743 T4564 -1.3854219436697267e-07
Rt5377 T744 T746 411663.01593351556
Rt5378 T744 T1194 11751733.644579874
Rt5379 T744 T2313 13640224.02410977
Rt5380 T744 T2333 5315611.8623437881
Rt5381 T744 T4548 11751733.644596629
Rt5382 T744 T5667 13640224.024092264
Rt5383 T744 T5686 5315611.862343085
Gcorr2145 T745 T764 T745 T764 -5.0717742349672209e-08
Rt5384 T745 T826 401876.64110883768
Gcorr2146 T745 T1472 T745 T1472 -5.1033446212380377e-09
Rt5385 T745 T1762 1443804.4678823173
Rt5386 T745 T1884 19317698.466108482
Gcorr2147 T745 T2380 T745 T2380 -3.238846404982475e-07
Gcorr2148 T745 T4826 T745 T4826 -5.1033446208397105e-09
Rt5387 T745 T5117 1443804.4678818698
Rt5388 T745 T5241 19317698.466046534
Gcorr2149 T745 T5734 T745 T5734 -3.2388464049902905e-07
Rt5389 T746 T789 730762.27351478417
Gcorr2150 T746 T1194 T746 T1194 -1.5821587107518267e-07
Gcorr2151 T746 T1980 T746 T1980 -1.4910219040322467e-07
Rt5390 T746 T2275 1692262.246880006
Rt5391 T746 T2333 16258400.609055342
Gcorr2152 T746 T4548 T746 T4548 -1.5821587107519853e-07
Gcorr2153 T746 T5332 T746 T5332 -1.4910219040308811e-07
Rt5392 T746 T5629 1692262.2468803392
Rt5393 T746 T5686 16258400.609057043
Rt5394 T747 T840 472336.41073719657
Gcorr2154 T747 T897 T747 T897 -4.0550504214416082e-07
Rt5395 T747 T899 2822269.6438316628
Gcorr2155 T747 T2140 T747 T2140 -1.0885900894466573e-07
Rt5396 T747 T2165 1891341.9848026969
Gcorr2156 T747 T4251 T747 T4251 -4.0550504214416347e-07
Rt5397 T747 T4253 2822269.6438316614
Gcorr2157 T747 T5496 T747 T5496 -1.0885900894466649e-07
Rt5398 T747 T5521 1891341.9848026945
Rt5399 T748 T841 501449.05518669437
Rt5400 T748 T1314 3128040.2856428325
Gcorr2158 T748 T1500 T748 T1500 -6.0577255726380898e-08
Rt5401 T748 T2161 9126244.8480697908
Rt5402 T748 T4668 3128040.285633665
Gcorr2159 T748 T4854 T748 T4854 -6.0577255726603972e-08
Rt5403 T748 T5517 9126244.8481294625
Rt5404 T749 T766 847160.78221700108
Rt5405 T749 T1694 3203104.5911401697
Rt5406 T749 T2167 2691152.9722023895
Gcorr2160 T749 T2173 T749 T2173 -4.1851846433362484e-07
Rt5407 T749 T2201 13167549.819476735
Rt5408 T749 T5048 3203104.5911406949
Rt5409 T749 T5523 2691152.9722001324
Gcorr2161 T749 T5530 T749 T5530 -4.1851846433349435e-07
Rt5410 T749 T5558 13167549.819544932
Rt5411 T750 T815 3502335.3092234102
Rt5412 T750 T834 341738.95183229796
Rt5413 T750 T987 6471745.9173852494
Rt5414 T750 T1072 13741391.072903318
Rt5415 T750 T1233 10343790.500492496
Rt5416 T750 T4341 6471745.9173878795
Rt5417 T750 T4426 13741391.072928449
Rt5418 T750 T4587 10343790.500471774
Rt5419 T751 T816 962598.39763828821
Gcorr2162 T751 T1336 T751 T1336 -3.8984525402728749e-07
Gcorr2163 T751 T2086 T751 T2086 -4.902890656533339e-07
Rt5420 T751 T2087 525480.08259458188
Gcorr2164 T751 T2548 T751 T2548 -6.5634350050033538e-08
Gcorr2165 T751 T2649 T751 T2649 -5.843989862123232e-07
Gcorr2166 T751 T4690 T751 T4690 -3.8984525402792827e-07
Gcorr2167 T751 T5440 T751 T5440 -4.9028906565340421e-07
Rt5421 T751 T5441 525480.08259442274
Gcorr2168 T751 T5901 T751 T5901 -6.5634350049959793e-08
Gcorr2169 T751 T6003 T751 T6003 -5.8439898621226497e-07
Gcorr2170 T752 T754 T752 T754 -5.2566091693264924e-08
Rt5422 T752 T781 6525035.9180348907
Rt5423 T752 T1174 1142401.2281905562
Gcorr2171 T752 T2109 T752 T2109 -1.4522515284607977e-07
Gcorr2172 T752 T2574 T752 T2574 -1.5465825364110693e-08
Gcorr2173 T752 T2711 T752 T2711 -2.7264205442335164e-07
Rt5424 T752 T4528 1142401.2281909098
Gcorr2174 T752 T5460 T752 T5460 -1.4522515284601201e-07
Gcorr2175 T752 T5928 T752 T5928 -1.5465825364115874e-08
Gcorr2176 T752 T6065 T752 T6065 -2.7264205442314608e-07
Rt5425 T753 T818 3483308.8282805993
Rt5426 T753 T1417 2155537.300959229
Gcorr2177 T753 T1418 T753 T1418 -4.5982859429613033e-07
Rt5427 T753 T1419 5478918.6590793198
Rt5428 T753 T2186 5059703.4637846742
Rt5429 T753 T4771 2155537.3009583144
Gcorr2178 T753 T4772 T753 T4772 -4.5982859429590248e-07
Rt5430 T753 T4773 5478918.6591056148
Rt5431 T753 T5543 5059703.4637731817
Rt5432 T754 T1923 5318960.7927139075
Gcorr2179 T754 T2522 T754 T2522 -1.5734671230225701e-07
Rt5433 T754 T2711 3171289.4937509294
Rt5434 T754 T5279 5318960.7927069971
Gcorr2180 T754 T5876 T754 T5876 -1.5734671230238245e-07
Rt5435 T754 T6065 3171289.4937521471
Rt5436 T755 T768 325486.84692673583
Rt5437 T755 T780 726801.39517521241
Rt5438 T755 T1776 593747.37933761685
Gcorr2181 T755 T2070 T755 T2070 -1.1992230949357887e-07
Gcorr2182 T755 T2344 T755 T2344 -5.005821571342599e-07
Gcorr2183 T755 T2726 T755 T2726 -7.3238061243496428e-07
Rt5439 T755 T5130 593747.37933787133
Gcorr2184 T755 T5424 T755 T5424 -1.1992230949369907e-07
Gcorr2185 T755 T5697 T755 T5697 -5.0058215713418494e-07
Gcorr2186 T755 T6081 T755 T6081 -7.3238061243419962e-07
Rt5440 T756 T802 413190.40483189176
Rt5441 T756 T1242 166110217.7041167
Gcorr2187 T756 T1792 T756 T1792 -1.5585176478130944e-06
Rt5442 T756 T2120 487913.13611446111
Gcorr2188 T756 T2237 T756 T2237 -1.0699552971384312e-07
Rt5443 T756 T4596 166110217.69949478
Gcorr2189 T756 T5147 T756 T5147 -1.5585176478063349e-06
Rt5444 T756 T5475 487913.13611613831
Gcorr2190 T756 T5592 T756 T5592 -1.0699552971372803e-07
Rt5445 T757 T784 2164358.7934342278
Gcorr2191 T757 T1787 T757 T1787 -3.2254094358384261e-08
Gcorr2192 T757 T1801 T757 T1801 -1.0865947113075769e-07
Rt5446 T757 T2179 14397201.64751273
Rt5447 T757 T2221 2426976.0202615703
Gcorr2193 T757 T5141 T757 T5141 -3.2254094358186724e-08
Gcorr2194 T757 T5156 T757 T5156 -1.0865947113113124e-07
Rt5448 T757 T5536 14397201.647465616
Rt5449 T757 T5577 2426976.0202618861
Rt5450 T758 T791 539901.08656569326
Rt5451 T758 T1254 7756164.9483841965
Rt5452 T758 T2152 109349512.83687423
Rt5453 T758 T2354 17258677.408387933
Rt5454 T758 T2437 6009419.1230944889
Rt5455 T758 T4608 7756164.9483682569
Rt5456 T758 T5508 109349512.83512898
Rt5457 T758 T5707 17258677.408359747
Rt5458 T758 T5791 6009419.1231128331
Rt5459 T759 T1418 1892656.6419559254
Gcorr2195 T759 T1419 T759 T1419 -2.2121258798329587e-07
Rt5460 T759 T1420 2409613.9466114948
Gcorr2196 T759 T2179 T759 T2179 -4.4872858143089292e-07
Rt5461 T759 T4772 1892656.6419581182
Gcorr2197 T759 T4773 T759 T4773 -2.2121258798246305e-07
Rt5462 T759 T4774 2409613.9466097257
Gcorr2198 T759 T5536 T759 T5536 -4.4872858143142004e-07
Rt5463 T760 T811 1931906.0206918861
Rt5464 T760 T832 336288.05531043618
Gcorr2199 T760 T1140 T760 T1140 -4.4756196528161607e-08
Rt5465 T760 T1142 4395312.5453491202
Gcorr2200 T760 T1280 T760 T1280 -1.3713914271931047e-07
Rt5466 T760 T2144 3511877.1065177117
Gcorr2201 T760 T4494 T760 T4494 -4.4756196528083409e-08
Rt5467 T760 T4496 4395312.5453473581
Gcorr2202 T760 T4634 T760 T4634 -1.3713914271941966e-07
Rt5468 T760 T5501 3511877.1065184814
Rt5469 T761 T763 499229.86710654566
Rt5470 T761 T777 1343142.8150486131
Rt5471 T761 T1151 9060909.2349642124
Rt5472 T761 T1274 8274815.3078422751
Rt5473 T761 T2130 11018060.154721828
Rt5474 T761 T4505 9060909.234973602
Rt5475 T761 T4628 8274815.3078524144
Rt5476 T761 T5486 11018060.154690227
Gcorr2203 T762 T1737 T762 T1737 -9.5034582537204083e-07
Rt5477 T762 T1752 4931260.9011586029
Rt5478 T762 T2168 568560.73634689359
Gcorr2204 T762 T2260 T762 T2260 -6.9053783649735459e-07
Gcorr2205 T762 T5091 T762 T5091 -9.5034582537212638e-07
Rt5479 T762 T5106 4931260.9011667948
Rt5480 T762 T5524 568560.73634679639
Gcorr2206 T762 T5615 T762 T5615 -6.9053783649723484e-07
Gcorr2207 T763 T1153 T763 T1153 -8.3485134963734823e-08
Rt5481 T763 T2123 46511874.558649614
Rt5482 T763 T2130 2568720.2683683634
Gcorr2208 T763 T4507 T763 T4507 -8.3485134963807112e-08
Rt5483 T763 T5479 46511874.558103822
Rt5484 T763 T5486 2568720.2683695648
Rt5485 T764 T1047 4282965.8527595662
Gcorr2209 T764 T1261 T764 T1261 -1.1677522942040246e-07
Rt5486 T764 T1472 1020094.7692563346
Gcorr2210 T764 T2235 T764 T2235 -7.768892868877346e-07
Rt5487 T764 T4401 4282965.8527529249
Gcorr2211 T764 T4615 T764 T4615 -1.1677522942074905e-07
Rt5488 T764 T4826 1020094.7692565516
Gcorr2212 T764 T5590 T764 T5590 -7.7688928688754359e-07
Rt5489 T765 T796 1667994.9420979202
Rt5490 T765 T831 304789.78326058894
Rt5491 T765 T1051 6573108.6927346587
Gcorr2213 T765 T1052 T765 T1052 -5.0697182623692255e-08
Rt5492 T765 T1053 295923.1663907402
Gcorr2214 T765 T2308 T765 T2308 -3.1160578041373048e-06
Rt5493 T765 T4405 6573108.6927467678
Gcorr2215 T765 T4406 T765 T4406 -5.0697182623367689e-08
Rt5494 T765 T4407 295923.1663907147
Gcorr2216 T765 T5662 T765 T5662 -3.1160578041376428e-06
Rt5495 T766 T1178 4443819.3314327188
Gcorr2217 T766 T2109 T766 T2109 -5.8439006649547704e-07
Gcorr2218 T766 T2166 T766 T2166 -1.1738753384013965e-07
Rt5496 T766 T2201 1176322.0963076549
Rt5497 T766 T4532 4443819.3314382331
Gcorr2219 T766 T5460 T766 T5460 -5.8439006649623895e-07
Gcorr2220 T766 T5522 T766 T5522 -1.1738753384023251e-07
Rt5498 T766 T5558 1176322.0963060888
Rt5499 T767 T787 470863.95614443062
Rt5500 T767 T837 726002.97757307126
Gcorr2221 T767 T1134 T767 T1134 -1.9294364257988538e-07
Rt5501 T767 T1135 9283782.472170176
Rt5502 T767 T1136 1492640.2816434077
Rt5503 T767 T1137 4076119.2595215249
Gcorr2222 T767 T1138 T767 T1138 -4.3457615117847384e-07
Gcorr2223 T767 T4488 T767 T4488 -1.929436425801202e-07
Rt5504 T767 T4489 9283782.4721901994
Rt5505 T767 T4490 1492640.2816428926
Rt5506 T767 T4491 4076119.2595141665
Gcorr2224 T767 T4492 T767 T4492 -4.3457615117868364e-07
Rt5507 T768 T776 1263801.2828956321
Gcorr2225 T768 T1528 T768 T1528 -5.7242942478081448e-07
Gcorr2226 T768 T1776 T768 T1776 -4.3362662160378586e-07
Gcorr2227 T768 T2070 T768 T2070 -8.0441186816537669e-08
Rt5508 T768 T2344 970902.06493520283
Rt5509 T768 T2470 2658650.9853903651
Gcorr2228 T768 T4882 T768 T4882 -5.7242942477936637e-07
Gcorr2229 T768 T5130 T768 T5130 -4.3362662160346436e-07
Gcorr2230 T768 T5424 T768 T5424 -8.0441186816241154e-08
Rt5510 T768 T5697 970902.06493636989
Rt5511 T768 T5824 2658650.9853962325
Rt5512 T769 T1036 32548590.276582308
Gcorr2231 T769 T1803 T769 T1803 -1.7782848123865592e-07
Rt5513 T769 T2296 9063793.2010459993
Rt5514 T769 T2355 2682514.4494389393
Rt5515 T769 T4390 32548590.276172914
Gcorr2232 T769 T5158 T769 T5158 -1.7782848123895741e-07
Rt5516 T769 T5650 9063793.2010388896
Rt5517 T769 T5708 2682514.4494401892
Rt5518 T770 T843 1860543.9328000892
Gcorr2233 T770 T1393 T770 T1393 -1.762075486074292e-07
Rt5519 T770 T2127 11602057.91317963
Rt5520 T770 T2137 1830794.8256751378
Gcorr2234 T770 T2161 T770 T2161 -6.2181855242971451e-08
Gcorr2235 T770 T4747 T770 T4747 -1.7620754860765465e-07
Rt5521 T770 T5483 11602057.913273083
Rt5522 T770 T5493 1830794.8256740938
Gcorr2236 T770 T5517 T770 T5517 -6.2181855242365836e-08
Rt5523 T771 T842 1302394.4557104115
Rt5524 T771 T896 3614321.6707945452
Rt5525 T771 T897 10537866.548568653
Rt5526 T771 T898 6747779.9953453727
Gcorr2237 T771 T1068 T771 T1068 -1.2575679370706689e-07
Rt5527 T771 T4250 3614321.670794555
Rt5528 T771 T4251 10537866.54856867
Rt5529 T771 T4252 6747779.9953454146
Gcorr2238 T771 T4422 T771 T4422 -1.2575679370706768e-07
Rt5530 T772 T805 835052.32473394158
Gcorr2239 T772 T1750 T772 T1750 -2.2804004360868973e-07
Gcorr2240 T772 T1946 T772 T1946 -2.180584792068212e-07
Rt5531 T772 T2036 2895782.98966265
Rt5532 T772 T2723 2340101.4901401834
Gcorr2241 T772 T5104 T772 T5104 -2.280400436087932e-07
Gcorr2242 T772 T5302 T772 T5302 -2.1805847920674618e-07
Rt5533 T772 T5389 2895782.9896647232
Rt5534 T772 T6078 2340101.4901386849
Rt5535 T773 T785 794660.19472809008
Rt5536 T773 T1789 35833735.468024343
Rt5537 T773 T2085 19440631.873615082
Gcorr2243 T773 T2159 T773 T2159 -1.8373751199860417e-07
Rt5538 T773 T2691 2259328.4372799839
Rt5539 T773 T5144 35833735.468638152
Rt5540 T773 T5439 19440631.873547357
Gcorr2244 T773 T5515 T773 T5515 -1.8373751199837452e-07
Rt5541 T773 T6045 2259328.4372796426
Rt5542 T774 T812 484138.48812254128
Rt5543 T774 T1169 3477345.8988848724
Rt5544 T774 T1171 25739622.745413147
Rt5545 T774 T1239 3621646.4595032902
Gcorr2245 T774 T2330 T774 T2330 -1.4792829920310317e-07
Gcorr2246 T774 T2711 T774 T2711 -8.273794346552694e-08
Rt5546 T774 T4523 3477345.8988871933
Rt5547 T774 T4525 25739622.745451372
Rt5548 T774 T4593 3621646.4594998807
Gcorr2247 T774 T5683 T774 T5683 -1.4792829920318182e-07
Gcorr2248 T774 T6065 T774 T6065 -8.2737943465461215e-08
Gcorr2249 T775 T1133 T775 T1133 -7.2555675044343859e-08
Rt5549 T775 T1139 2839313.9806239009
Gcorr2250 T775 T2149 T775 T2149 -1.3980323431474156e-07
Rt5550 T775 T2178 8508997.8652691562
Gcorr2251 T775 T4487 T775 T4487 -7.2555675044369985e-08
Rt5551 T775 T4493 2839313.980625377
Gcorr2252 T775 T5505 T775 T5505 -1.3980323431470342e-07
Rt5552 T775 T5535 8508997.8652569018
Rt5553 T776 T838 5835653.4554558024
Rt5554 T776 T1528 4615066.7849107059
Gcorr2253 T776 T2151 T776 T2151 -1.830539011961542e-07
Rt5555 T776 T2206 2406978.3051575474
Rt5556 T776 T2344 308286779.45193166
Rt5557 T776 T4882 4615066.7849107739
Gcorr2254 T776 T5507 T776 T5507 -1.8305390119615174e-07
Rt5558 T776 T5562 2406978.3051582226
Rt5559 T776 T5697 308286779.44107288
Rt5560 T777 T783 424743.5780343237
Rt5561 T777 T835 3323895.5771630174
Gcorr2255 T777 T1148 T777 T1148 -5.0009350244335973e-07
Rt5562 T777 T1149 3936059.6562241302
Rt5563 T777 T1150 2092557.6459253295
Rt5564 T777 T1151 4472292.9153039474
Gcorr2256 T777 T4502 T777 T4502 -5.0009350244342315e-07
Rt5565 T777 T4503 3936059.6562233064
Rt5566 T777 T4504 2092557.64592589
Rt5567 T777 T4505 4472292.9153012438
Rt5568 T778 T825 5924525.9116218798
Rt5569 T778 T1228 5583395.67259394
Rt5570 T778 T2080 192141454.38911185
Rt5571 T778 T2443 5753851.6447996572
Rt5572 T778 T4582 5583395.6725918623
Rt5573 T778 T5434 192141454.38142008
Rt5574 T778 T5797 5753851.6448088409
Rt5575 T779 T782 2000960.4311015601
Rt5576 T779 T1157 1113965.5059320682
Gcorr2257 T779 T1173 T779 T1173 -3.8223541596391805e-07
Gcorr2258 T779 T1436 T779 T1436 -4.0962629736691082e-08
Gcorr2259 T779 T2118 T779 T2118 -1.122332171171564e-07
Rt5577 T779 T4511 1113965.5059321856
Gcorr2260 T779 T4527 T779 T4527 -3.8223541596410561e-07
Gcorr2261 T779 T4790 T779 T4790 -4.0962629736619078e-08
Gcorr2262 T779 T5471 T779 T5471 -1.1223321711694884e-07
Gcorr2263 T780 T1774 T780 T1774 -1.4715683844150583e-07
Gcorr2264 T780 T1776 T780 T1776 -1.7689151014769374e-07
Gcorr2265 T780 T1959 T780 T1959 -1.5337765294360994e-07
Rt5578 T780 T2459 1179093.9573061152
Rt5579 T780 T2726 41107282.550381102
Gcorr2266 T780 T5128 T780 T5128 -1.471568384413062e-07
Gcorr2267 T780 T5130 T780 T5130 -1.7689151014777722e-07
Gcorr2268 T780 T5313 T780 T5313 -1.5337765294344289e-07
Rt5580 T780 T5813 1179093.9573062446
Rt5581 T780 T6081 41107282.550706536
Rt5582 T781 T1831 18254407.301120777
Gcorr2269 T781 T2109 T781 T2109 -3.517939292448775e-07
Rt5583 T781 T2400 2766593.0296196756
Rt5584 T781 T2574 3650813.0577649255
Rt5585 T781 T5186 18254407.301078733
Gcorr2270 T781 T5460 T781 T5460 -3.5179392924489651e-07
Rt5586 T781 T5755 2766593.0296197338
Rt5587 T781 T5928 3650813.0577662829
Rt5588 T782 T1436 2872487.1704961271
Gcorr2271 T782 T1438 T782 T1438 -9.3661426795782336e-08
Rt5589 T782 T1792 10447480.852634052
Rt5590 T782 T4790 2872487.1704977136
Gcorr2272 T782 T4792 T782 T4792 -9.3661426795723414e-08
Rt5591 T782 T5147 10447480.852619743
Rt5592 T783 T835 495980.7104206151
Gcorr2273 T783 T1138 T783 T1138 -3.043559959055744e-07
Rt5593 T783 T1147 88038185.377462491
Rt5594 T783 T1148 751132.72949683014
Gcorr2274 T783 T1149 T783 T1149 -1.097669793482662e-07
Gcorr2275 T783 T1150 T783 T1150 -5.3961176636018943e-07
Gcorr2276 T783 T4492 T783 T4492 -3.0435599590562855e-07
Rt5595 T783 T4501 88038185.376078188
Rt5596 T783 T4502 751132.72949702246
Gcorr2277 T783 T4503 T783 T4503 -1.0976697934797504e-07
Gcorr2278 T783 T4504 T783 T4504 -5.396117663602663e-07
Gcorr2279 T784 T1416 T784 T1416 -4.2075311539901491e-07
Gcorr2280 T784 T1418 T784 T1418 -3.6910577793467935e-07
Rt5597 T784 T1787 861645.56015648413
Gcorr2281 T784 T4770 T784 T4770 -4.2075311539885704e-07
Gcorr2282 T784 T4772 T784 T4772 -3.6910577793461682e-07
Rt5598 T784 T5141 861645.56015664956
Gcorr2283 T785 T1723 T785 T1723 -1.5497067695822525e-07
Rt5599 T785 T2159 984348.35610991623
Rt5600 T785 T2210 12005007.037916772
Gcorr2284 T785 T2588 T785 T2588 -9.3448648451232317e-08
Gcorr2285 T785 T2691 T785 T2691 -4.6838434131500582e-07
Gcorr2286 T785 T5077 T785 T5077 -1.5497067695852224e-07
Rt5601 T785 T5515 984348.35610979865
Rt5602 T785 T5566 12005007.037892658
Gcorr2287 T785 T5942 T785 T5942 -9.3448648450977982e-08
Gcorr2288 T785 T6045 T785 T6045 -4.6838434131525474e-07
Rt5603 T786 T1806 2536530.2060340941
Gcorr2289 T786 T2079 T786 T2079 -2.0115250202187099e-07
Rt5604 T786 T2080 9677374.7801201139
Gcorr2290 T786 T2548 T786 T2548 -1.6128553786835763e-08
Rt5605 T786 T5161 2536530.206033072
Gcorr2291 T786 T5433 T786 T5433 -2.0115250202180199e-07
Rt5606 T786 T5434 9677374.7801305838
Gcorr2292 T786 T5901 T786 T5901 -1.6128553786953573e-08
Rt5607 T787 T837 1348083.756869206
Rt5608 T787 T1133 7108335.4156285161
Rt5609 T787 T1134 10244538.462960973
Rt5610 T787 T1135 7144494.1900193598
Rt5611 T787 T4487 7108335.4156376068
Rt5612 T787 T4488 10244538.462974112
Rt5613 T787 T4489 7144494.1900039166
Gcorr2293 T788 T994 T788 T994 -7.7405209742252392e-08
Rt5614 T788 T1114 17270747.840599455
Gcorr2294 T788 T1351 T788 T1351 -2.2673803942222952e-07
Rt5615 T788 T2150 1775429.383774349
Gcorr2295 T788 T4348 T788 T4348 -7.7405209742461741e-08
Rt5616 T788 T4468 17270747.840681378
Gcorr2296 T788 T4705 T788 T4705 -2.267380394221633e-07
Rt5617 T788 T5506 1775429.3837730386
Rt5618 T789 T1195 2612518.6565787643
Gcorr2297 T789 T1199 T789 T1199 -1.4138066737263859e-07
Rt5619 T789 T2275 15057394.801317055
Rt5620 T789 T4549 2612518.6565798093
Gcorr2298 T789 T4553 T789 T4553 -1.41380667372564e-07
Rt5621 T789 T5629 15057394.801299708
Gcorr2299 T790 T2062 T790 T2062 -4.2416633464537019e-07
Gcorr2300 T790 T2150 T790 T2150 -3.2504956067914398e-07
Gcorr2301 T790 T2193 T790 T2193 -2.0252473096378828e-07
Gcorr2302 T790 T2194 T790 T2194 -1.3190384750662704e-07
Rt5622 T790 T2245 722569.4633196987
Gcorr2303 T790 T5416 T790 T5416 -4.241663346453723e-07
Gcorr2304 T790 T5506 T790 T5506 -3.2504956067938454e-07
Gcorr2305 T790 T5550 T790 T5550 -2.0252473096355802e-07
Gcorr2306 T790 T5551 T790 T5551 -1.3190384750675031e-07
Rt5623 T790 T5600 722569.46331962908
Rt5624 T791 T798 1280646.3288552784
Gcorr2307 T791 T1753 T791 T1753 -1.532119871169327e-07
Gcorr2308 T791 T2152 T791 T2152 -1.2106471514253574e-07
Rt5625 T791 T2437 13436113.234534249
Rt5626 T791 T2499 1735791.143016235
Gcorr2309 T791 T5107 T791 T5107 -1.5321198711761462e-07
Gcorr2310 T791 T5508 T791 T5508 -1.210647151423436e-07
Rt5627 T791 T5791 13436113.23451023
Rt5628 T791 T5853 1735791.1430151679
Rt5629 T792 T815 4068948.8899783259
Rt5630 T792 T838 372159.09064769896
Rt5631 T792 T990 2983600.2032659524
Rt5632 T792 T1300 9971768.8778448943
Gcorr2311 T792 T2151 T792 T2151 -1.2528397139613065e-07
Rt5633 T792 T4344 2983600.2032661294
Rt5634 T792 T4654 9971768.8778585512
Gcorr2312 T792 T5507 T792 T5507 -1.2528397139597549e-07
Rt5635 T793 T801 588008.68821728206
Rt5636 T793 T831 536043.49440198531
Rt5637 T793 T1052 2678360.8616180103
Gcorr2313 T793 T2141 T793 T2141 -1.3147714853271052e-07
Rt5638 T793 T2171 17981113.154277202
Rt5639 T793 T4406 2678360.8616205566
Gcorr2314 T793 T5497 T793 T5497 -1.3147714853241517e-07
Rt5640 T793 T5528 17981113.154258523
Rt5641 T794 T982 8205739.270409774
Rt5642 T794 T985 11199951.320493972
Rt5643 T794 T994 4243112.6314225858
Gcorr2315 T794 T2193 T794 T2193 -1.4784447183445864e-07
Rt5644 T794 T4336 8205739.2704117103
Rt5645 T794 T4339 11199951.320516773
Rt5646 T794 T4348 4243112.6314202258
Gcorr2316 T794 T5550 T794 T5550 -1.4784447183438118e-07
Rt5647 T795 T989 2211174.0784156527
Gcorr2317 T795 T996 T795 T996 -8.7590528995818137e-08
Rt5648 T795 T997 9269719.2270486783
Gcorr2318 T795 T2249 T795 T2249 -1.6274259877530031e-07
Rt5649 T795 T4343 2211174.0784175475
Gcorr2319 T795 T4350 T795 T4350 -8.7590528995824874e-08
Rt5650 T795 T4351 9269719.2270317134
Gcorr2320 T795 T5604 T795 T5604 -1.6274259877510544e-07
Rt5651 T796 T1048 33402752.120281313
Rt5652 T796 T1051 2744384.1054425729
Gcorr2321 T796 T2235 T796 T2235 -7.1743405920319928e-08
Rt5653 T796 T4402 33402752.120466799
Rt5654 T796 T4405 2744384.1054377151
Gcorr2322 T796 T5590 T796 T5590 -7.1743405920800712e-08
Rt5655 T797 T1137 8019155.1288003856
Gcorr2323 T797 T1138 T797 T1138 -3.1294914958761062e-08
Rt5656 T797 T1146 6407357.7257603006
Rt5657 T797 T4491 8019155.12881424
Gcorr2324 T797 T4492 T797 T4492 -3.1294914958717241e-08
Rt5658 T797 T4500 6407357.7257533232
Gcorr2325 T798 T1075 T798 T1075 -4.697295413658917e-07
Rt5659 T798 T2187 748481.6523687708
Gcorr2326 T798 T2499 T798 T2499 -1.4933095980984956e-07
Gcorr2327 T798 T2588 T798 T2588 -3.5231045139168429e-07
Gcorr2328 T798 T4429 T798 T4429 -4.6972954136580117e-07
Rt5660 T798 T5544 748481.65236872109
Gcorr2329 T798 T5853 T798 T5853 -1.4933095980984607e-07
Gcorr2330 T798 T5942 T798 T5942 -3.5231045139186974e-07
Gcorr2331 T799 T803 T799 T803 -7.3645622691649175e-08
Gcorr2332 T799 T985 T799 T985 -6.1799235936794706e-07
Rt5661 T799 T995 908761.39780909603
Gcorr2333 T799 T1116 T799 T1116 -4.8467568174594981e-07
Rt5662 T799 T2182 2602602.9546736157
Gcorr2334 T799 T4339 T799 T4339 -6.1799235936780698e-07
Rt5663 T799 T4349 908761.39780923969
Gcorr2335 T799 T4470 T799 T4470 -4.8467568174565536e-07
Rt5664 T799 T5539 2602602.9546753964
Rt5665 T800 T1693 6196570.7189998263
Gcorr2336 T800 T1700 T800 T1700 -5.302200257128601e-07
Rt5666 T800 T1865 1399553.9947886751
Gcorr2337 T800 T2034 T800 T2034 -1.180944734096551e-07
Rt5667 T800 T5047 6196570.7189888116
Gcorr2338 T800 T5054 T800 T5054 -5.30220025713856e-07
Rt5668 T800 T5220 1399553.9947866949
Gcorr2339 T800 T5387 T800 T5387 -1.180944734099587e-07
Rt5669 T801 T836 565485.2341882356
Rt5670 T801 T2141 6610705.8518501893
Rt5671 T801 T2171 40892777.566105604
Rt5672 T801 T2229 10565769.308491219
Rt5673 T801 T5497 6610705.8518548952
Rt5674 T801 T5528 40892777.566743359
Rt5675 T801 T5584 10565769.308436828
Rt5676 T802 T817 432158.55729273165
Gcorr2340 T802 T1242 T802 T1242 -1.0804810150952355e-07
Rt5677 T802 T2237 2162061.0505181011
Gcorr2341 T802 T4596 T802 T4596 -1.0804810150960838e-07
Rt5678 T802 T5592 2162061.0505177155
Gcorr2342 T803 T985 T803 T985 -5.3249654992328948e-07
Rt5679 T803 T1461 1690691.8590687807
Rt5680 T803 T2182 4525153.1102967951
Rt5681 T803 T2214 10778474.559449926
Gcorr2343 T803 T4339 T803 T4339 -5.3249654992325645e-07
Rt5682 T803 T4815 1690691.859068505
Rt5683 T803 T5539 4525153.1102936324
Rt5684 T803 T5570 10778474.559483213
Gcorr2344 T804 T993 T804 T993 -9.0698412176323757e-09
Rt5685 T804 T996 7696783.6593387108
Rt5686 T804 T1113 5104981.6973043429
Gcorr2345 T804 T4347 T804 T4347 -9.0698412176525721e-09
Rt5687 T804 T4350 7696783.6593276421
Rt5688 T804 T4467 5104981.6973087415
Gcorr2346 T805 T1725 T805 T1725 -1.1309397808171556e-07
Rt5689 T805 T1750 1834363.3479893361
Rt5690 T805 T1789 8881118.0993806459
Gcorr2347 T805 T2723 T805 T2723 -1.9047576550589468e-07
Gcorr2348 T805 T5079 T805 T5079 -1.1309397808157005e-07
Rt5691 T805 T5104 1834363.3479911559
Rt5692 T805 T5144 8881118.0993392356
Gcorr2349 T805 T6078 T805 T6078 -1.9047576550602689e-07
Rt5693 T806 T1545 9135269.4517534841
Gcorr2350 T806 T1812 T806 T1812 -1.6545687478551947e-07
Rt5694 T806 T2631 2831781.2958781444
Rt5695 T806 T4899 9135269.4517656472
Gcorr2351 T806 T5167 T806 T5167 -1.6545687478539101e-07
Rt5696 T806 T5985 2831781.295878022
Rt5697 T807 T819 550734.04800290836
Rt5698 T807 T827 1278832.7025378412
Gcorr2352 T807 T1200 T807 T1200 -1.0649555365245444e-07
Rt5699 T807 T1203 2990763.5417025681
Gcorr2353 T807 T1444 T807 T1444 -1.1361100216774687e-07
Rt5700 T807 T2185 3698233.3673302517
Gcorr2354 T807 T4554 T807 T4554 -1.064955536521683e-07
Rt5701 T807 T4557 2990763.5417045788
Gcorr2355 T807 T4798 T807 T4798 -1.1361100216754434e-07
Rt5702 T807 T5542 3698233.3673338969
Rt5703 T808 T821 366109.67223599058
Gcorr2356 T808 T1466 T808 T1466 -1.0170818961449806e-07
Rt5704 T808 T2101 11137998.523166679
Rt5705 T808 T2349 1604699.5498986708
Gcorr2357 T808 T2434 T808 T2434 -2.4000403505261155e-07
Gcorr2358 T808 T4820 T808 T4820 -1.0170818961476579e-07
Rt5706 T808 T5454 11137998.523150418
Rt5707 T808 T5702 1604699.549899149
Gcorr2359 T808 T5788 T808 T5788 -2.4000403505229179e-07
Gcorr2360 T809 T1815 T809 T1815 -8.829428657280267e-08
Gcorr2361 T809 T2034 T809 T2034 -4.0975720641614606e-08
Rt5708 T809 T2495 2301027.1153322849
Gcorr2362 T809 T5170 T809 T5170 -8.8294286572986172e-08
Gcorr2363 T809 T5387 T809 T5387 -4.09757206413617e-08
Rt5709 T809 T5849 2301027.1153326631
Rt5710 T810 T993 8014258.8582112389
Rt5711 T810 T1281 1742986.1237311664
Gcorr2364 T810 T2061 T810 T2061 -5.0028571553553569e-07
Rt5712 T810 T2236 8814942.5732151959
Rt5713 T810 T4347 8014258.8582075024
Rt5714 T810 T4635 1742986.1237272657
Gcorr2365 T810 T5415 T810 T5415 -5.0028571553678538e-07
Rt5715 T810 T5591 8814942.5732225608
Rt5716 T811 T2144 12602640.465134893
Gcorr2366 T811 T2336 T811 T2336 -1.7451060505466932e-07
Gcorr2367 T811 T2337 T811 T2337 -3.614699554546135e-07
Rt5717 T811 T2644 1331958.5190254848
Rt5718 T811 T5501 12602640.465119176
Gcorr2368 T811 T5689 T811 T5689 -1.745106050548396e-07
Gcorr2369 T811 T5690 T811 T5690 -3.6146995545468841e-07
Rt5719 T811 T5998 1331958.5190252292
Rt5720 T812 T820 34992817.829570577
Rt5721 T812 T1167 3894656.7716496824
Gcorr2370 T812 T1169 T812 T1169 -1.0542193562114978e-07
Gcorr2371 T812 T2320 T812 T2320 -5.2266290944424825e-07
Rt5722 T812 T2330 1358904.4656854856
Rt5723 T812 T4521 3894656.7716528149
Gcorr2372 T812 T4523 T812 T4523 -1.0542193562113599e-07
Gcorr2373 T812 T5674 T812 T5674 -5.2266290944412533e-07
Rt5724 T812 T5683 1358904.4656853615
Gcorr2374 T813 T1355 T813 T1355 -5.6629180595050946e-07
Rt5725 T813 T1692 2713374.3598676873
Rt5726 T813 T2197 1799818.6153187903
Gcorr2375 T813 T2214 T813 T2214 -5.8742169502975478e-08
Gcorr2376 T813 T4709 T813 T4709 -5.6629180595000897e-07
Rt5727 T813 T5046 2713374.359869896
Rt5728 T813 T5554 1799818.6153200399
Gcorr2377 T813 T5570 T813 T5570 -5.8742169502792009e-08
Gcorr2378 T814 T997 T814 T997 -3.4803724529741072e-10
Rt5729 T814 T1077 7053466.4738228386
Rt5730 T814 T1078 6262702.7547005815
Gcorr2379 T814 T4351 T814 T4351 -3.4803724538042657e-10
Rt5731 T814 T4431 7053466.4738274179
Rt5732 T814 T4432 6262702.7546937969
Gcorr2380 T815 T976 T815 T976 -2.0212358849109891e-07
Rt5733 T815 T986 1989592.2306286213
Rt5734 T815 T987 5792836.2049590796
Gcorr2381 T815 T990 T815 T990 -8.6054387081409156e-09
Gcorr2382 T815 T4330 T815 T4330 -2.0212358849097434e-07
Rt5735 T815 T4340 1989592.2306293144
Rt5736 T815 T4341 5792836.2049554251
Gcorr2383 T815 T4344 T815 T4344 -8.6054387082023453e-09
Gcorr2384 T816 T1619 T816 T1619 -5.9249600502347547e-07
Rt5737 T816 T1628 2917769.1855866052
Gcorr2385 T816 T2087 T816 T2087 -5.4951740919509925e-07
Rt5738 T816 T2649 880823.08482905279
Gcorr2386 T816 T4973 T816 T4973 -5.9249600502345885e-07
Rt5739 T816 T4982 2917769.1855860357
Gcorr2387 T816 T5441 T816 T5441 -5.4951740919516808e-07
Rt5740 T816 T6003 880823.08482906572
Rt5741 T817 T820 612558.09629183786
Gcorr2388 T817 T1242 T817 T1242 -5.5747774479935389e-07
Rt5742 T817 T2217 570055.80734453571
Gcorr2389 T817 T2237 T817 T2237 -1.182887426748048e-07
Gcorr2390 T817 T2320 T817 T2320 -7.3061633221323038e-07
Gcorr2391 T817 T4596 T817 T4596 -5.57477744798702e-07
Rt5743 T817 T5573 570055.80734428857
Gcorr2392 T817 T5592 T817 T5592 -1.1828874267483417e-07
Gcorr2393 T817 T5674 T817 T5674 -7.3061633221461612e-07
Gcorr2394 T818 T1419 T818 T1419 -1.3071925440613429e-07
Rt5744 T818 T1423 2039013.6213378527
Rt5745 T818 T2186 2339772.6500497102
Gcorr2395 T818 T2212 T818 T2212 -4.5426374098547467e-07
Gcorr2396 T818 T4773 T818 T4773 -1.3071925440622397e-07
Rt5746 T818 T4777 2039013.6213377342
Rt5747 T818 T5543 2339772.6500504087
Gcorr2397 T818 T5568 T818 T5568 -4.5426374098528827e-07
Rt5748 T819 T1199 3855725.8069819552
Gcorr2398 T819 T1200 T819 T1200 -5.4393591877598377e-07
Rt5749 T819 T2185 1275071.4533046063
Gcorr2399 T819 T2203 T819 T2203 -1.4712761079020168e-07
Rt5750 T819 T4553 3855725.8069874505
Gcorr2400 T819 T4554 T819 T4554 -5.4393591877732018e-07
Rt5751 T819 T5542 1275071.4533017343
Gcorr2401 T819 T5560 T819 T5560 -1.4712761079026425e-07
Rt5752 T820 T2011 2285457.1719438056
Rt5753 T820 T2217 9469746.0456398819
Gcorr2402 T820 T2320 T820 T2320 -1.2247966485607626e-07
Gcorr2403 T820 T2330 T820 T2330 -5.5426846885157537e-08
Rt5754 T820 T5363 2285457.1719422336
Rt5755 T820 T5573 9469746.0456596725
Gcorr2404 T820 T5674 T820 T5674 -1.2247966485615403e-07
Gcorr2405 T820 T5683 T820 T5683 -5.5426846885162381e-08
Gcorr2406 T821 T2061 T821 T2061 -1.156650816205839e-07
Gcorr2407 T821 T2236 T821 T2236 -3.7455699941809346e-07
Gcorr2408 T821 T2349 T821 T2349 -1.9459898964387773e-07
Rt5756 T821 T2434 1020110.8787928857
Gcorr2409 T821 T5415 T821 T5415 -1.1566508162051977e-07
Gcorr2410 T821 T5591 T821 T5591 -3.7455699941714907e-07
Gcorr2411 T821 T5702 T821 T5702 -1.9459898964360811e-07
Rt5757 T821 T5788 1020110.8787942179
Gcorr2412 T822 T1472 T822 T1472 -5.2358154032561186e-07
Rt5758 T822 T1885 1439544.8048223336
Rt5759 T822 T2235 2182385.0123347165
Rt5760 T822 T2308 22785589.977858443
Gcorr2413 T822 T2689 T822 T2689 -3.9568049522717932e-07
Gcorr2414 T822 T4826 T822 T4826 -5.2358154032573913e-07
Rt5761 T822 T5242 1439544.8048241741
Rt5762 T822 T5590 2182385.0123340338
Rt5763 T822 T5662 22785589.977655597
Gcorr2415 T822 T6043 T822 T6043 -3.9568049522669964e-07
Rt5764 T823 T844 816280.65089552989
Rt5765 T823 T1683 8746582.0788141247
Rt5766 T823 T1815 8615744.5287877824
Rt5767 T823 T2091 1741571.0116237949
Gcorr2416 T823 T2274 T823 T2274 -5.0756621652084582e-07
Rt5768 T823 T5037 8746582.0788139813
Rt5769 T823 T5170 8615744.528775651
Rt5770 T823 T5444 1741571.0116241788
Gcorr2417 T823 T5628 T823 T5628 -5.0756621652088648e-07
Gcorr2418 T824 T1280 T824 T1280 -1.4509947532728696e-07
Gcorr2419 T824 T1812 T824 T1812 -6.1386734533022673e-08
Rt5771 T824 T2336 7072874.7778258324
Rt5772 T824 T2508 2602624.8135014698
Gcorr2420 T824 T4634 T824 T4634 -1.4509947532720845e-07
Gcorr2421 T824 T5167 T824 T5167 -6.1386734533169687e-08
Rt5773 T824 T5689 7072874.7778168172
Rt5774 T824 T5862 2602624.8135022405
Rt5775 T825 T1228 2702214.6853175056
Gcorr2422 T825 T1982 T825 T1982 -4.273135450223834e-07
Gcorr2423 T825 T2313 T825 T2313 -5.463296555676068e-07
Rt5776 T825 T2371 1067647.1672523217
Rt5777 T825 T4582 2702214.6853180779
Gcorr2424 T825 T5334 T825 T5334 -4.273135450222987e-07
Gcorr2425 T825 T5667 T825 T5667 -5.463296555677149e-07
Rt5778 T825 T5725 1067647.1672522081
Rt5779 T826 T1762 3110838.024883064
Gcorr2426 T826 T1974 T826 T1974 -4.5067118696502693e-07
Rt5780 T826 T1998 2060756.9474797931
Gcorr2427 T826 T2380 T826 T2380 -8.9219189316345654e-08
Rt5781 T826 T5117 3110838.024880189
Gcorr2428 T826 T5328 T826 T5328 -4.5067118696461013e-07
Rt5782 T826 T5350 2060756.9474842728
Gcorr2429 T826 T5734 T826 T5734 -8.9219189316006324e-08
Rt5783 T827 T839 2682117.6366286837
Gcorr2430 T827 T1200 T827 T1200 -3.120525952803666e-08
Rt5784 T827 T1202 1055216.6956369511
Gcorr2431 T827 T1203 T827 T1203 -2.0150371636490733e-07
Gcorr2432 T827 T1204 T827 T1204 -8.8936678514790753e-08
Gcorr2433 T827 T1205 T827 T1205 -1.4367260938986373e-07
Gcorr2434 T827 T4554 T827 T4554 -3.1205259527952169e-08
Rt5785 T827 T4556 1055216.6956373188
Gcorr2435 T827 T4557 T827 T4557 -2.0150371636490651e-07
Gcorr2436 T827 T4558 T827 T4558 -8.8936678514560519e-08
Gcorr2437 T827 T4559 T827 T4559 -1.4367260938985237e-07
Gcorr2438 T828 T1155 T828 T1155 -4.3787841233937175e-07
Rt5786 T828 T1173 2104736.3334533847
Gcorr2439 T828 T2108 T828 T2108 -9.6058732545818748e-08
Rt5787 T828 T2123 3059024.2257837867
Gcorr2440 T828 T4509 T828 T4509 -4.3787841233928467e-07
Rt5788 T828 T4527 2104736.3334530499
Gcorr2441 T828 T5459 T828 T5459 -9.6058732545667102e-08
Rt5789 T828 T5479 3059024.2257867442
Rt5790 T829 T1745 3531003.6855466347
Gcorr2442 T829 T2426 T829 T2426 -1.465556374318195e-07
Rt5791 T829 T2579 5088611.8562624725
Rt5792 T829 T5099 3531003.6855514562
Gcorr2443 T829 T5779 T829 T5779 -1.465556374317912e-07
Rt5793 T829 T5933 5088611.8562532496
Gcorr2444 T830 T2029 T830 T2029 -1.0030975115629711e-07
Rt5794 T830 T2246 7087297.7743509365
Rt5795 T830 T2274 6246490.0992152682
Gcorr2445 T830 T5382 T830 T5382 -1.0030975115628171e-07
Rt5796 T830 T5601 7087297.7743599219
Rt5797 T830 T5628 6246490.0992089417
Rt5798 T831 T1052 1939480.8255631847
Gcorr2446 T831 T1053 T831 T1053 -8.75280738902624e-08
Rt5799 T831 T1054 2474191.5761706019
Gcorr2447 T831 T2141 T831 T2141 -4.8541344281821921e-07
Rt5800 T831 T4406 1939480.8255666234
Gcorr2448 T831 T4407 T831 T4407 -8.7528073890608929e-08
Rt5801 T831 T4408 2474191.5761673464
Gcorr2449 T831 T5497 T831 T5497 -4.8541344281749267e-07
Rt5802 T832 T1140 3599356.9401558167
Rt5803 T832 T1141 7697413.5127410619
Gcorr2450 T832 T1142 T832 T1142 -8.263722414518864e-08
Rt5804 T832 T4494 3599356.9401566773
Rt5805 T832 T4495 7697413.5127332322
Gcorr2451 T832 T4496 T832 T4496 -8.2637224145256535e-08
Rt5806 T833 T1742 7893519.1741474448
Rt5807 T833 T1752 22406337.455271542
Rt5808 T833 T1774 5294663.910408996
Gcorr2452 T833 T1775 T833 T1775 -1.246723217836389e-07
Rt5809 T833 T5096 7893519.1741511375
Rt5810 T833 T5106 22406337.455080323
Rt5811 T833 T5128 5294663.9104141667
Gcorr2453 T833 T5129 T833 T5129 -1.2467232178377755e-07
Rt5812 T834 T1233 333885.73307365063
Gcorr2454 T834 T1517 T834 T1517 -2.4814143651901699e-06
Gcorr2455 T834 T2158 T834 T2158 -2.8198507710978297e-07
Rt5813 T834 T4587 333885.73307300842
Gcorr2456 T834 T4871 T834 T4871 -2.481414365195978e-06
Gcorr2457 T834 T5514 T834 T5514 -2.819850771097367e-07
Rt5814 T835 T1147 5166511.0385634257
Rt5815 T835 T1149 8376958.7561442899
Gcorr2458 T835 T2372 T835 T2372 -8.3182697351263793e-08
Rt5816 T835 T2720 10414485.376841666
Rt5817 T835 T4501 5166511.0385673391
Rt5818 T835 T4503 8376958.7561394162
Gcorr2459 T835 T5726 T835 T5726 -8.3182697351274023e-08
Rt5819 T835 T6075 10414485.376832427
Gcorr2460 T836 T1057 T836 T1057 -1.1612532912882928e-07
Rt5820 T836 T1453 2027575.3197805514
Rt5821 T836 T2141 14595783.679712601
Gcorr2461 T836 T2229 T836 T2229 -1.9190637443136059e-07
Gcorr2462 T836 T4411 T836 T4411 -1.1612532912889679e-07
Rt5822 T836 T4807 2027575.3197787118
Rt5823 T836 T5497 14595783.67983119
Gcorr2463 T836 T5584 T836 T5584 -1.9190637443118551e-07
Rt5824 T837 T1135 9623370.3917301018
Gcorr2464 T837 T1137 T837 T1137 -1.7125288463449566e-07
Rt5825 T837 T2145 2637896.4859351241
Rt5826 T837 T4489 9623370.3917589933
Gcorr2465 T837 T4491 T837 T4491 -1.7125288463410788e-07
Rt5827 T837 T5500 2637896.4859356675
Rt5828 T838 T1300 2566316.8796557197
Gcorr2466 T838 T1302 T838 T1302 -4.2342703406564374e-07
Rt5829 T838 T1528 2016201.1065100029
Gcorr2467 T838 T2151 T838 T2151 -1.479018318614536e-07
Rt5830 T838 T4654 2566316.8796548676
Gcorr2468 T838 T4656 T838 T4656 -4.2342703406572347e-07
Rt5831 T838 T4882 2016201.1065117382
Gcorr2469 T838 T5507 T838 T5507 -1.4790183186107831e-07
Rt5832 T839 T1204 2535031.0969529934
Gcorr2470 T839 T1206 T839 T1206 -3.8801096858114575e-08
Gcorr2471 T839 T2126 T839 T2126 -6.6293535141997588e-08
Rt5833 T839 T4558 2535031.0969524425
Gcorr2472 T839 T4560 T839 T4560 -3.880109685803913e-08
Gcorr2473 T839 T5482 T839 T5482 -6.6293535142160695e-08
Gcorr2474 T840 T1555 T840 T1555 -8.5346287046293922e-08
Rt5834 T840 T1796 9461130.9165482186
Rt5835 T840 T2140 3064279.7458509705
Gcorr2475 T840 T2165 T840 T2165 -1.1815082982363817e-07
Gcorr2476 T840 T4909 T840 T4909 -8.5346287046293974e-08
Rt5836 T840 T5151 9461130.9165482279
Rt5837 T840 T5496 3064279.7458509752
Gcorr2477 T840 T5521 T840 T5521 -1.1815082982363919e-07
Rt5838 T841 T1312 3382420.6677511069
Gcorr2478 T841 T1314 T841 T1314 -1.0003546333429776e-07
Rt5839 T841 T1500 30368678.161037948
Rt5840 T841 T4666 3382420.6677415464
Gcorr2479 T841 T4668 T841 T4668 -1.0003546333449434e-07
Rt5841 T841 T4854 30368678.161628742
Rt5842 T842 T895 2944460.0050190557
Gcorr2480 T842 T896 T842 T896 -1.3108449437016391e-07
Rt5843 T842 T897 40486450.799925447
Rt5844 T842 T4249 2944460.0050190566
Gcorr2481 T842 T4250 T842 T4250 -1.3108449437016518e-07
Rt5845 T842 T4251 40486450.799925782
Gcorr2482 T843 T1316 T843 T1316 -8.220905790669857e-08
Rt5846 T843 T1318 3631000.8106513796
Rt5847 T843 T2137 24975730.591117997
Gcorr2483 T843 T4670 T843 T4670 -8.2209057906317538e-08
Rt5848 T843 T4672 3631000.81064989
Rt5849 T843 T5493 24975730.591427147
Rt5850 T844 T1517 9334338.7319479492
Rt5851 T844 T2091 6976848.1223628148
Gcorr2484 T844 T2097 T844 T2097 -5.4432716927556595e-08
Rt5852 T844 T4871 9334338.7319565695
Rt5853 T844 T5444 6976848.1223557992
Gcorr2485 T844 T5450 T844 T5450 -5.4432716927603056e-08
Rt5854 T845 T2051 975417.23176466522
Gcorr2486 T845 T2659 T845 T2659 -7.4568036193548535e-07
Gcorr2487 T845 T3012 T845 T3012 -1.5832839496610851e-07
Rt5855 T846 T853 8428195.9141645059
Rt5856 T846 T3481 6467723.3784328895
Gcorr2488 T847 T1909 T847 T1909 -1.7208450297160446e-07
Rt5857 T847 T3807 1881204.1121840202
Gcorr2489 T848 T2023 T848 T2023 -5.5669876383881425e-07
Rt5858 T848 T2659 1431258.6992204168
Rt5859 T848 T3372 2278704.8657775768
Rt5860 T849 T872 8348158.1822466142
Rt5861 T849 T3003 6781063.1359366076
Rt5862 T850 T873 8252941.9803370303
Rt5863 T850 T2996 6808649.5698942607
Gcorr2490 T851 T1914 T851 T1914 -2.656417190881489e-07
Rt5864 T851 T4033 1229107.7922787836
Gcorr2491 T852 T1919 T852 T1919 -2.2889092941061454e-07
Rt5865 T852 T3984 1096439.9183206432
Gcorr2492 T853 T1909 T853 T1909 -1.5160385954194751e-07
Rt5866 T853 T1999 6514790.7186906543
Rt5867 T853 T2250 2206497.951564169
Rt5868 T853 T2505 4652588.8492324371
Rt5869 T853 T3481 620353.66709806956
Gcorr2493 T853 T3585 T853 T3585 -2.191961434238139e-07
Rt5870 T853 T3613 1527385.4367572849
Gcorr2494 T854 T1828 T854 T1828 -8.2302192447513433e-08
Gcorr2495 T854 T1830 T854 T1830 -7.9295808997016055e-08
Gcorr2496 T854 T2208 T854 T2208 -7.6040422641296354e-10
Gcorr2497 T854 T2487 T854 T2487 -5.8382269049770329e-08
Rt5871 T854 T2690 746025.0989794021
Rt5872 T854 T2994 844651.16423725639
Rt5873 T854 T3385 776881.78111904126
Gcorr2498 T854 T3387 T854 T3387 -3.9493775669040891e-07
Rt5874 T855 T1919 5667940.2407616405
Gcorr2499 T855 T1921 T855 T1921 -1.9893095332443946e-08
Rt5875 T855 T1922 6719195.4837937988
Rt5876 T855 T2220 2225665.552768928
Rt5877 T855 T2951 430145.69666858483
Rt5878 T855 T4046 104966105.02728683
Rt5879 T855 T4093 4544252.9501450555
Gcorr2500 T856 T1888 T856 T1888 -4.3789072198666739e-08
Gcorr2501 T856 T1945 T856 T1945 -4.0855951715974987e-08
Rt5880 T856 T2418 2631203.5692079267
Rt5881 T856 T2642 618255.1026706096
Rt5882 T856 T3002 478464.00159387576
Rt5883 T856 T3434 1282359.7974735333
Gcorr2502 T856 T3846 T856 T3846 -8.7464323044773957e-07
Gcorr2503 T856 T4198 T856 T4198 -4.1422426903652749e-07
Rt5884 T857 T2468 36167609.841718376
Rt5885 T857 T2469 3236644.4651219873
Rt5886 T857 T2568 135118242.49449536
Rt5887 T857 T2595 183895500.15428904
Rt5888 T857 T2930 871199.63835671253
Rt5889 T857 T4170 625300.07045998925
Gcorr2504 T858 T1850 T858 T1850 -1.7249066830043453e-07
Gcorr2505 T858 T1906 T858 T1906 -8.3800340004477454e-08
Gcorr2506 T858 T2350 T858 T2350 -3.8451918362437675e-08
Rt5890 T858 T2518 3609706.4857503353
Rt5891 T858 T2525 6548122.8654239075
Gcorr2507 T858 T2549 T858 T2549 -7.0404098471083684e-08
Rt5892 T858 T3304 2841686.4198303837
Rt5893 T858 T3715 428222.29735388578
Rt5894 T858 T3862 1534671.1772839411
Rt5895 T859 T1807 22622121.198184449
Rt5896 T859 T2261 1208985.0708438309
Gcorr2508 T859 T2450 T859 T2450 -3.1119626127270964e-07
Rt5897 T859 T2600 18533248.311439592
Rt5898 T859 T2657 1575374.9494653891
Rt5899 T859 T2796 3505993.8526556436
Rt5900 T859 T3430 509975.65013352531
Rt5901 T859 T3978 253985.10783343637
Gcorr2509 T859 T3979 T859 T3979 -6.8051805482489165e-07
Gcorr2510 T860 T1914 T860 T1914 -6.1802004697746621e-08
Rt5902 T860 T1915 13834834.032499526
Rt5903 T860 T2014 3866856.1013181731
Rt5904 T860 T2353 1511996.3424769395
Rt5905 T860 T2958 412307.51394934137
Rt5906 T860 T3523 35379170.333445743
Rt5907 T860 T3866 4379850.4715106105
Gcorr2511 T860 T4043 T860 T4043 -1.470536808316001e-08
Gcorr2512 T860 T4083 T860 T4083 -1.4687994566887022e-07
Gcorr2513 T861 T1987 T861 T1987 -3.3658560481794083e-08
Gcorr2514 T861 T2334 T861 T2334 -5.3150626833930093e-08
Rt5908 T861 T2572 1699708.5509995879
Rt5909 T861 T2576 7451686.4435328795
Rt5910 T861 T2635 1666029.6566565235
Rt5911 T861 T3495 345638.34659963363
Rt5912 T861 T3946 44636697.726264872
Gcorr2515 T862 T1940 T862 T1940 -1.4375146063978606e-07
Gcorr2516 T862 T1991 T862 T1991 -1.3712819437756078e-07
Rt5913 T862 T2289 5537521.239110847
Rt5914 T862 T2679 2602746.0152275679
Rt5915 T862 T3371 2023402.2675516908
Rt5916 T862 T3610 1426187.0722967701
Rt5917 T862 T3888 563239.66120376508
Rt5918 T862 T4011 3942467.4007553491
Gcorr2517 T863 T1983 T863 T1983 -1.3950927229350556e-07
Gcorr2518 T863 T2556 T863 T2556 -3.1943627121635647e-08
Rt5919 T863 T2599 4845704.5208426006
Rt5920 T863 T2656 4387673.4905267954
Gcorr2519 T863 T2658 T863 T2658 -1.0505725419308743e-07
Rt5921 T863 T2928 612158.13894785102
Rt5922 T863 T3998 5254831.8827149803
Rt5923 T863 T4108 566255.97863843839
Gcorr2520 T864 T1933 T864 T1933 -1.6817574042501167e-07
Gcorr2521 T864 T2286 T864 T2286 -1.2548035002938197e-07
Rt5924 T864 T2287 4794233.4020015523
Rt5925 T864 T2288 6323047.5610263441
Rt5926 T864 T2699 1860649.2733581909
Rt5927 T864 T3169 851305.74407722068
Gcorr2522 T864 T3170 T864 T3170 -2.0115202734437378e-07
Rt5928 T864 T3924 688631.93698209478
Rt5929 T864 T3944 1901502.0193346173
Rt5930 T865 T1967 8537691.1115028001
Rt5931 T865 T1975 8100485.8964993516
Gcorr2523 T865 T1976 T865 T1976 -2.0268664387688781e-07
Rt5932 T865 T2404 3528915.0637690295
Gcorr2524 T865 T2424 T865 T2424 -8.1164781556982223e-08
Rt5933 T865 T2924 392771.1048574064
Rt5934 T865 T3444 2230154.4200503817
Gcorr2525 T865 T3518 T865 T3518 -3.6262893067239938e-08
Rt5935 T865 T3926 1106284.8023983382
Gcorr2526 T866 T1859 T866 T1859 -1.344110445212938e-07
Gcorr2527 T866 T1996 T866 T1996 -6.7698757232978485e-08
Rt5936 T866 T2322 3916325.6150948368
Gcorr2528 T866 T2472 T866 T2472 -1.5123331417012764e-07
Rt5937 T866 T2473 2531299.8351954897
Rt5938 T866 T3424 646056.90670084767
Rt5939 T866 T3500 4645132.1983275684
Rt5940 T866 T4190 738412.7254077018
Rt5941 T867 T1989 12099934.460984088
Gcorr2529 T867 T2399 T867 T2399 -6.5485794567069873e-08
Rt5942 T867 T2461 3178266.6357306931
Rt5943 T867 T2632 396559.63888625772
Rt5944 T867 T2707 1918311.1377849514
Gcorr2530 T867 T2942 T867 T2942 -2.0658295557354804e-07
Rt5945 T867 T3101 22706855.711915553
Rt5946 T867 T3799 230993.19131170399
Gcorr2531 T867 T3810 T867 T3810 -1.5039162354333821e-06
Rt5947 T867 T3962 2431711.7358853715
Gcorr2532 T868 T1935 T868 T1935 -2.1611663891676616e-07
Rt5948 T868 T1937 1788766.0125399951
Gcorr2533 T868 T2024 T868 T2024 -1.1646076931178655e-07
Rt5949 T868 T2398 310544.03614799457
Rt5950 T868 T3139 1157355.4574779896
Gcorr2534 T868 T3140 T868 T3140 -8.3884331651319929e-07
Rt5951 T868 T3728 456641.19044214569
Rt5952 T868 T3821 202627.91760070875
Gcorr2535 T868 T3939 T868 T3939 -2.7038777538157496e-06
Rt5953 T869 T2444 3917248.3043361474
Rt5954 T869 T2474 1816549.0685781694
Rt5955 T869 T2475 4208427.0330223665
Rt5956 T869 T2687 16776878.012014478
Rt5957 T869 T2906 306255.45952993404
Gcorr2536 T869 T3681 T869 T3681 -2.5449416931049526e-07
Gcorr2537 T869 T3798 T869 T3798 -9.2356029937293184e-08
Rt5958 T869 T3985 5435378.9191352278
Rt5959 T869 T4175 26473855.373771928
Gcorr2538 T870 T1816 T870 T1816 -1.175912305927964e-07
Rt5960 T870 T2482 2656469.642731817
Rt5961 T870 T2516 3639162.4175438359
Rt5962 T870 T2558 2672828.9952218989
Rt5963 T870 T2947 698270.50943004771
Gcorr2539 T870 T3394 T870 T3394 -6.1938940782386983e-07
Rt5964 T870 T3396 1126861.9087513897
Rt5965 T870 T4007 2939997.0743721682
Rt5966 T870 T4105 4460673.1373066986
Gcorr2540 T871 T1896 T871 T1896 -6.7603751122906437e-08
Rt5967 T871 T2015 2615515.7920353967
Rt5968 T871 T2247 4448759.8361384543
Gcorr2541 T871 T2554 T871 T2554 -1.0689493342851937e-08
Rt5969 T871 T2682 1547671.4769713413
Rt5970 T871 T3004 2240024.8523519286
Rt5971 T871 T3458 1973574.112955488
Rt5972 T871 T3463 862679.18285633344
Gcorr2542 T871 T3761 T871 T3761 -4.4260573731595574e-07
Rt5973 T872 T1909 5858737.2900356688
Gcorr2543 T872 T1914 T872 T1914 -1.2311579113949864e-07
Rt5974 T872 T2028 6858122.2132734228
Rt5975 T872 T2030 924832.23275925033
Gcorr2544 T872 T2465 T872 T2465 -2.4609946677489062e-08
Rt5976 T872 T3003 386631.52031804575
Gcorr2545 T872 T3401 T872 T3401 -5.7142959900399085e-07
Gcorr2546 T872 T3807 T872 T3807 -2.0173745193496515e-07
Rt5977 T872 T4033 2476824.6600654218
Rt5978 T872 T4052 23554915.736385994
Rt5979 T872 T4053 4524523.1164837228
Gcorr2547 T873 T1920 T873 T1920 -3.8295272877317294e-08
Rt5980 T873 T2023 1106110.7260561737
Rt5981 T873 T2428 2568815.0296826879
Rt5982 T873 T2728 543758.59766268136
Rt5983 T873 T2996 272569.8776934935
Gcorr2548 T873 T3372 T873 T3372 -7.7253136531862285e-07
Rt5984 T873 T3375 99488104.112371191
Gcorr2549 T873 T3963 T873 T3963 -1.0446335986254913e-06
Gcorr2550 T874 T1940 T874 T1940 -6.0572369431657277e-08
Rt5985 T874 T1961 3487946.9672627738
Gcorr2551 T874 T1988 T874 T1988 -2.892977676276014e-08
Rt5986 T874 T2498 3509131.6633101618
Rt5987 T874 T3172 1323689.2150035778
Rt5988 T874 T3551 1944989.8523765025
Rt5989 T874 T3920 8147019.2127537373
Rt5990 T874 T4087 530865.31696402282
Rt5991 T875 T2049 4144063.204921023
Gcorr2552 T875 T2050 T875 T2050 -2.1908792089302134e-07
Rt5992 T875 T2445 762495.22736509377
Rt5993 T875 T2538 850883.93884315179
Gcorr2553 T875 T2910 T875 T2910 -6.6828790199343907e-07
Gcorr2554 T875 T3370 T875 T3370 -6.6388229117147741e-07
Rt5994 T875 T3446 126179.46402097022
Rt5995 T875 T3705 4432381.5118382294
Rt5996 T876 T1924 4122826.2939425195
Rt5997 T876 T1925 12637987.968738986
Rt5998 T876 T1926 10078367.256515505
Rt5999 T876 T1936 3774904.3589210715
Gcorr2555 T876 T2731 T876 T2731 -1.6602135523535291e-07
Rt6000 T876 T3158 1618106.9763414694
Rt6001 T876 T3515 20954892.195193186
Rt6002 T876 T3867 388482.29474096093
Rt6003 T876 T3912 1810862.3160172359
Gcorr2556 T877 T883 T877 T883 -2.3267708153419527e-07
Rt6004 T877 T885 13835713.599493785
Rt6005 T877 T886 4996500.4163109176
Gcorr2557 T877 T1845 T877 T1845 -7.1027186394301279e-08
Rt6006 T877 T3137 2567846.9803605708
Rt6007 T877 T3710 469734.71284047537
Rt6008 T877 T3778 728676.58379405772
Gcorr2558 T878 T2271 T878 T2271 -8.2790073853783445e-08
Rt6009 T878 T2358 3162423.8049288443
Gcorr2559 T878 T2559 T878 T2559 -3.2678248320319726e-08
Rt6010 T878 T2617 1021158.489113525
Rt6011 T878 T2857 262667.93241876533
Rt6012 T878 T3784 5056885.4283491699
Gcorr2560 T879 T1955 T879 T1955 -2.9464255135796532e-07
Rt6013 T879 T2057 3450651.9886156768
Gcorr2561 T879 T2081 T879 T2081 -4.1004078601609101e-09
Rt6014 T879 T2361 1696708.0427044292
Gcorr2562 T879 T2719 T879 T2719 -1.3604447873948913e-07
Rt6015 T879 T2858 243172.24143493819
Rt6016 T879 T3496 12447438.038793666
Rt6017 T879 T3986 1283726.2751576637
Gcorr2563 T880 T1961 T880 T1961 -2.998417313940303e-07
Gcorr2564 T880 T2506 T880 T2506 -9.916810619753693e-08
Rt6018 T880 T2592 2464872.650270612
Rt6019 T880 T2621 5722287.6595801581
Rt6020 T880 T2684 5387695.5100116506
Rt6021 T880 T3334 1413806.533209498
Rt6022 T880 T3968 758923.84439488978
Gcorr2565 T880 T3988 T880 T3988 -2.324665814150733e-07
Rt6023 T880 T4079 511855.63703714235
Gcorr2566 T881 T1935 T881 T1935 -1.3565036424801519e-07
Rt6024 T881 T2253 1786429.0842464755
Rt6025 T881 T2490 1991811.7106694512
Rt6026 T881 T2533 1131707.5018255378
Rt6027 T881 T3070 197306.05460879256
Rt6028 T881 T3727 18474839.042239401
Gcorr2567 T881 T3897 T881 T3897 -5.3232194574596599e-07
Gcorr2568 T881 T4112 T881 T4112 -4.6084991100380762e-07
Gcorr2569 T882 T1963 T882 T1963 -2.2952718447430708e-07
Gcorr2570 T882 T2271 T882 T2271 -6.6404636217571604e-09
Rt6029 T882 T2432 1860175.8961546633
Rt6030 T882 T2444 6014068.3099573981
Rt6031 T882 T2646 3353034.9220509874
Rt6032 T882 T3167 199566.86686434146
Rt6033 T882 T3777 20503127.097735699
Rt6034 T882 T4037 7964740.5077015683
Rt6035 T882 T4080 10542620.513108181
Rt6036 T883 T885 15817506.41827351
Rt6037 T883 T2632 22943386.017992351
Rt6038 T883 T2675 666071.5661394865
Rt6039 T883 T3136 2087148.1511607629
Rt6040 T883 T3778 401769.14833290083
Rt6041 T883 T3810 512336.9068353732
Gcorr2571 T883 T3938 T883 T3938 -1.0426991485024439e-06
Rt6042 T884 T2269 1780448.1792736528
Rt6043 T884 T2461 21166562.011764638
Gcorr2572 T884 T2480 T884 T2480 -6.945206582348505e-08
Rt6044 T884 T2547 2995280.8591336152
Rt6045 T884 T2632 6783566.6817267248
Rt6046 T884 T2675 17616327.167439107
Gcorr2573 T884 T3006 T884 T3006 -3.9941909388355368e-07
Rt6047 T884 T3018 1520713.2029203684
Rt6048 T884 T3101 3731780.9755014838
Rt6049 T884 T3938 1225441.7560179087
Rt6050 T885 T886 17807519.062911313
Rt6051 T885 T887 9658778.5890226327
Gcorr2574 T885 T1864 T885 T1864 -3.4457652870652565e-08
Rt6052 T885 T2269 4947561.1038768953
Rt6053 T885 T2675 23772084.381641567
Rt6054 T885 T3005 1335873.9294306056
Rt6055 T885 T3136 1264416.7307808211
Rt6056 T885 T3137 939279.00444401032
Gcorr2575 T885 T3778 T885 T3778 -1.9244936110703642e-07
Rt6057 T885 T4096 10703919.941124475
Rt6058 T886 T887 6616334.7934163716
Rt6059 T886 T888 4181728.6030051964
Rt6060 T886 T1845 5558858.2309643095
Rt6061 T886 T2456 3128027.1066171122
Gcorr2576 T886 T2993 T886 T2993 -1.1633147826264856e-07
Rt6062 T886 T3137 4098542.8029486234
Rt6063 T886 T3159 4125968.1711477982
Rt6064 T886 T3710 8887377.7456527893
Rt6065 T886 T3863 531700.87088880374
Gcorr2577 T886 T4096 T886 T4096 -1.9923329243718803e-07
Rt6066 T887 T888 6416319.92146983
Rt6067 T887 T889 7215160.4035717119
Rt6068 T887 T890 4811336.5864091814
Rt6069 T887 T1864 1216092.2265999026
Gcorr2578 T887 T2877 T887 T2877 -1.2041714025525305e-07
Rt6070 T887 T2912 5325437.9907670459
Gcorr2579 T887 T3005 T887 T3005 -7.131481148244854e-07
Rt6071 T887 T3541 1381253.3180801824
Gcorr2580 T887 T3863 T887 T3863 -1.1394433297688924e-07
Rt6072 T887 T4096 646923.67753311095
Rt6073 T888 T889 7069625.4914902654
Rt6074 T888 T1544 5084480.1269740853
Rt6075 T888 T1841 4175702.0054055648
Rt6076 T888 T2456 27493802.468940981
Rt6077 T888 T2949 2729085.6579166362
Gcorr2581 T888 T2960 T888 T2960 -9.1795494870458439e-08
Rt6078 T888 T2993 964324.88060813048
Rt6079 T888 T3541 5354832.3682200089
Gcorr2582 T888 T3863 T888 T3863 -1.1416689246125859e-07
Rt6080 T889 T890 5981967.7481589718
Rt6081 T889 T891 14694823.526251601
Rt6082 T889 T1544 5476352.5460585998
Rt6083 T889 T2240 4370127.2381133307
Gcorr2583 T889 T2613 T889 T2613 -3.2798557397078599e-08
Rt6084 T889 T2865 5601465.9087510686
Rt6085 T889 T2867 3788929.3718270501
Rt6086 T889 T2877 367636480.42521852
Rt6087 T889 T2949 5510082.9289094619
Rt6088 T889 T3541 18004021.558612209
Rt6089 T889 T3806 2336795.2726053777
Rt6090 T890 T891 5185399.6084362129
Rt6091 T890 T892 3983136.0585554508
Rt6092 T890 T1864 5991613.2176754363
Rt6093 T890 T2297 9236436.7924050633
Rt6094 T890 T2864 11131814.562101942
Gcorr2584 T890 T2865 T890 T2865 -1.2642506715615428e-07
Rt6095 T890 T2877 1541618.5070620275
Rt6096 T890 T2899 3360520.2187920334
Gcorr2585 T890 T2912 T890 T2912 -8.0764744315461215e-08
Rt6097 T891 T892 4638367.1479921928
Rt6098 T891 T893 10171206.292791026
Rt6099 T891 T1392 4269556.7036187313
Rt6100 T891 T2240 3215106.0748891025
Rt6101 T891 T2863 3798640.6724517359
Gcorr2586 T891 T2864 T891 T2864 -8.8305395759292496e-08
Rt6102 T891 T2865 1948138.4638782276
Gcorr2587 T891 T2866 T891 T2866 -8.7205105694260605e-08
Rt6103 T892 T893 4307184.9127741437
Rt6104 T892 T894 10526187.017775752
Rt6105 T892 T1340 3484269.7360482179
Rt6106 T892 T2297 6081191.3098819042
Rt6107 T892 T2862 3730259.5516818021
Gcorr2588 T892 T2863 T892 T2863 -1.2212705053135874e-07
Rt6108 T892 T2864 2169614.0162350973
Gcorr2589 T892 T2899 T892 T2899 -1.4763544607604489e-07
Rt6109 T892 T3595 8990802.3674870711
Rt6110 T893 T894 4235698.4703627843
Rt6111 T893 T895 7504148.2143857703
Rt6112 T893 T1392 3452578.0313923084
Rt6113 T893 T2211 7169811.579925742
Gcorr2590 T893 T2862 T893 T2862 -6.6315224184721329e-08
Rt6114 T893 T2863 2588395.2840161952
Gcorr2591 T893 T3556 T893 T3556 -1.3463465090005241e-07
Rt6115 T894 T895 4160935.2684778874
Rt6116 T894 T896 10852015.030355893
Rt6117 T894 T1340 3992835.5915545295
Rt6118 T894 T2207 4230325.2486658618
Rt6119 T894 T2862 2758618.3362342915
Gcorr2592 T894 T3764 T894 T3764 -5.3804721433998577e-08
Rt6120 T895 T896 4408920.4679667372
Rt6121 T895 T897 5059422.9994169511
Rt6122 T895 T1076 8240334.713032499
Rt6123 T895 T2211 7971145.2802477432
Rt6124 T896 T897 4324243.9021920711
Rt6125 T896 T898 10649620.654066252
Rt6126 T896 T1068 4349114.2088224841
Rt6127 T896 T2207 4048281.2160530076
Rt6128 T897 T898 3832895.4062462407
Rt6129 T897 T899 1777873.1575242409
Rt6130 T897 T1076 1949620.6195769829
Rt6131 T897 T2165 1951534.8429140639
Rt6132 T898 T899 10761621.911861978
Rt6133 T898 T900 10700740.074711643
Rt6134 T898 T1068 4401072.194812119
Rt6135 T898 T2156 4035547.8404275835
Rt6136 T899 T900 4019918.8388458355
Rt6137 T899 T901 10509401.842387063
Rt6138 T899 T2140 4862107.4841552489
Rt6139 T899 T2165 10245134.262531832
Rt6140 T900 T901 4208254.0946005778
Rt6141 T900 T902 10557183.381821642
Rt6142 T900 T2136 3961090.8657893189
Rt6143 T900 T2156 4172827.6347411512
Rt6144 T901 T902 3951857.5638964786
Rt6145 T901 T903 10337895.443429343
Rt6146 T901 T1074 4222852.9445615914
Rt6147 T901 T2140 4013188.4286275385
Rt6148 T902 T903 4226339.3092730744
Rt6149 T902 T904 4162578.5138669456
Rt6150 T902 T905 4018263.3502270016
Rt6151 T902 T2136 4200587.3432935616
Rt6152 T903 T904 3991278.9126809165
Rt6153 T903 T1074 3955726.7621979625
Rt6154 T903 T1553 4235293.0389350634
Rt6155 T903 T2133 4176744.176412663
Rt6156 T903 T2742 2491477.433743062
Gcorr2593 T903 T3629 T903 T3629 -1.4102098048493902e-07
Gcorr2594 T903 T3647 T903 T3647 -1.3899142889396309e-07
Rt6157 T904 T905 10493633.442075469
Rt6158 T904 T906 4062046.7107654763
Rt6159 T904 T907 4165521.1202214011
Rt6160 T904 T2133 10263445.530331803
Gcorr2595 T904 T2882 T904 T2882 -1.3194326075421611e-07
Rt6161 T904 T3629 2562771.6929022456
Rt6162 T905 T906 4153252.9501228528
Rt6163 T905 T1394 4084632.5714672888
Rt6164 T905 T1488 10670365.316105671
Rt6165 T905 T2136 4137188.8998984359
Rt6166 T906 T907 10386630.488447171
Rt6167 T906 T908 4591229.9225202883
Rt6168 T906 T1394 10534219.336369775
Rt6169 T906 T2105 4621377.1759341042
Rt6170 T906 T2882 2832197.3829251057
Gcorr2596 T906 T3916 T906 T3916 -8.6084753335352517e-08
Rt6171 T907 T908 3786984.6439947668
Rt6172 T907 T909 9384794.551504273
Rt6173 T907 T2133 4113740.295582104
Rt6174 T907 T2307 9797883.4027545787
Rt6175 T907 T2882 10231482.311760047
Gcorr2597 T907 T3629 T907 T3629 -7.8055469905695273e-08
Rt6176 T907 T3899 2259526.1432258696
Rt6177 T908 T909 3678363.0774527015
Rt6178 T908 T910 11256197.523050459
Rt6179 T908 T919 1891143.1643844978
Rt6180 T908 T2105 9939173.4578253217
Rt6181 T908 T2882 8633586.5482897293
Rt6182 T908 T3440 2089031.4233586593
Gcorr2598 T908 T3450 T908 T3450 -4.0492441021184285e-07
Gcorr2599 T908 T3899 T908 T3899 -1.3038088931016099e-07
Rt6183 T908 T3916 2383256.8850174183
Rt6184 T909 T910 4050019.3174697077
Rt6185 T909 T911 2801161.1477949517
Rt6186 T909 T923 19399232.859088995
Rt6187 T909 T2307 4149936.847689474
Gcorr2600 T909 T3124 T909 T3124 -1.6640561409306416e-07
Rt6188 T909 T3440 10342640.275238506
Rt6189 T909 T3441 1922551.8569963265
Rt6190 T909 T3899 14384649.597018121
Rt6191 T910 T911 9293000.509154547
Rt6192 T910 T912 5089360.9151216689
Rt6193 T910 T919 4233507.882754745
Rt6194 T910 T2335 7116858.6882552113
Rt6195 T910 T3124 6614096.1330264341
Rt6196 T910 T3332 6924503.6324887946
Rt6197 T910 T3440 4149323.9534714413
Rt6198 T911 T912 9615236.8763645235
Rt6199 T911 T913 842898.8932303593
Rt6200 T911 T923 2459383.8520734049
Rt6201 T911 T2510 18112778.199827347
Rt6202 T911 T3113 4157717.8692807332
Gcorr2601 T911 T3115 T911 T3115 -7.5222988588289152e-07
Rt6203 T911 T3124 690553.95113129541
Gcorr2602 T911 T3441 T911 T3441 -8.7419733831999484e-08
Gcorr2603 T911 T4123 T911 T4123 -1.376573108874886e-07
Rt6204 T912 T913 1013406.6923340651
Rt6205 T912 T914 12101058.123661308
Rt6206 T912 T1889 15192320.093633698
Rt6207 T912 T2335 2055068.6867860837
Gcorr2604 T912 T2683 T912 T2683 -5.8653975228077755e-08
Gcorr2605 T912 T3115 T912 T3115 -6.5127543047617549e-07
Rt6208 T912 T3124 3128417.6078615747
Rt6209 T912 T3125 730375.13496494119
Gcorr2606 T912 T3332 T912 T3332 -1.3815871695043559e-07
Rt6210 T913 T914 3447550.7638613717
Rt6211 T913 T915 11052373.017348783
Rt6212 T913 T1462 25053188.729994562
Rt6213 T913 T2510 1404908.4551696191
Gcorr2607 T913 T3113 T913 T3113 -4.7079808504595047e-07
Rt6214 T913 T3115 352995.77716509014
Gcorr2608 T913 T3124 T913 T3124 -7.2784671423370771e-07
Gcorr2609 T913 T3125 T913 T3125 -6.1579409037159743e-07
Rt6215 T914 T915 5244546.7886244459
Rt6216 T914 T916 3087847.8063334147
Rt6217 T914 T2683 549781.59900182288
Gcorr2610 T914 T3115 T914 T3115 -8.4962357279284552e-08
Rt6218 T914 T3125 2381196.1671902016
Rt6219 T914 T3174 616368.10506740725
Gcorr2611 T914 T3175 T914 T3175 -6.4050773712569424e-07
Gcorr2612 T914 T3487 T914 T3487 -4.1591459310613202e-07
Rt6220 T915 T916 4522869.0412072269
Rt6221 T915 T917 5223174.4180820929
Rt6222 T915 T1462 4840457.8787362771
Rt6223 T915 T2561 34842161.49051775
Rt6224 T915 T3115 5701040.8508016411
Rt6225 T915 T3174 3433591.2641286245
Rt6226 T915 T3575 910676.2326901838
Gcorr2613 T915 T3989 T915 T3989 -8.9021040667109054e-08
Gcorr2614 T916 T917 T916 T917 -1.9061315957437153e-08
Rt6227 T916 T918 3240678.0316867731
Rt6228 T916 T920 51664260.033364154
Rt6229 T916 T2270 6599595.7538652588
Gcorr2615 T916 T2683 T916 T2683 -9.6668905474426677e-08
Gcorr2616 T916 T2945 T916 T2945 -2.4087553873729039e-07
Rt6230 T916 T3174 13819221.473700039
Rt6231 T916 T3487 972303.41284577071
Rt6232 T916 T3989 989376.41049413593
Rt6233 T917 T918 3113026.1852617804
Rt6234 T917 T921 8531372.6434856225
Gcorr2617 T917 T1112 T917 T1112 -1.3598551410302271e-07
Rt6235 T917 T2561 3099125.192531256
Gcorr2618 T917 T2945 T917 T2945 -1.2279506384688e-07
Rt6236 T917 T3575 27321201.134102434
Rt6237 T917 T3680 710128.04480046942
Rt6238 T917 T3989 1034892.6633614618
Rt6239 T918 T921 7043120.6984588942
Rt6240 T918 T922 4631788.7873196127
Rt6241 T918 T2270 6788640.723747869
Rt6242 T918 T2435 1905296.4483503681
Rt6243 T918 T2945 298302.89517595997
Gcorr2619 T918 T3989 T918 T3989 -4.3039639652620095e-07
Gcorr2620 T918 T4121 T918 T4121 -4.5664407194871225e-07
Rt6244 T919 T2105 3316746.9705033605
Rt6245 T919 T2335 12428937.123176565
Rt6246 T919 T2383 3133057.0455873529
Rt6247 T919 T2660 1798699.3352902157
Rt6248 T919 T3332 60164646.846327066
Gcorr2621 T919 T3440 T919 T3440 -1.6263255354220076e-07
Rt6249 T919 T3450 753652.22094422416
Gcorr2622 T919 T3916 T919 T3916 -4.353813619796857e-07
Gcorr2623 T919 T4169 T919 T4169 -3.1918237395509461e-07
Rt6250 T920 T2270 8440169.1906731613
Rt6251 T920 T2317 3343837.0077165859
Rt6252 T920 T2502 6050951.7094813976
Rt6253 T920 T2604 8014276.0950613637
Rt6254 T920 T2683 1913714.8106880346
Rt6255 T920 T3175 660040517.25113046
Gcorr2624 T920 T3223 T920 T3223 -2.0731953970021419e-07
Rt6256 T920 T3487 1622254.6794867786
Rt6257 T920 T3948 1600712.4009665633
Rt6258 T921 T922 6620067.7264915956
Gcorr2625 T921 T924 T921 T924 -1.8642757853370094e-07
Rt6259 T921 T1112 5193784.3090659156
Rt6260 T921 T2511 2346010.6079481081
Rt6261 T921 T2920 400154.72758977843
Gcorr2626 T921 T2923 T921 T2923 -2.8543115932865694e-07
Rt6262 T921 T2945 3208562.2107594851
Rt6263 T921 T3680 1243368.9661315221
Rt6264 T922 T924 4587191.897783041
Rt6265 T922 T925 4989916.6679354459
Rt6266 T922 T926 6498860.0544896508
Rt6267 T922 T2435 3719238.1398831951
Rt6268 T922 T2918 286025.03036115237
Gcorr2627 T922 T2919 T922 T2919 -1.3385777735247819e-07
Rt6269 T922 T2920 1882119.4343624271
Rt6270 T922 T2945 7129082.4555873424
Rt6271 T922 T4121 2775395.0847894615
Gcorr2628 T922 T4122 T922 T4122 -4.4776357486099843e-07
Gcorr2629 T923 T2134 T923 T2134 -2.9718659004373893e-08
Rt6272 T923 T2303 14783825.472948864
Rt6273 T923 T2304 3031352.2154371887
Rt6274 T923 T2307 1766035.5501591002
Rt6275 T923 T2510 11829759.342790054
Gcorr2630 T923 T3112 T923 T3112 -1.4564933960879849e-07
Gcorr2631 T923 T3113 T923 T3113 -9.06940727256353e-09
Gcorr2632 T923 T3441 T923 T3441 -9.8022524309911618e-08
Gcorr2633 T923 T4024 T923 T4024 -4.4829091586361995e-08
Rt6276 T923 T4123 831042.60118461458
Gcorr2634 T924 T925 T924 T925 -2.2753399297830241e-07
Gcorr2635 T924 T2013 T924 T2013 -2.5154912155824489e-07
Gcorr2636 T924 T2226 T924 T2226 -2.7817046458491293e-07
Rt6277 T924 T2451 2430254.8930459474
Rt6278 T924 T2511 13739296.289899889
Rt6279 T924 T2919 403853.28846891841
Rt6280 T924 T2920 867506.85349118302
Rt6281 T924 T2922 1038006.9583509387
Gcorr2637 T925 T926 T925 T926 -1.2832879662067889e-08
Gcorr2638 T925 T927 T925 T927 -2.4980916984742977e-07
Rt6282 T925 T1856 2248836.0008887304
Rt6283 T925 T2226 3265994.0745058898
Rt6284 T925 T2837 338515.85829516203
Rt6285 T925 T2918 5543219.0888012303
Rt6286 T925 T2919 711113.78395786136
Rt6287 T925 T3514 2719315.9185926407
Gcorr2639 T925 T3960 T925 T3960 -5.4195184657489522e-07
Rt6288 T926 T927 7301521.0818212852
Rt6289 T926 T928 2943727.0419618739
Rt6290 T926 T1985 7787905.8215108914
Rt6291 T926 T1986 12258644.419542396
Gcorr2640 T926 T2435 T926 T2435 -3.2477066136651378e-07
Gcorr2641 T926 T2836 T926 T2836 -9.1397448916009744e-08
Rt6292 T926 T2837 1135519.4556437
Rt6293 T926 T2917 242051.58544177137
Rt6294 T926 T2918 1736232.119100902
Rt6295 T926 T4122 2119300.7379787061
Gcorr2642 T926 T4125 T926 T4125 -8.3485761885373662e-07
Gcorr2643 T927 T928 T927 T928 -2.6648769173294046e-07
Rt6296 T927 T929 8725524.2770551499
Gcorr2644 T927 T941 T927 T941 -4.5280908105910317e-08
Rt6297 T927 T1856 2005503.2456935982
Gcorr2645 T927 T2814 T927 T2814 -2.1163979427869708e-07
Rt6298 T927 T2815 557707.80924587301
Rt6299 T927 T2836 457339.26858234894
Rt6300 T927 T2837 643747.92924838793
Gcorr2646 T927 T3960 T927 T3960 -6.3568883544221034e-07
Gcorr2647 T928 T929 T928 T929 -2.4327411844581196e-09
Rt6301 T928 T930 10070615.951848514
Gcorr2648 T928 T1984 T928 T1984 -2.4983212825491917e-07
Rt6302 T928 T1985 8629114.5839844663
Rt6303 T928 T2836 519290.24980212055
Gcorr2649 T928 T2917 T928 T2917 -4.4175255424532377e-07
Rt6304 T928 T2921 509967.8590655913
Rt6305 T928 T4008 3226898.913870139
Rt6306 T928 T4125 1344010.8638009529
Gcorr2650 T929 T930 T929 T930 -2.5035316675729972e-07
Rt6307 T929 T931 16606087.82741249
Gcorr2651 T929 T941 T929 T941 -2.4359021312095774e-07
Rt6308 T929 T1968 28113562.967128631
Rt6309 T929 T2814 503920.8286830727
Rt6310 T929 T2836 2905521.5657025916
Rt6311 T929 T3969 2876141.1516845454
Rt6312 T929 T4008 511272.11739612074
Rt6313 T930 T931 4456665.8176780967
Rt6314 T930 T932 6531142.6330647096
Rt6315 T930 T945 67368058.029679298
Rt6316 T930 T1984 7956055.5536277862
Rt6317 T930 T2921 5781504.2086481275
Gcorr2652 T930 T3552 T930 T3552 -4.8756006227551939e-08
Rt6318 T930 T3570 300655.30114124768
Rt6319 T930 T3830 97161874.55071941
Rt6320 T930 T4008 761248.59049027436
Gcorr2653 T931 T932 T931 T932 -2.4093863555868447e-07
Rt6321 T931 T933 4301144.595075733
Gcorr2654 T931 T1968 T931 T1968 -9.4115499406681194e-08
Rt6322 T931 T2075 564489.11688761495
Rt6323 T931 T2812 18249245.86410553
Gcorr2655 T931 T2817 T931 T2817 -1.2278644780190174e-06
Rt6324 T931 T3552 219464.39682863682
Rt6325 T931 T3969 728991.23236572254
Rt6326 T931 T4008 23407075.176319588
Rt6327 T932 T933 175961347.07578546
Rt6328 T932 T934 6108343.4703187374
Rt6329 T932 T945 492655591.96600711
Gcorr2656 T932 T2006 T932 T2006 -2.3712176941738626e-07
Rt6330 T932 T2827 3160721.2877743714
Rt6331 T932 T3057 292088.76403814321
Rt6332 T932 T3552 733559.65790599398
Rt6333 T932 T3570 6155686.2187413322
Gcorr2657 T933 T934 T933 T934 -3.1613819052825853e-07
Rt6334 T933 T935 17714080.501440089
Gcorr2658 T933 T2075 T933 T2075 -4.0423860077985993e-07
Gcorr2659 T933 T2411 T933 T2411 -3.2028707345188444e-07
Rt6335 T933 T2698 1851663.0045990294
Rt6336 T933 T2817 617682.08400034811
Rt6337 T933 T2821 2508479.8012183919
Rt6338 T933 T2827 346877.502263556
Rt6339 T933 T3552 1908814.4644939308
Gcorr2660 T934 T935 T934 T935 -3.5375233993492616e-08
Rt6340 T934 T936 8617973.2300642543
Gcorr2661 T934 T2006 T934 T2006 -2.3602798965419643e-08
Gcorr2662 T934 T2007 T934 T2007 -2.9848309838859328e-07
Rt6341 T934 T2827 500680.68385541288
Rt6342 T934 T2828 1580818.2501648823
Rt6343 T934 T2855 350109.68469001405
Gcorr2663 T934 T3057 T934 T3057 -1.5083857248739062e-08
Gcorr2664 T935 T936 T935 T936 -3.4316876438214213e-07
Rt6344 T935 T937 10736394.314383423
Gcorr2665 T935 T2099 T935 T2099 -2.2131160445166079e-08
Gcorr2666 T935 T2411 T935 T2411 -2.2477673752683184e-07
Rt6345 T935 T2821 414374.99088515178
Rt6346 T935 T2827 3822430.7753020613
Rt6347 T935 T2828 435199.61798517744
Rt6348 T935 T2829 2422133.8433388802
Rt6349 T936 T937 24661121.434528008
Rt6350 T936 T938 11183160.289272178
Rt6351 T936 T2007 10645895.86028133
Gcorr2667 T936 T2033 T936 T2033 -2.8639333067659506e-07
Rt6352 T936 T2828 440733.74510717019
Rt6353 T936 T2830 1665518.0116057091
Gcorr2668 T936 T2855 T936 T2855 -8.0976269290985682e-08
Rt6354 T936 T3993 347892.3152404172
Gcorr2669 T937 T938 T937 T938 -3.2240766918567206e-07
Rt6355 T937 T939 11943903.522977058
Rt6356 T937 T940 17056546.337575737
Gcorr2670 T937 T2099 T937 T2099 -3.0155064574335898e-07
Rt6357 T937 T2828 37576510.606059179
Rt6358 T937 T2829 297707.69176029653
Rt6359 T937 T2830 582865.40168056393
Rt6360 T937 T2847 1764309.4127450367
Rt6361 T938 T939 480567.91738459788
Gcorr2671 T938 T942 T938 T942 -2.9091305241433343e-07
Gcorr2672 T938 T944 T938 T944 -4.0670574023532505e-09
Rt6362 T938 T2033 91959047.285306528
Rt6363 T938 T2830 204327.74298218629
Gcorr2673 T938 T2847 T938 T2847 -2.0112655104743179e-06
Rt6364 T938 T2860 618225.72422448907
Rt6365 T938 T2874 823064.19395564718
Gcorr2674 T938 T3993 T938 T3993 -2.1728736643463046e-07
Gcorr2675 T939 T940 T939 T940 -2.2761804709671155e-07
Gcorr2676 T939 T942 T939 T942 -4.8820690380011066e-08
Rt6366 T939 T943 123151449.37970449
Gcorr2677 T939 T2417 T939 T2417 -1.058191310392032e-07
Rt6367 T939 T2680 1477796.0980730634
Gcorr2678 T939 T2830 T939 T2830 -1.9678426192426192e-06
Rt6368 T939 T2847 150706.71781007279
Rt6369 T939 T2860 2230901.6736436957
Gcorr2679 T939 T3748 T939 T3748 -1.5295055523816995e-07
Rt6370 T939 T3900 1496825.8790335287
Rt6371 T940 T2099 5548891.1850345191
Gcorr2680 T940 T2412 T940 T2412 -2.1078872111033942e-07
Rt6372 T940 T2417 809826.89844970917
Rt6373 T940 T2665 16006693.673903732
Rt6374 T940 T2829 5982359.4283776032
Rt6375 T940 T2847 847390.16013088799
Rt6376 T940 T2878 265722.64721990714
Gcorr2681 T940 T2898 T940 T2898 -6.5899812905980439e-07
Gcorr2682 T941 T1856 T941 T1856 -1.7779773538937294e-08
Rt6377 T941 T1968 13234640.649657955
Gcorr2683 T941 T1995 T941 T1995 -9.3416684433147702e-08
Rt6378 T941 T2273 1839571.026257324
Gcorr2684 T941 T2552 T941 T2552 -7.4834609483317482e-08
Rt6379 T941 T2813 500931.41175184638
Rt6380 T941 T2814 1312687.5621469996
Rt6381 T941 T2815 883258.73302942934
Gcorr2685 T941 T3038 T941 T3038 -3.7038393332468968e-08
Gcorr2686 T942 T943 T942 T943 -1.3633789963354797e-07
Rt6382 T942 T944 4539092.259488672
Rt6383 T942 T946 123732640.85197653
Rt6384 T942 T1766 6923811.5303488066
Rt6385 T942 T2860 378604.42732294009
Rt6386 T942 T2904 9823537.628569046
Rt6387 T942 T3662 655428.40350422275
Rt6388 T942 T3900 1099173.4891275172
Gcorr2687 T942 T4074 T942 T4074 -2.546594610815556e-07
Gcorr2688 T943 T946 T943 T946 -1.8571815499366025e-07
Rt6389 T943 T947 459073405.15453583
Rt6390 T943 T2280 5010043.0617991528
Rt6391 T943 T2680 25985086.72950666
Rt6392 T943 T3157 1130874.8704284648
Rt6393 T943 T3748 1271377.3118280396
Rt6394 T943 T3900 675037.36626440089
Rt6395 T943 T4074 2380156.1418345952
Gcorr2689 T944 T1766 T944 T1766 -2.9725993825095425e-07
Gcorr2690 T944 T2033 T944 T2033 -2.7039566383344551e-07
Rt6396 T944 T2340 7724791.5710673677
Rt6397 T944 T2396 1707961.9483145587
Rt6398 T944 T2860 1248207415.9680748
Rt6399 T944 T2874 417731.67176787811
Rt6400 T944 T2904 534423.3273276235
Rt6401 T944 T2937 19942245.51525728
Gcorr2691 T945 T1984 T945 T1984 -1.2868068021607087e-07
Gcorr2692 T945 T2006 T945 T2006 -3.6180432364007257e-08
Rt6402 T945 T2591 2867942.4511446641
Rt6403 T945 T2652 1633287.5742061741
Rt6404 T945 T3057 2230089.3173405314
Rt6405 T945 T3570 3566980.9025226021
Rt6406 T945 T3571 379500.300006454
Gcorr2693 T945 T3572 T945 T3572 -6.7631333261736776e-08
Rt6407 T945 T3830 3557764.2959305001
Rt6408 T946 T947 8878295.5773199555
Rt6409 T946 T948 11519056.86062015
Gcorr2694 T946 T1766 T946 T1766 -2.8138955641476735e-07
Gcorr2695 T946 T1950 T946 T1950 -2.8396011165034938e-08
Rt6410 T946 T2633 1180916.2241075539
Rt6411 T946 T3073 1551519.1500624497
Rt6412 T946 T3662 1692537.1891312492
Rt6413 T946 T3804 7269441.0931065213
Gcorr2696 T946 T4015 T946 T4015 -4.6017079109406689e-08
Rt6414 T946 T4074 522346.96368147852
Rt6415 T947 T948 14345066.353677712
Rt6416 T947 T949 5260438.9382272949
Rt6417 T947 T950 5045373.1099958485
Rt6418 T947 T2280 3633911.6275709956
Gcorr2697 T947 T2998 T947 T2998 -1.7537493163773797e-07
Rt6419 T947 T3026 1056267.486422631
Gcorr2698 T947 T3100 T947 T3100 -9.3594922512915845e-08
Rt6420 T947 T3157 1144610.4315238378
Rt6421 T947 T3804 993014.34858577605
Gcorr2699 T947 T4074 T947 T4074 -2.0995858773931753e-07
Gcorr2700 T948 T949 T948 T949 -4.5232729341277643e-09
Rt6422 T948 T951 3620851.4278708845
Rt6423 T948 T952 13186652.220612936
Rt6424 T948 T1950 1823891.7802485141
Gcorr2701 T948 T3073 T948 T3073 -1.52052681255735e-07
Rt6425 T948 T3100 2828719.1374216904
Gcorr2702 T948 T3426 T948 T3426 -6.7345064097200927e-08
Rt6426 T948 T3804 3536839.8803377156
Rt6427 T948 T3843 840163.50260285474
Rt6428 T948 T4047 9002060.8528947216
Rt6429 T949 T950 6337093.1736301035
Rt6430 T949 T951 3748771532.6339607
Rt6431 T949 T953 45326387.612399898
Rt6432 T949 T1853 2974571.7686761236
Rt6433 T949 T2663 2635056.0448221583
Gcorr2703 T949 T3026 T949 T3026 -3.2916306607075475e-08
Rt6434 T949 T3099 1422301.8786122338
Rt6435 T949 T3100 912225.92861831421
Rt6436 T949 T3205 32069895.220974918
Gcorr2704 T949 T4073 T949 T4073 -3.2969768992033568e-07
Rt6437 T950 T953 4198558.6926506776
Rt6438 T950 T954 21199054.835605811
Rt6439 T950 T1381 3692261.5207181913
Gcorr2705 T950 T2280 T950 T2280 -6.4482064201532579e-08
Rt6440 T950 T2998 5606941.624137857
Rt6441 T950 T3025 1400886.5442195532
Rt6442 T950 T3026 1865988.4347407417
Rt6443 T950 T3099 25754705.530930109
Rt6444 T951 T952 4901304.407561495
Rt6445 T951 T977 21932656.971979711
Rt6446 T951 T1898 5481252.5361737637
Rt6447 T951 T2663 1168660.0277082813
Gcorr2706 T951 T3100 T951 T3100 -7.5080822665083506e-08
Rt6448 T951 T3426 1094910.5287967408
Gcorr2707 T951 T3442 T951 T3442 -7.369788141752588e-08
Rt6449 T951 T3927 2898852.4710717695
Gcorr2708 T951 T4047 T951 T4047 -1.550485064924085e-07
Rt6450 T952 T977 6158754.002473061
Rt6451 T952 T978 6078140.9323142385
Rt6452 T952 T1950 5233202.6214308729
Rt6453 T952 T2374 4539594.189275559
Rt6454 T952 T3072 22265608.202640042
Rt6455 T952 T3214 4957712.5373942303
Gcorr2709 T952 T3927 T952 T3927 -1.4845388992712511e-07
Rt6456 T952 T4047 1209858.7549233055
Rt6457 T952 T4188 16034969.992418084
Rt6458 T953 T954 4360778.7164523844
Rt6459 T953 T955 20539806.690457441
Rt6460 T953 T1853 4608969.9569331035
Rt6461 T953 T2008 5047603.4401524365
Rt6462 T953 T2589 7238852.4930306161
Gcorr2710 T953 T3025 T953 T3025 -1.5714849470297053e-07
Rt6463 T953 T3099 1275631.14817304
Rt6464 T953 T3173 2550966.2387866825
Rt6465 T953 T3428 6879707.3615209861
Gcorr2711 T953 T4073 T953 T4073 -1.1034344649030747e-07
Rt6466 T954 T955 5434313.3687070869
Rt6467 T954 T956 16306638.452577857
Rt6468 T954 T1381 7403716.3372950014
Rt6469 T954 T2555 3982806.3809937388
Rt6470 T954 T3025 2128935.8065762231
Rt6471 T954 T3173 35628066.934869155
Rt6472 T954 T3754 2508574.3695658296
Rt6473 T954 T4075 58808597.315192915
Rt6474 T955 T956 4878719.9883923344
Rt6475 T955 T957 13343242.692562824
Rt6476 T955 T959 4761186.1672430737
Rt6477 T955 T2589 1937571.5678304005
Rt6478 T955 T3173 2118553.5633396106
Gcorr2712 T955 T3429 T955 T3429 -1.0170734599990604e-07
Rt6479 T955 T3573 2482485.572605418
Gcorr2713 T955 T3754 T955 T3754 -1.2397805553956691e-07
Rt6480 T956 T957 4851197.2969255811
Rt6481 T956 T958 4229560.0155915217
Rt6482 T956 T961 4490557.5601638854
Rt6483 T956 T2555 3724345.7813229561
Gcorr2714 T956 T3178 T956 T3178 -1.3213251331820674e-07
Rt6484 T956 T3573 25133239.650419228
Gcorr2715 T956 T3574 T956 T3574 -1.1787568704404952e-07
Rt6485 T956 T3754 2889416.7466111905
Rt6486 T956 T4062 2009898.3317234328
Rt6487 T957 T958 11430362.398173658
Rt6488 T957 T959 4303089.7239930602
Rt6489 T957 T960 4408187.3018856039
Rt6490 T957 T2069 4967729.7068868
Rt6491 T957 T2763 6619787.622941697
Rt6492 T957 T3573 5883990.6657676138
Rt6493 T957 T3574 2945604.0121310018
Gcorr2716 T957 T3911 T957 T3911 -8.919901323691772e-08
Rt6494 T958 T961 4880233.3820992308
Rt6495 T958 T962 4907690.8700162265
Rt6496 T958 T1941 6157793.9766289406
Rt6497 T958 T2069 4452720.3087924849
Rt6498 T958 T3574 4452052.869629615
Gcorr2717 T958 T3879 T958 T3879 -1.0176322727819053e-07
Rt6499 T958 T3904 14935131.390545856
Rt6500 T958 T4062 188184895.41682622
Rt6501 T958 T4157 2755043.1275812224
Rt6502 T959 T960 1748185.6509490185
Rt6503 T959 T982 3891428.6276250849
Rt6504 T959 T1375 3065360.1097996365
Rt6505 T959 T2589 1456884.3571014395
Gcorr2718 T959 T2763 T959 T2763 -5.2514111784810001e-08
Gcorr2719 T959 T3429 T959 T3429 -1.5035475181351063e-07
Gcorr2720 T959 T3573 T959 T3573 -3.8546694616072006e-08
Gcorr2721 T959 T3717 T959 T3717 -3.8903089790493618e-07
Rt6506 T959 T3907 625740.07180540171
Rt6507 T960 T982 10573699.06007085
Rt6508 T960 T985 4561124.9837638848
Rt6509 T960 T1461 8928722.0159920584
Rt6510 T960 T2069 5370881.18968191
Rt6511 T960 T2763 3310489.5685266168
Gcorr2722 T960 T3907 T960 T3907 -4.9875164264402765e-07
Gcorr2723 T960 T3911 T960 T3911 -1.3149784931484406e-07
Rt6512 T961 T962 3861563.3266137443
Rt6513 T961 T963 4715333.0881204698
Rt6514 T961 T1900 6058012.8401245056
Rt6515 T961 T2555 9944677.7854874376
Rt6516 T961 T3178 3820058.244080368
Gcorr2724 T961 T3189 T961 T3189 -1.7586607621040971e-07
Rt6517 T961 T3904 2334564.9523805934
Gcorr2725 T961 T4062 T961 T4062 -7.7156924285388147e-08
Rt6518 T961 T4179 6401985.4528134428
Rt6519 T962 T963 11994734.70359836
Rt6520 T962 T964 5427586.1629657904
Rt6521 T962 T965 11195368.619720366
Rt6522 T962 T1941 4987346.4275317453
Rt6523 T962 T3189 2996419.1749518514
Rt6524 T962 T3879 4371371.6351981563
Gcorr2726 T962 T3904 T962 T3904 -8.0008497711838826e-08
Rt6525 T962 T4111 10444370.998730633
Rt6526 T963 T964 3938995.1138340509
Rt6527 T963 T1900 5439994.4422897389
Rt6528 T963 T1972 37660174.618913271
Rt6529 T963 T2390 2612955.8127586883
Rt6530 T963 T3052 2932027.7852803846
Gcorr2727 T963 T3186 T963 T3186 -1.4683512953802066e-07
Rt6531 T963 T3189 2752264.6245134976
Rt6532 T963 T4179 8655731.4052078351
Rt6533 T964 T965 4607175.6197544178
Rt6534 T964 T966 4061304.1093612234
Rt6535 T964 T967 1741314.2545118204
Rt6536 T964 T2390 11382323.619675918
Rt6537 T964 T3186 6489883.3198313219
Rt6538 T964 T3189 12748441.427911902
Rt6539 T964 T3539 998144.2915111545
Gcorr2728 T964 T4109 T964 T4109 -5.4291942722693387e-07
Gcorr2729 T964 T4111 T964 T4111 -1.1598194782259751e-07
Rt6540 T965 T966 4785073.7934546964
Rt6541 T965 T1941 4080245.6305069537
Rt6542 T965 T2373 3835058.8227668097
Rt6543 T965 T2517 4809117.0168452365
Rt6544 T965 T2738 2523412.5950858616
Gcorr2730 T965 T3539 T965 T3539 -7.3897632355117431e-09
Gcorr2731 T965 T3878 T965 T3878 -1.6721902642570203e-07
Gcorr2732 T965 T4050 T965 T4050 -1.3071135074389722e-07
Rt6545 T965 T4111 2343286.8203321304
Rt6546 T966 T967 9918892.4985396024
Rt6547 T966 T968 457470.74739374977
Rt6548 T966 T988 12303512.068757761
Rt6549 T966 T2373 4175477.2103655129
Rt6550 T966 T2989 331207.9791075922
Gcorr2733 T966 T3539 T966 T3539 -7.1045038342939266e-08
Gcorr2734 T966 T3891 T966 T3891 -3.005546050613707e-06
Rt6551 T966 T4050 148383120.70381415
Rt6552 T966 T4109 1861514.5554515007
Rt6553 T967 T968 5533396.0336660352
Rt6554 T967 T969 3678994.3585740114
Rt6555 T967 T1335 3023461.2447602847
Rt6556 T967 T2390 19771208.027155504
Rt6557 T967 T3186 2515097.0348411449
Gcorr2735 T967 T3187 T967 T3187 -1.27818083632615e-07
Rt6558 T967 T3448 3681166.8199387756
Gcorr2736 T967 T3539 T967 T3539 -4.8835269415239773e-07
Rt6559 T967 T4109 2054128.7941368229
Rt6560 T968 T969 3633610.1489121947
Rt6561 T968 T970 3925983.4166574539
Rt6562 T968 T988 4659567.2779248934
Rt6563 T968 T2029 4975003.005880571
Rt6564 T968 T2756 9882248.0058307704
Gcorr2737 T968 T2989 T968 T2989 -2.9949728586251638e-06
Rt6565 T968 T3448 3119657.3990159747
Gcorr2738 T968 T3449 T968 T3449 -1.3518508926901765e-07
Rt6566 T968 T3891 302083.15227414545
Gcorr2739 T968 T4109 T968 T4109 -1.0632130441459818e-07
Rt6567 T969 T970 11241687.761926608
Rt6568 T969 T971 11196812.08767486
Rt6569 T969 T1335 12271304.855050858
Rt6570 T969 T2376 3630003.5434129573
Rt6571 T969 T3187 6992628.2582560526
Gcorr2740 T969 T3448 T969 T3448 -4.3876543476231092e-08
Rt6572 T969 T3449 2426092.8268817258
Rt6573 T970 T971 4021339.9659312828
Rt6574 T970 T972 4072193.2044878434
Rt6575 T970 T2029 3689374.5473225443
Rt6576 T970 T2068 9721603.123815624
Gcorr2741 T970 T2756 T970 T2756 -9.3915373154287892e-08
Rt6577 T970 T3449 3229942.5638799733
Rt6578 T970 T3923 2305920.8253205777
Gcorr2742 T970 T4016 T970 T4016 -1.6109859208242965e-07
Rt6579 T971 T972 9317117.787295932
Rt6580 T971 T973 9515712.4884536434
Rt6581 T971 T2376 3744475.8178182305
Rt6582 T971 T2457 3320281.0136378175
Gcorr2743 T971 T3285 T971 T3285 -1.3794936003821741e-07
Rt6583 T971 T3449 12487743.251332402
Rt6584 T971 T4016 1820245.5485777515
Rt6585 T972 T973 1474642.2648553073
Rt6586 T972 T974 3274384.2485282812
Rt6587 T972 T976 1237788.257768933
Rt6588 T972 T2068 4802151.6052602539
Rt6589 T972 T2955 649687.40560926928
Gcorr2744 T972 T3801 T972 T3801 -4.143462586114196e-07
Rt6590 T972 T3923 22704901.175181877
Rt6591 T972 T4016 68621938.768806472
Gcorr2745 T972 T4139 T972 T4139 -7.0221555288929985e-08
Rt6592 T973 T974 9809823.815323811
Rt6593 T973 T975 4477781.3500418244
Rt6594 T973 T991 8414132.1605202854
Rt6595 T973 T2457 1823437.0109628208
Gcorr2746 T973 T2955 T973 T2955 -5.2331651667965756e-07
Gcorr2747 T973 T3285 T973 T3285 -2.9793501719585213e-07
Rt6596 T973 T3499 13541637.477875013
Rt6597 T973 T3801 1221088.3686163197
Rt6598 T973 T4016 2504427.1615495393
Rt6599 T974 T975 1581826.5342476733
Rt6600 T974 T976 9666144.0934489332
Rt6601 T974 T986 4580967.5924621774
Rt6602 T974 T2196 4557150.2920544259
Gcorr2748 T974 T2778 T974 T2778 -3.5098544329973413e-07
Gcorr2749 T974 T3801 T974 T3801 -1.0617663695356377e-07
Rt6603 T974 T4139 1220267.036930307
Rt6604 T975 T991 3709356.9363226243
Rt6605 T975 T992 10297291.579107961
Rt6606 T975 T2012 4422503.6843570257
Rt6607 T975 T2196 9502188.736224642
Rt6608 T975 T2778 1401123.5147895205
Gcorr2750 T975 T3499 T975 T3499 -5.3357062677374709e-09
Rt6609 T975 T3800 12004468.520284384
Rt6610 T975 T3801 6480546.0288457358
Gcorr2751 T975 T4139 T975 T4139 -4.7320459635537577e-07
Rt6611 T976 T986 3155518.8468186096
Rt6612 T976 T987 4238389.1518943766
Rt6613 T976 T2068 11271174.381280009
Rt6614 T976 T2158 4453019.8077420713
Gcorr2752 T976 T2955 T976 T2955 -6.4906056543984277e-07
Rt6615 T977 T978 6432418.0302408542
Rt6616 T977 T979 6585144.3057275768
Rt6617 T977 T981 4360120.7586186035
Rt6618 T977 T1898 5326282.4794792915
Rt6619 T977 T3214 4927107.1221975349
Rt6620 T977 T3732 4405167.8069638982
Rt6621 T977 T3820 23241313.523462251
Rt6622 T977 T3927 2616489.3104547248
Gcorr2753 T977 T4187 T977 T4187 -7.4043721060108454e-08
Rt6623 T978 T979 5240431.9252484953
Rt6624 T978 T980 4801734.7160518039
Rt6625 T978 T1119 4237550.1937688421
Rt6626 T978 T2374 12334712.725587742
Rt6627 T978 T3213 9123613.7906474136
Gcorr2754 T978 T3214 T978 T3214 -4.8983283255643533e-08
Gcorr2755 T978 T3733 T978 T3733 -1.4162237574952623e-07
Rt6628 T978 T4187 2570829.4386181021
Rt6629 T978 T4188 2523516.559719827
Rt6630 T979 T980 12635445.891056975
Rt6631 T979 T981 4845901.1264277287
Rt6632 T979 T983 10078295.901042271
Rt6633 T979 T1971 3959528.3699931535
Rt6634 T979 T3686 8948933.5327596776
Rt6635 T979 T3732 6338633.3801475484
Rt6636 T979 T3733 2836132.7664996185
Gcorr2756 T979 T4187 T979 T4187 -4.2579476184334943e-08
Rt6637 T980 T1119 4434353.3814695626
Rt6638 T980 T1120 3155191.4257300245
Rt6639 T980 T1907 10286287.225813206
Rt6640 T980 T1971 4683918.183188213
Gcorr2757 T980 T3212 T980 T3212 -2.0510155722245326e-07
Rt6641 T980 T3213 7796367.0218043914
Rt6642 T980 T3719 1898677.4621024407
Rt6643 T980 T3733 6553679.6401665788
Rt6644 T981 T983 3328888.081004838
Rt6645 T981 T984 8956438.4632673133
Rt6646 T981 T1898 91948444.581130892
Rt6647 T981 T2059 1616984.8443956268
Rt6648 T981 T2754 1337096.9314706747
Gcorr2758 T981 T3686 T981 T3686 -1.6947106123527841e-07
Gcorr2759 T981 T3687 T981 T3687 -4.2595062093257835e-07
Rt6649 T981 T3732 11996329.534815909
Rt6650 T981 T3820 3153059.3794736043
Rt6651 T982 T985 4857972.091618292
Rt6652 T982 T994 10584276.104784463
Rt6653 T982 T1375 5151476.7612877544
Rt6654 T982 T2193 4806809.6337442277
Gcorr2760 T982 T3907 T982 T3907 -1.1218014486960374e-07
Rt6655 T983 T984 4821302.8290154329
Rt6656 T983 T989 4838890.6705644224
Rt6657 T983 T1971 4587910.6963129984
Rt6658 T983 T2249 10022860.386538707
Gcorr2761 T983 T2754 T983 T2754 -1.5075531280712223e-07
Rt6659 T983 T3686 2396469.1120608565
Rt6660 T984 T989 4805561.2436633753
Rt6661 T984 T993 3297998.7537334701
Rt6662 T984 T1281 9411465.4411300793
Rt6663 T984 T2059 5188506.6272670766
Rt6664 T984 T2754 13761337.167337507
Rt6665 T985 T994 4271769.9719039556
Rt6666 T985 T995 1302256.5900637016
Rt6667 T985 T1461 1492666.6107027209
Rt6668 T985 T2182 2457213.3713265238
Rt6669 T986 T987 9581500.0981071424
Rt6670 T986 T990 4245143.8813387332
Rt6671 T986 T2151 8514700.2903168276
Rt6672 T986 T2196 4669601.5200962527
Rt6673 T987 T990 4792569.2473500976
Rt6674 T987 T1072 5074614.5130028175
Rt6675 T987 T1233 4677457.648951428
Rt6676 T987 T2158 10606580.629567103
Rt6677 T988 T2029 5422262.8334264355
Rt6678 T988 T2274 6277728.7340660356
Rt6679 T988 T2373 4295685.5054307524
Rt6680 T988 T2495 3769162.1146337166
Rt6681 T988 T2989 3761787.8159102858
Rt6682 T988 T3891 10807691.107321136
Rt6683 T989 T993 9769461.5151095148
Rt6684 T989 T996 4339011.5079729315
Rt6685 T989 T997 10089412.527121877
Rt6686 T989 T2249 3262284.9982891954
Rt6687 T990 T1072 4959651.9696060335
Rt6688 T990 T1073 9781700.8541494105
Rt6689 T990 T1300 5199430.0484231096
Rt6690 T990 T2151 3563939.0433694408
Rt6691 T991 T992 9410383.9616170749
Rt6692 T991 T998 1053617.1102965174
Rt6693 T991 T1595 9745888.3215347473
Rt6694 T991 T2457 7738279.2825038591
Gcorr2762 T991 T3338 T991 T3338 -6.3676986172304292e-07
Rt6695 T991 T3499 1045215.3380308538
Rt6696 T991 T3800 5272589.5896728626
Rt6697 T992 T998 2849243.1204242739
Rt6698 T992 T999 5208828.1168965623
Rt6699 T992 T1000 4970298.3327420475
Rt6700 T992 T2012 3471508.7681649271
Gcorr2763 T992 T3338 T992 T3338 -1.7373940852242635e-07
Rt6701 T992 T3800 1426848.1970496622
Rt6702 T992 T3802 13361023.545264
Gcorr2764 T992 T3889 T992 T3889 -8.3506196950768625e-08
Rt6703 T993 T996 4298168.745733073
Rt6704 T993 T1113 4807553.9816775257
Rt6705 T993 T1281 4847547.7674190458
Rt6706 T993 T2236 4110286.0773855974
Rt6707 T994 T995 10669902.830809206
Rt6708 T994 T1114 4674430.8930626474
Rt6709 T994 T2150 4447940.5307622869
Rt6710 T994 T2193 3665029.8157204492
Rt6711 T995 T1114 4689341.5033058878
Rt6712 T995 T1115 10431905.345987031
Rt6713 T995 T1116 1624258.4218048214
Rt6714 T995 T2182 10078497.774030255
Rt6715 T996 T997 4587560.0909751849
Rt6716 T996 T1077 1719179.9039079978
Rt6717 T996 T1113 4969541.8750522081
Rt6718 T996 T2160 9387528.2459965013
Rt6719 T997 T1077 4732707.3102024859
Rt6720 T997 T1078 4071251.3005664474
Rt6721 T997 T2142 10927672.130401215
Rt6722 T997 T2249 4526082.6983945183
Rt6723 T998 T999 10914287.113421755
Rt6724 T998 T1595 2102070.4081128649
Rt6725 T998 T1642 20784487.305548567
Rt6726 T998 T2420 4228116.9531313377
Gcorr2765 T998 T3336 T998 T3336 -1.9594900887484284e-07
Rt6727 T998 T3338 747575.99129817274
Gcorr2766 T998 T3499 T998 T3499 -3.4994126940020143e-07
Gcorr2767 T998 T3800 T998 T3800 -4.553562109071367e-07
Rt6728 T998 T4100 3795525.835363409
Rt6729 T999 T1000 11113363.451855848
Rt6730 T999 T1001 3838959.7994100763
Rt6731 T999 T1002 4354851.9705093428
Rt6732 T999 T2420 3824322.0405800953
Rt6733 T999 T3338 6627813.4852670105
Gcorr2768 T999 T3598 T999 T3598 -1.2660096138333154e-08
Rt6734 T999 T3802 2835901.8832075866
Rt6735 T999 T3953 24596115.515447889
Rt6736 T1000 T1001 4281308.6567422347
Rt6737 T1000 T1015 4949500.0444418918
Rt6738 T1000 T1814 4706073.9780421359
Rt6739 T1000 T2012 14798920.979549609
Gcorr2769 T1000 T2841 T1000 T2841 -6.1478301040435761e-08
Rt6740 T1000 T3802 4230233.1383325383
Rt6741 T1000 T3889 8387992.8529925626
Rt6742 T1000 T4182 4717118.9437686484
Rt6743 T1001 T1002 10786289.198918037
Rt6744 T1001 T1003 4648074.139859898
Rt6745 T1001 T1015 4411307.6359371394
Rt6746 T1001 T2267 8836897.212986432
Rt6747 T1001 T2841 5499052.7705259528
Rt6748 T1001 T3597 8499598.5243418086
Rt6749 T1001 T3598 3004315.7619128618
Gcorr2770 T1001 T3802 T1001 T3802 -1.4466833419512135e-07
Rt6750 T1002 T1003 3884054.4019408491
Rt6751 T1002 T1004 4348639.2377613075
Rt6752 T1002 T2420 12322159.970438432
Rt6753 T1002 T2483 4025325.320189001
Rt6754 T1002 T3133 26514952.795629799
Rt6755 T1002 T3598 2927573.994905923
Gcorr2771 T1002 T3599 T1002 T3599 -4.4899598016448641e-08
Rt6756 T1002 T3953 5624820.4456417188
Rt6757 T1003 T1004 10136213.770232122
Rt6758 T1003 T1005 4480635.5799342357
Rt6759 T1003 T1266 10653775.801014526
Rt6760 T1003 T2267 4230130.7928213309
Rt6761 T1003 T3597 12711112.133037457
Gcorr2772 T1003 T3598 T1003 T3598 -1.3770984084651579e-07
Rt6762 T1003 T3599 2398905.4998628292
Rt6763 T1003 T3913 6969365.6076431982
Rt6764 T1004 T1005 4724535.1469606571
Rt6765 T1004 T1006 8820641.1179195046
Rt6766 T1004 T1273 5210628.4378350414
Rt6767 T1004 T2483 9115706.9862520956
Rt6768 T1004 T3133 10054896.1043003
Rt6769 T1004 T3599 12305103.922634834
Rt6770 T1004 T4097 2737433.2360836342
Rt6771 T1005 T1006 5180320.4638819061
Rt6772 T1005 T1007 4721522.1436053412
Rt6773 T1005 T1266 3910202.637601384
Rt6774 T1005 T1910 5570113.02474414
Rt6775 T1005 T2751 1960522.7599180981
Rt6776 T1005 T3588 7225059.6329679284
Rt6777 T1005 T3599 63656507.859817021
Gcorr2773 T1005 T3913 T1005 T3913 -9.8606189464425174e-08
Gcorr2774 T1005 T3971 T1005 T3971 -1.0133458862517642e-07
Rt6778 T1005 T4097 10263767.568595409
Rt6779 T1006 T1007 3517469.2362252208
Rt6780 T1006 T1008 2436652.0044431468
Rt6781 T1006 T1273 4717940.8777772533
Rt6782 T1006 T2497 10853720.609373603
Rt6783 T1006 T3132 3670941.938177275
Gcorr2775 T1006 T3517 T1006 T3517 -1.5864261940928359e-07
Rt6784 T1006 T3588 1802730.5029663714
Rt6785 T1006 T4097 12358501.180356333
Gcorr2776 T1006 T4101 T1006 T4101 -1.5420663260681307e-07
Rt6786 T1007 T1008 1281024.5782375312
Rt6787 T1007 T1009 3230367.6508833575
Rt6788 T1007 T1033 10323317.761323636
Rt6789 T1007 T1910 4357179.0004719486
Rt6790 T1007 T2950 13029046.943444919
Gcorr2777 T1007 T3517 T1007 T3517 -1.0611955462697646e-06
Gcorr2778 T1007 T3588 T1007 T3588 -2.0738858369862489e-07
Rt6791 T1007 T3971 10823903.689468727
Rt6792 T1007 T4101 601553.96403153543
Rt6793 T1008 T1009 4076262.181734887
Rt6794 T1008 T1010 3965404.3069562656
Rt6795 T1008 T2378 6982973.6002042349
Rt6796 T1008 T2497 1063720.5571449839
Gcorr2779 T1008 T3132 T1008 T3132 -6.4090960164764104e-07
Rt6797 T1008 T3135 51586761.582126833
Rt6798 T1008 T3517 422800.62768178887
Gcorr2780 T1008 T3625 T1008 T3625 -9.369941455139954e-08
Gcorr2781 T1008 T4101 T1008 T4101 -1.0614256347038259e-06
Rt6799 T1009 T1010 9196559.2272357028
Rt6800 T1009 T1011 4500971.2400643285
Rt6801 T1009 T1033 4287144.4903821284
Rt6802 T1009 T1946 4762712.0570581136
Gcorr2782 T1009 T2759 T1009 T2759 -5.827949969673223e-08
Gcorr2783 T1009 T2950 T1009 T2950 -5.2192337012518141e-08
Rt6803 T1009 T3517 9412066.051326571
Rt6804 T1009 T3625 6083815.5909031983
Rt6805 T1009 T3835 1889997.6939694982
Gcorr2784 T1009 T4101 T1009 T4101 -1.4459484997890929e-07
Rt6806 T1010 T1011 3278083.5679415325
Rt6807 T1010 T1012 5148313.8517512428
Rt6808 T1010 T1309 4117333.500575765
Rt6809 T1010 T2378 8315760.3601451758
Gcorr2785 T1010 T3135 T1010 T3135 -1.2950094773025659e-09
Rt6810 T1010 T3625 1683643.1342976163
Gcorr2786 T1010 T3826 T1010 T3826 -1.9362965449385849e-07
Rt6811 T1010 T4142 6483226.7672420256
Rt6812 T1011 T1012 12214868.499086337
Rt6813 T1011 T1013 5349422.1971978107
Rt6814 T1011 T1946 5125831.1574836066
Rt6815 T1011 T2085 4643258.960712811
Rt6816 T1011 T2759 3192307.5795590775
Gcorr2787 T1011 T3625 T1011 T3625 -1.5611508247075317e-07
Rt6817 T1011 T3826 2990955.8640779695
Rt6818 T1011 T4036 7016356.4662515065
Rt6819 T1012 T1013 3549689.7110812911
Rt6820 T1012 T1014 4167500.8040481494
Rt6821 T1012 T1309 4941915.2518162495
Rt6822 T1012 T2282 9271626.5414124187
Gcorr2788 T1012 T2957 T1012 T2957 -1.6478013153109842e-07
Rt6823 T1012 T3540 3017649.8803722518
Rt6824 T1012 T3826 3166022.067002154
Rt6825 T1012 T4142 53812321.600555055
Rt6826 T1013 T1014 9082562.255876299
Rt6827 T1013 T1016 3640282.0451304885
Rt6828 T1013 T1075 4425136.7007846227
Rt6829 T1013 T2085 5975869.5838948274
Rt6830 T1013 T2957 1734267.7396965222
Gcorr2789 T1013 T3826 T1013 T3826 -1.2005231057012531e-07
Rt6831 T1013 T4036 7210652.1507191351
Rt6832 T1014 T1016 4802824.9744970547
Rt6833 T1014 T1017 4750218.2836547345
Rt6834 T1014 T1026 10529464.163028203
Rt6835 T1014 T2282 4049817.0622344282
Rt6836 T1014 T2957 11648274.689060597
Rt6837 T1014 T3527 5636844.1083866097
Rt6838 T1014 T3540 14335293.219239976
Rt6839 T1014 T3693 7559180.9176327493
Rt6840 T1015 T1814 5320369.2265697932
Rt6841 T1015 T1959 40421113.313389458
Rt6842 T1015 T2267 3737245.3370070928
Rt6843 T1015 T2459 3068800.2214286742
Rt6844 T1015 T2841 3798715.1826428548
Gcorr2790 T1015 T3597 T1015 T3597 -1.6854516034281126e-07
Gcorr2791 T1015 T4182 T1015 T4182 -8.2245443132123625e-08
Rt6845 T1016 T1017 4621420.7027619379
Rt6846 T1016 T1018 10153949.919046657
Rt6847 T1016 T1075 10650188.247714724
Rt6848 T1016 T2187 4676079.119266252
Gcorr2792 T1016 T2957 T1016 T2957 -1.2841177091521151e-07
Rt6849 T1016 T3693 5941839.0421331469
Rt6850 T1017 T1018 3533027.0231591971
Rt6851 T1017 T1019 5034158.2668075347
Rt6852 T1017 T1026 4460746.2642909382
Rt6853 T1017 T2256 9618667.8159110658
Rt6854 T1017 T2740 2700519.7221328649
Rt6855 T1017 T3527 26038344.907293569
Rt6856 T1017 T3693 7299540.1377182342
Rt6857 T1017 T4054 11328301.892650573
Rt6858 T1018 T1019 4737931.2151418477
Rt6859 T1018 T1020 10695392.70972438
Rt6860 T1018 T2152 3564252.6810962898
Rt6861 T1018 T2187 4673857.0687709292
Gcorr2793 T1018 T2740 T1018 T2740 -1.0411215632715942e-07
Rt6862 T1019 T1020 4504426.2522323653
Rt6863 T1019 T1021 3324606.4553595409
Rt6864 T1019 T2146 3305438.3031720328
Rt6865 T1019 T2256 1423490.2335725455
Rt6866 T1019 T2740 8562428.6813459564
Gcorr2794 T1019 T3577 T1019 T3577 -4.6093303150525915e-07
Rt6867 T1019 T3898 860687.41811957047
Gcorr2795 T1019 T4054 T1019 T4054 -2.3722985258529448e-07
Rt6868 T1020 T1021 10576674.093745496
Rt6869 T1020 T1022 4567986.3138995823
Rt6870 T1020 T1254 10611196.117635241
Rt6871 T1020 T2152 1600752.5672721134
Rt6872 T1021 T1022 4702593.7532220483
Rt6873 T1021 T1023 9641704.2713598181
Rt6874 T1021 T1024 4244869.5944415936
Rt6875 T1021 T2146 5055096.945970796
Rt6876 T1021 T3593 7103541.1499332823
Gcorr2796 T1021 T3898 T1021 T3898 -1.3645276220785373e-07
Rt6877 T1022 T1023 4667253.4815411316
Rt6878 T1022 T1036 2389272.3626200692
Rt6879 T1022 T1254 3691553.3617319418
Rt6880 T1022 T2355 7666700.457261987
Rt6881 T1023 T1024 3509031.4506524955
Rt6882 T1023 T1025 4583888.7251068894
Rt6883 T1023 T1036 8786708.605967341
Rt6884 T1023 T2095 5300160.0248756483
Gcorr2797 T1023 T2776 T1023 T2776 -1.0784477821707072e-07
Rt6885 T1024 T1025 10582963.508298196
Rt6886 T1024 T1027 3850579.0606287196
Rt6887 T1024 T1468 9573571.137598101
Rt6888 T1024 T2146 4600141.5439179707
Rt6889 T1024 T2776 2447743.5271997028
Rt6890 T1024 T3535 10720510.883949472
Rt6891 T1024 T3593 8517784.4255374912
Rt6892 T1025 T1027 4154544.5546216252
Rt6893 T1025 T1028 10581978.221250456
Rt6894 T1025 T2084 3542656.7135527981
Rt6895 T1025 T2095 4890207.5417141849
Rt6896 T1025 T2776 6178594.7616172815
Rt6897 T1025 T3651 3021974.330733709
Rt6898 T1026 T2256 4531334.019892158
Rt6899 T1026 T2257 11057151.602536753
Rt6900 T1026 T2282 3254220.7951636179
Rt6901 T1026 T2489 3324259.908629437
Gcorr2798 T1026 T3168 T1026 T3168 -1.1480908003992162e-07
Rt6902 T1026 T3287 4223877.854620127
Rt6903 T1026 T3527 2467105.7457037717
Gcorr2799 T1026 T4054 T1026 T4054 -6.0253995988099151e-08
Rt6904 T1027 T1028 3531239.0654235487
Rt6905 T1027 T1029 9567851.9410285354
Rt6906 T1027 T1468 2099357.1216144864
Rt6907 T1027 T2368 8790053.0991690066
Rt6908 T1027 T2776 38091727.312197909
Rt6909 T1027 T3533 1286809.1583515638
Gcorr2800 T1027 T3535 T1027 T3535 -2.3380665865470832e-07
Gcorr2801 T1027 T3651 T1027 T3651 -1.0491991068541907e-07
Rt6910 T1028 T1029 3931334.6040590508
Rt6911 T1028 T1030 11617457.553016523
Rt6912 T1028 T1031 4524450.2630829979
Rt6913 T1028 T2084 4610521.592776902
Gcorr2802 T1028 T3533 T1028 T3533 -1.2503188418303888e-07
Rt6914 T1028 T3534 2931890.2094819276
Rt6915 T1028 T3651 2996093.0125489207
Gcorr2803 T1028 T3876 T1028 T3876 -6.3912253875861808e-08
Rt6916 T1029 T1030 3615365.1707060598
Rt6917 T1029 T1267 10379856.413493305
Rt6918 T1029 T1268 22121185.005051967
Rt6919 T1029 T2368 3107754.4174643778
Rt6920 T1029 T3117 2105899.8840959575
Rt6921 T1029 T3533 9550066.4484693613
Gcorr2804 T1029 T3534 T1029 T3534 -4.8841013438109436e-08
Rt6922 T1030 T1031 1833519.4112313862
Rt6923 T1030 T1032 8944062.3052256964
Rt6924 T1030 T1267 3976601.3254920612
Rt6925 T1030 T2352 4149798.426953604
Gcorr2805 T1030 T2735 T1030 T2735 -3.7175341355659019e-07
Gcorr2806 T1030 T3117 T1030 T3117 -9.2125462736312805e-08
Rt6926 T1030 T3190 8018607.5215988215
Rt6927 T1030 T3534 1898703.1923762453
Rt6928 T1030 T3884 2909173.2724255836
Rt6929 T1031 T1032 2895074.1570239677
Rt6930 T1031 T1034 10635718.387332039
Rt6931 T1031 T1416 3316246.6465025265
Rt6932 T1031 T2084 4904169.0893295836
Rt6933 T1031 T2735 929089.59601669153
Gcorr2807 T1031 T3534 T1031 T3534 -1.4192004864126197e-07
Rt6934 T1031 T3876 6288287.642965368
Gcorr2808 T1031 T3884 T1031 T3884 -4.3943972081780148e-07
Rt6935 T1032 T1034 4810647.8450179687
Rt6936 T1032 T1035 4764251.4491394395
Rt6937 T1032 T1037 3007930.7353088241
Rt6938 T1032 T2352 8435952.8749604281
Gcorr2809 T1032 T2735 T1032 T2735 -2.1760663169225208e-07
Rt6939 T1032 T3701 16391948.774068037
Gcorr2810 T1032 T3883 T1032 T3883 -1.4756789583468176e-07
Rt6940 T1032 T3884 1229135.436725107
Rt6941 T1033 T1910 4710480.1462915912
Rt6942 T1033 T1911 4778062.419542307
Rt6943 T1033 T1946 6195551.1414223416
Rt6944 T1033 T2036 4508324.5862363195
Rt6945 T1033 T2950 2949988.085915186
Gcorr2811 T1033 T3835 T1033 T3835 -1.1578234772213119e-07
Rt6946 T1034 T1035 10552977.706646701
Rt6947 T1034 T1416 4807321.5884986566
Rt6948 T1034 T1417 4674719.5842084279
Rt6949 T1034 T2063 3597855.0911298105
Rt6950 T1034 T2735 11691046.063010983
Rt6951 T1034 T3701 2568387.4533923469
Rt6952 T1035 T1037 10143451.489712039
Rt6953 T1035 T1038 1392272.855571643
Rt6954 T1035 T1039 11252878.086314756
Rt6955 T1035 T2063 1766800.2384835128
Rt6956 T1035 T2956 1329118.8154371344
Rt6957 T1035 T3701 2563021.452207448
Gcorr2812 T1035 T3743 T1035 T3743 -5.3072721393809173e-07
Rt6958 T1035 T3883 2808773.9171696249
Rt6959 T1036 T2095 3465299.6498411051
Rt6960 T1036 T2221 4196876.4037515596
Rt6961 T1036 T2296 4602804.8714321898
Rt6962 T1036 T2355 4801368.8316196734
Rt6963 T1037 T1038 1436379.8701495246
Gcorr2813 T1037 T2071 T1037 T2071 -4.4242542714815446e-08
Rt6964 T1037 T2242 3440308.7583152112
Rt6965 T1037 T2352 845755.98279192613
Gcorr2814 T1037 T3190 T1037 T3190 -3.1762677922031473e-07
Rt6966 T1037 T3504 871977.26478968211
Gcorr2815 T1037 T3743 T1037 T3743 -4.9738980353195825e-07
Gcorr2816 T1037 T3847 T1037 T3847 -2.3970415445261316e-07
Rt6967 T1037 T3883 1375818.4083507822
Gcorr2817 T1037 T3884 T1037 T3884 -1.6325096054588322e-07
Rt6968 T1038 T1039 4735695.638983597
Rt6969 T1038 T1040 4018890.8366349386
Rt6970 T1038 T1041 1740750.4815311353
Rt6971 T1038 T2242 2084069.6683645605
Gcorr2818 T1038 T2956 T1038 T2956 -3.3473588056416918e-07
Gcorr2819 T1038 T3470 T1038 T3470 -5.0753735114966043e-07
Gcorr2820 T1038 T3504 T1038 T3504 -4.0589419056190455e-07
Rt6972 T1038 T3743 434454.04360378225
Gcorr2821 T1038 T3883 T1038 T3883 -4.3948539800212251e-07
Gcorr2822 T1038 T3909 T1038 T3909 -7.8439072616232617e-08
Rt6973 T1039 T1040 2352364.9989443962
Rt6974 T1039 T1697 4812530.2700544335
Rt6975 T1039 T1791 4972578.9296701662
Rt6976 T1039 T2063 4734345.406425993
Gcorr2823 T1039 T2758 T1039 T2758 -3.5757423163558296e-07
Rt6977 T1039 T2956 12163486.784950834
Rt6978 T1039 T3909 1568290.9077240848
Rt6979 T1040 T1041 4133899.571439228
Rt6980 T1040 T1042 5525345.7038017511
Rt6981 T1040 T1697 9213684.1744656675
Rt6982 T1040 T2083 3448006.1185580706
Rt6983 T1040 T2758 1194481.0253076993
Gcorr2824 T1040 T3682 T1040 T3682 -1.4923330490380175e-07
Gcorr2825 T1040 T3743 T1040 T3743 -2.5933032286975823e-08
Gcorr2826 T1040 T3909 T1040 T3909 -2.7580020671737192e-07
Rt6984 T1040 T4017 8676575.5040556081
Rt6985 T1041 T1042 11661762.671622362
Rt6986 T1041 T1043 4432025.9796638601
Rt6987 T1041 T2242 12574527.581154801
Rt6988 T1041 T2565 8965962.7012411524
Rt6989 T1041 T3470 1403844.7451265007
Gcorr2827 T1041 T3743 T1041 T3743 -3.6070973602494565e-07
Rt6990 T1041 T4017 5184645.8747203732
Rt6991 T1042 T1043 4115398.8656466757
Rt6992 T1042 T1044 4556093.9587100586
Rt6993 T1042 T1045 9250490.1779300123
Rt6994 T1042 T2083 5196769.0328110643
Rt6995 T1042 T3471 11299941.104857776
Rt6996 T1042 T3682 5803780.5423281826
Rt6997 T1042 T3961 10996961.399992697
Rt6998 T1042 T4017 4721037.2726120101
Rt6999 T1043 T1044 5370398.3617045479
Rt7000 T1043 T1262 4936846.2229353189
Rt7001 T1043 T1263 21343166.948735449
Rt7002 T1043 T2565 3245648.0370501638
Rt7003 T1043 T3469 3448755.2541697836
Rt7004 T1043 T3470 16857517.437035244
Rt7005 T1043 T3471 2604918.0170088764
Gcorr2828 T1043 T4017 T1043 T4017 -1.3052121221059829e-07
Rt7006 T1043 T4174 41533581.915211916
Rt7007 T1044 T1045 4135114.1665082239
Rt7008 T1044 T1046 4625668.4912773035
Rt7009 T1044 T1262 4762609.4205130665
Rt7010 T1044 T2299 3753216.5369808734
Rt7011 T1044 T2800 10177179.86447135
Gcorr2829 T1044 T3077 T1044 T3077 -1.2176179165794564e-07
Rt7012 T1044 T3471 3547014.3370380597
Rt7013 T1044 T3868 2484600.1652165917
Gcorr2830 T1044 T3961 T1044 T3961 -1.4337559564484185e-07
Rt7014 T1044 T4174 15886778.41162624
Rt7015 T1045 T1046 11621999.589061162
Rt7016 T1045 T1047 4867876.111808084
Rt7017 T1045 T1261 4326090.4570684526
Rt7018 T1045 T2083 5915547.8787084175
Rt7019 T1045 T2800 6794010.6559682786
Rt7020 T1045 T3961 2231634.3967974046
Rt7021 T1046 T1047 4311865.2004603874
Rt7022 T1046 T1048 3140272.3226298932
Rt7023 T1046 T1049 2758516.0818191199
Rt7024 T1046 T2299 3368285.2604269297
Rt7025 T1046 T2800 3722312.2685270356
Rt7026 T1046 T3750 1043296.993765823
Gcorr2831 T1046 T3868 T1046 T3868 -1.1044370504534253e-07
Gcorr2832 T1046 T4056 T1046 T4056 -5.1014888888257454e-07
Rt7027 T1047 T1048 4855527.6717262976
Rt7028 T1047 T1261 5009413.5649699857
Rt7029 T1047 T1472 10773293.235594628
Rt7030 T1047 T2235 4347697.585869397
Gcorr2833 T1047 T2800 T1047 T2800 -1.2438759860998663e-07
Rt7031 T1048 T1049 5501217.7970080776
Rt7032 T1048 T1050 10239637.797516486
Rt7033 T1048 T1051 4965778.8717857618
Rt7034 T1048 T2235 4257767.775998014
Gcorr2834 T1048 T3750 T1048 T3750 -1.4852438450511479e-07
Rt7035 T1048 T4056 7442834.1508638849
Rt7036 T1049 T1050 4772339.3725629188
Rt7037 T1049 T1061 10887656.18921354
Rt7038 T1049 T1771 3850345.8905713637
Rt7039 T1049 T2299 4049612.316495527
Rt7040 T1049 T2745 3424185.6617559474
Rt7041 T1049 T3075 52758982.385712378
Gcorr2835 T1049 T3750 T1049 T3750 -3.2201490601541634e-07
Rt7042 T1049 T4056 1658739.710079276
Rt7043 T1050 T1051 4849059.0259907711
Rt7044 T1050 T1052 4730279.3256857647
Rt7045 T1050 T1061 4922310.0879500406
Rt7046 T1050 T2171 10305499.034089532
Gcorr2836 T1050 T2745 T1050 T2745 -8.212496696317592e-08
Rt7047 T1051 T1052 4894131.2597186919
Rt7048 T1051 T1053 10166960.013935385
Rt7049 T1051 T2235 4400786.3500718456
Rt7050 T1051 T2308 3914691.496330325
Rt7051 T1052 T1053 4739425.9999992959
Rt7052 T1052 T1054 10179208.435392162
Rt7053 T1052 T2141 1804524.7210106975
Rt7054 T1052 T2171 5072592.2534044757
Rt7055 T1053 T1054 4917906.5410240581
Rt7056 T1053 T1055 4288663.6302991239
Rt7057 T1053 T1241 10572343.207364552
Rt7058 T1053 T2308 303233.66597809526
Rt7059 T1054 T1055 4135068.8776677954
Rt7060 T1054 T1056 10592470.246572983
Rt7061 T1054 T1057 4639506.7599163
Rt7062 T1054 T2141 3846529.0282090032
Rt7063 T1055 T1056 4059224.9684417294
Rt7064 T1055 T1071 4252894.6583055537
Rt7065 T1055 T1241 3967721.5503891706
Rt7066 T1055 T2138 10558407.13799602
Rt7067 T1055 T3216 9313630.7625602074
Rt7068 T1055 T3660 3792830.0954376399
Rt7069 T1056 T1057 4594883.6524805101
Rt7070 T1056 T1058 9594330.4285050388
Rt7071 T1056 T1071 5178525.1612930056
Rt7072 T1056 T2135 5469771.5177761512
Gcorr2837 T1056 T3216 T1056 T3216 -3.3754121944486233e-08
Rt7073 T1056 T4171 6968894.7465811297
Rt7074 T1057 T1058 2974739.3274153434
Rt7075 T1057 T1059 9862322.1749942005
Rt7076 T1057 T1453 3830157.6312159337
Rt7077 T1057 T2141 5044915.2948150635
Rt7078 T1058 T1059 4611076.203837716
Rt7079 T1058 T1060 4660457.1546562873
Rt7080 T1058 T1597 4410197.9508451419
Rt7081 T1058 T2135 2768965.9767341511
Gcorr2838 T1058 T2764 T1058 T2764 -2.2812725374502078e-07
Rt7082 T1059 T1060 10739483.503144491
Rt7083 T1059 T1062 3062041.1500676693
Rt7084 T1059 T1453 4660714.6018581027
Rt7085 T1059 T2157 4502358.4009556649
Rt7086 T1060 T1062 1645747.7558571594
Rt7087 T1060 T1063 10538664.627390446
Rt7088 T1060 T1597 9928918.5799125135
Rt7089 T1060 T2131 4509974.0123132095
Rt7090 T1061 T1771 3980743.3824473689
Rt7091 T1061 T2171 2978516.9904825697
Rt7092 T1061 T2295 9094093.0575553309
Rt7093 T1061 T2395 3815900.0447973781
Rt7094 T1061 T2745 3034472.8567846548
Rt7095 T1061 T3042 3010421.2897699345
Gcorr2839 T1061 T3043 T1061 T3043 -1.8488187368758804e-08
Rt7096 T1062 T1063 4343355.0716273095
Rt7097 T1062 T1064 4516262.9619261269
Rt7098 T1062 T1066 1769686.2432509724
Rt7099 T1062 T2157 2957468.4184184596
Rt7100 T1063 T1064 10532035.578655688
Rt7101 T1063 T1065 1809409.544410252
Rt7102 T1063 T1069 10336405.429519797
Rt7103 T1063 T2131 4648393.7579723615
Rt7104 T1064 T1065 4505752.1588527998
Rt7105 T1064 T1066 10582132.134026499
Rt7106 T1064 T1067 4352736.9111344796
Rt7107 T1064 T2198 10407317.558452535
Rt7108 T1065 T1069 2755576.4273093422
Rt7109 T1065 T1070 2749612.7998669934
Rt7110 T1065 T2119 1711757.9734768234
Rt7111 T1065 T2198 4410906.0084634805
Rt7112 T1066 T1067 4314139.794085511
Rt7113 T1066 T1255 10478939.333595667
Rt7114 T1066 T2100 4587631.4447827898
Rt7115 T1066 T2157 10476923.71829254
Rt7116 T1067 T1255 1712434.1504435355
Rt7117 T1067 T1256 1684151.6274507442
Rt7118 T1067 T2058 1802233.6015249572
Rt7119 T1067 T2198 1710188.0859700593
Gcorr2840 T1067 T2748 T1067 T2748 -4.1666018834969276e-07
Gcorr2841 T1067 T3648 T1067 T3648 -4.0275229153792572e-07
Rt7120 T1068 T2156 10856258.251220224
Rt7121 T1068 T2163 4008712.8525574957
Rt7122 T1068 T2164 4119223.924997977
Rt7123 T1068 T2207 10483136.25538677
Rt7124 T1069 T1070 4629415.1778417556
Rt7125 T1069 T1079 4872795.0443410147
Rt7126 T1069 T2131 4623349.1440580878
Rt7127 T1069 T2311 8259140.6316293059
Rt7128 T1070 T1079 4723297.5191866877
Rt7129 T1070 T1080 9102293.6141701583
Rt7130 T1070 T1081 4493798.2050912045
Rt7131 T1070 T2119 10473532.723082114
Rt7132 T1071 T2135 4017979.44201092
Rt7133 T1071 T2138 3890175.6856300398
Rt7134 T1071 T2718 2543249.8611811111
Rt7135 T1071 T3216 3524274.5975381266
Gcorr2842 T1071 T3660 T1071 T3660 -1.4583980703627549e-07
Rt7136 T1071 T3861 7912879.8747950783
Rt7137 T1071 T4051 4891583.9505568035
Gcorr2843 T1071 T4171 T1071 T4171 -9.9517608341336727e-08
Rt7138 T1072 T1073 1970586.1225594538
Rt7139 T1072 T1233 5048230.2941563735
Rt7140 T1072 T1234 6196107.6940768007
Rt7141 T1072 T2636 1537069.5194169106
Gcorr2844 T1072 T2783 T1072 T2783 -2.4267906312668483e-07
Gcorr2845 T1072 T4009 T1072 T4009 -3.5379755290494419e-07
Rt7142 T1073 T1300 3673901.5918193716
Rt7143 T1073 T1301 4420043.2454191074
Gcorr2846 T1073 T2026 T1073 T2026 -3.5529372731968279e-08
Rt7144 T1073 T2367 3907665.2461368856
Rt7145 T1073 T2636 10357103.956535807
Rt7146 T1073 T3587 58414287.797775909
Rt7147 T1073 T4009 2315986.0504254103
Rt7148 T1074 T1553 10100806.543397026
Rt7149 T1074 T1554 4314310.8006467847
Rt7150 T1074 T1555 4086056.4328792845
Rt7151 T1074 T2140 10317305.589864567
Gcorr2847 T1074 T3407 T1074 T3407 -1.2182971814519564e-07
Rt7152 T1074 T3647 2539335.8002100787
Rt7153 T1075 T2085 24974944.720344871
Rt7154 T1075 T2187 1824480.4674193154
Rt7155 T1075 T2588 6756337.9455284234
Rt7156 T1075 T2691 2923285.4231198085
Rt7157 T1076 T2165 11090723.047143789
Rt7158 T1076 T2211 5236364.9587858543
Rt7159 T1076 T2348 6002519.199997359
Rt7160 T1076 T2655 5416433.7820102349
Rt7161 T1076 T2929 18335581.861027513
Rt7162 T1077 T1078 5071557.5253549982
Rt7163 T1077 T1249 3190461.573645296
Rt7164 T1077 T1299 9428053.0997492783
Rt7165 T1077 T2160 2641357.4900103593
Rt7166 T1078 T1249 10273827.678257426
Rt7167 T1078 T1373 1642361.0756597917
Rt7168 T1078 T1374 9793148.884304842
Rt7169 T1078 T2142 3508135.869235625
Rt7170 T1079 T1080 2772234.9306560759
Rt7171 T1079 T1294 10068733.867073867
Rt7172 T1079 T1295 10374028.922482178
Rt7173 T1079 T2311 2698278.2567360979
Rt7174 T1080 T1081 2788598.8977627903
Rt7175 T1080 T1082 4492697.0442157313
Rt7176 T1080 T1294 1702708.7487228098
Rt7177 T1080 T2113 4587763.2984357588
Rt7178 T1081 T1082 9903085.5460283235
Rt7179 T1081 T1083 2765909.3665763382
Rt7180 T1081 T1534 4630337.7140061595
Rt7181 T1081 T2119 4712195.7944855532
Rt7182 T1082 T1083 4546667.9419611767
Rt7183 T1082 T1084 10626041.765580304
Rt7184 T1082 T1085 1646686.3015989757
Rt7185 T1082 T2113 10676660.372642038
Rt7186 T1083 T1084 3758812.0953487195
Rt7187 T1083 T1534 2683319.3474559085
Rt7188 T1083 T2022 3760217.8239473854
Rt7189 T1083 T2244 2617773.326115164
Rt7190 T1084 T1085 1685142.487810543
Rt7191 T1084 T1086 10603098.380774103
Rt7192 T1084 T1087 3719812.483833164
Gcorr2848 T1084 T2022 T1084 T2022 -1.0157641712875345e-08
Rt7193 T1084 T2700 127926652.44842148
Rt7194 T1085 T1086 1794146.396834282
Rt7195 T1085 T2111 1721802.4299412807
Rt7196 T1085 T2112 1719378.6498314037
Rt7197 T1085 T2113 1718631.0433619309
Rt7198 T1086 T1087 4418620.6632285435
Rt7199 T1086 T1088 10516033.943368288
Rt7200 T1086 T1089 4560156.7518913429
Rt7201 T1086 T2111 10547701.608741235
Rt7202 T1087 T1088 1770134.1098744445
Rt7203 T1087 T2039 14671510.771407774
Rt7204 T1087 T2700 2069571.2313289477
Rt7205 T1087 T2716 1815108.1572196633
Rt7206 T1088 T1089 4401701.5960965445
Rt7207 T1088 T1090 10193014.57105208
Rt7208 T1088 T1091 6372323.6941439314
Rt7209 T1088 T2716 4415704.3469716646
Rt7210 T1089 T1090 2939497.0997118875
Rt7211 T1089 T1285 9049949.886892397
Rt7212 T1089 T1286 2970562.4239243208
Rt7213 T1089 T2111 4410226.1844347026
Rt7214 T1090 T1091 1714727.1638112494
Rt7215 T1090 T1092 10102931.296390545
Rt7216 T1090 T1285 4685726.0540715475
Rt7217 T1090 T2162 4706794.5485342955
Rt7218 T1091 T1092 2960387.6500717043
Rt7219 T1091 T1093 9478877.6767693963
Rt7220 T1091 T2110 2822151.4011158654
Rt7221 T1091 T2716 2502351.3019265495
Rt7222 T1092 T1093 4698006.9297844553
Rt7223 T1092 T1094 4747805.7536984924
Rt7224 T1092 T1104 2758161.6466940064
Rt7225 T1092 T2162 10113439.25579913
Rt7226 T1093 T1094 4711026.0619406924
Rt7227 T1093 T1095 2961726.5748413717
Rt7228 T1093 T1096 10261442.552869484
Rt7229 T1093 T2110 4507558.7653235514
Rt7230 T1094 T1095 9153146.8503026664
Rt7231 T1094 T1097 4794047.9020742485
Rt7232 T1094 T1104 9307217.360491002
Rt7233 T1094 T2309 4344952.800296085
Rt7234 T1095 T1096 5325088.7176418332
Rt7235 T1095 T1097 2767465.5162786199
Rt7236 T1095 T1098 4645206.9104808429
Rt7237 T1095 T2627 2918578.8907863884
Rt7238 T1095 T3628 44183587.895297371
Rt7239 T1095 T3650 15485038.165645912
Rt7240 T1096 T2042 28950765.101924993
Rt7241 T1096 T2110 4046168.6160526592
Rt7242 T1096 T2536 1506921.1452263049
Rt7243 T1096 T2627 6239750.0309221875
Rt7244 T1096 T2762 3160217.9356403006
Rt7245 T1096 T3628 2328839.6329194703
Gcorr2849 T1096 T3928 T1096 T3928 -4.1965434916388402e-07
Rt7246 T1097 T1098 9875459.4201857913
Rt7247 T1097 T1099 2997678.4403935098
Rt7248 T1097 T2262 4260250.5714069325
Rt7249 T1097 T2309 4340487.1706671724
Rt7250 T1098 T1099 4660267.2046866911
Rt7251 T1098 T1100 13092361.497358765
Rt7252 T1098 T2425 3219630.2068038066
Rt7253 T1098 T2627 11603154.384343863
Rt7254 T1098 T2747 7066436.4269462945
Rt7255 T1098 T3650 4733987.8345232774
Rt7256 T1099 T1100 4670961.0400615027
Rt7257 T1099 T1101 2764971.9921430056
Rt7258 T1099 T1103 9959019.696301382
Rt7259 T1099 T2262 8991581.1484978665
Rt7260 T1099 T2747 9431847.0018479731
Gcorr2850 T1099 T3627 T1099 T3627 -1.8470580613005672e-07
Rt7261 T1100 T1101 9405493.7782267388
Rt7262 T1100 T1102 4795776.8457332216
Rt7263 T1100 T1259 4812868.0505933547
Rt7264 T1100 T2425 2823883.7034490118
Rt7265 T1100 T2747 3544253.5836579832
Gcorr2851 T1100 T3618 T1100 T3618 -1.3683509389560922e-07
Rt7266 T1100 T3627 18365892.567712609
Rt7267 T1100 T3893 4019952.8472851589
Rt7268 T1101 T1102 2969271.0971252783
Rt7269 T1101 T1103 4196194.2861293918
Rt7270 T1101 T1105 4507020.3542798674
Rt7271 T1101 T2031 5437613.6868064441
Rt7272 T1101 T2885 14738443.612830929
Rt7273 T1101 T3627 1321261.2501802621
Gcorr2852 T1101 T3999 T1101 T3999 -1.9201578417291074e-07
Rt7274 T1102 T1105 4725877.3437917028
Rt7275 T1102 T1106 2619134.8523973697
Rt7276 T1102 T1259 4067905.4860430411
Rt7277 T1102 T2346 1579112436.0402281
Rt7278 T1102 T3284 3920401.9934121566
Gcorr2853 T1102 T3501 T1102 T3501 -1.2910171918720243e-07
Gcorr2854 T1102 T3627 T1102 T3627 -2.3588620914675234e-07
Rt7279 T1102 T3893 11306596.208065437
Rt7280 T1102 T3999 1827915.1741100617
Rt7281 T1103 T2031 12101777.426969394
Rt7282 T1103 T2209 2820284.2854658077
Rt7283 T1103 T2262 4401428.935614353
Rt7284 T1103 T2391 5140344.2290670909
Rt7285 T1104 T2038 5173551.9970252095
Rt7286 T1104 T2162 1750390.7915061249
Rt7287 T1104 T2189 4112899.8481031931
Rt7288 T1104 T2309 3110217.1424593464
Rt7289 T1105 T1106 8997449.7638127599
Rt7290 T1105 T1107 3803582.8598536323
Rt7291 T1105 T1973 5148357.0933120763
Rt7292 T1105 T2031 4573054.605968711
Rt7293 T1105 T2885 2978688.4011748168
Rt7294 T1105 T3501 4083552.38424274
Rt7295 T1105 T3516 25928289.643944919
Gcorr2855 T1105 T3870 T1105 T3870 -8.4703556955729714e-08
Gcorr2856 T1105 T3999 T1105 T3999 -3.5351652366847818e-08
Rt7296 T1106 T1107 3623762.0527220736
Rt7297 T1106 T1108 11016453.134671247
Rt7298 T1106 T2346 1790390.3908759882
Rt7299 T1106 T2701 2742478.058704779
Gcorr2857 T1106 T3210 T1106 T3210 -1.3939931839057455e-07
Gcorr2858 T1106 T3284 T1106 T3284 -3.93754581944608e-07
Rt7300 T1106 T3501 982581.29779016192
Rt7301 T1106 T3502 40609732.566219874
Rt7302 T1107 T1108 9118393.8930395227
Rt7303 T1107 T1109 4416010.2413967494
Rt7304 T1107 T1110 4215828.5243717041
Rt7305 T1107 T1973 8872610.7365402989
Gcorr2859 T1107 T3501 T1107 T3501 -1.1830572737796641e-07
Rt7306 T1107 T3502 4394695.1601492483
Rt7307 T1107 T3516 1872397.0405045031
Gcorr2860 T1107 T3524 T1107 T3524 -9.5016425088881723e-08
Rt7308 T1108 T1109 3880438.092318248
Rt7309 T1108 T1111 4071780.0264824098
Rt7310 T1108 T1260 29175811.939771902
Rt7311 T1108 T2701 781939.32583167346
Gcorr2861 T1108 T3210 T1108 T3210 -7.197516195103883e-07
Rt7312 T1108 T3502 847199.60147832241
Rt7313 T1108 T3734 4101082.2304060822
Gcorr2862 T1108 T3779 T1108 T3779 -1.0367928790220753e-07
Rt7314 T1109 T1110 10593738.006977065
Rt7315 T1109 T1111 13425284.759390706
Rt7316 T1109 T1250 2225516.7891697758
Rt7317 T1109 T2327 733129.0873601744
Gcorr2863 T1109 T3197 T1109 T3197 -4.7338383040460402e-07
Gcorr2864 T1109 T3502 T1109 T3502 -9.5708390784217286e-08
Rt7318 T1109 T3524 636377.4792356923
Rt7319 T1109 T3779 3151321.3515826506
Gcorr2865 T1109 T3831 T1109 T3831 -7.2195720453524087e-07
Rt7320 T1110 T1250 5414013.4806312406
Rt7321 T1110 T1251 4719176.692197483
Rt7322 T1110 T1973 4265613.3045156598
Rt7323 T1110 T2188 4993091.0635189107
Rt7324 T1110 T2753 3271815.8509820406
Gcorr2866 T1110 T3516 T1110 T3516 -8.4040722784654783e-08
Rt7325 T1110 T3524 4878630.3630886646
Rt7326 T1110 T3976 4927764.955231905
Gcorr2867 T1110 T4189 T1110 T4189 -9.8559351073572837e-08
Rt7327 T1111 T1260 12462777.677953055
Rt7328 T1111 T1265 5835502.3187765349
Rt7329 T1111 T2327 2370109.7411574698
Rt7330 T1111 T2328 2343310.8650528253
Rt7331 T1111 T2954 70732642.962914541
Rt7332 T1111 T3734 5666609.957532458
Rt7333 T1111 T3779 905539.18804672465
Gcorr2868 T1111 T3831 T1111 T3831 -4.9212951158849152e-07
Rt7334 T1112 T2093 7665542.7435144819
Gcorr2869 T1112 T2192 T1112 T2192 -3.8335477826144209e-07
Gcorr2870 T1112 T2306 T1112 T2306 -2.7153947238660045e-08
Gcorr2871 T1112 T2511 T1112 T2511 -1.3358528385909561e-07
Rt7335 T1112 T2561 5652019.1475409269
Rt7336 T1112 T2923 863574.63726376113
Gcorr2872 T1112 T3576 T1112 T3576 -3.9057130056338231e-08
Rt7337 T1112 T3680 713492.44164037274
Rt7338 T1112 T4031 608829.70572600269
Rt7339 T1113 T2160 10488905.953141438
Rt7340 T1113 T2236 11824893.285953924
Rt7341 T1113 T2562 3070883.8737962986
Rt7342 T1113 T2654 5042281.9916037628
Rt7343 T1114 T1115 3368459.9288453115
Rt7344 T1114 T1278 9644478.7637598142
Rt7345 T1114 T1351 4734186.4567155764
Rt7346 T1114 T2150 9424493.4355790038
Rt7347 T1115 T1116 1668502.5285511306
Rt7348 T1115 T1117 10409300.193781454
Rt7349 T1115 T1278 4685691.3260669112
Rt7350 T1115 T2148 4668544.1934134783
Rt7351 T1115 T3669 8124446.0705380989
Rt7352 T1115 T3672 3417324.6800552406
Rt7353 T1116 T1117 4373407.5564419087
Rt7354 T1116 T1118 1675155.2971050024
Rt7355 T1116 T2182 1761944.8000036518
Rt7356 T1116 T2197 1655888.9506014795
Gcorr2873 T1116 T2833 T1116 T2833 -2.6560967661688414e-07
Gcorr2874 T1116 T3672 T1116 T3672 -1.503401574597153e-07
Rt7357 T1117 T1118 10288857.450369025
Rt7358 T1117 T1243 4415593.8869829206
Rt7359 T1117 T1331 5090496.6181461457
Rt7360 T1117 T2148 3442346.7905964456
Rt7361 T1117 T2833 8411172.3419068083
Rt7362 T1117 T3563 10208077.161491033
Rt7363 T1117 T3672 2396698.3478202843
Gcorr2875 T1117 T4116 T1117 T4116 -1.6818541882988045e-07
Rt7364 T1118 T1243 3083168.9239972821
Rt7365 T1118 T1244 4588639.4008963667
Rt7366 T1118 T1355 4503967.7777292766
Rt7367 T1118 T2197 9920906.3707514443
Rt7368 T1118 T2833 1411704.614699509
Rt7369 T1118 T3558 10085874.681381466
Gcorr2876 T1118 T3559 T1118 T3559 -1.6973092029223484e-07
Rt7370 T1119 T1120 8632972.461609086
Rt7371 T1119 T1121 4617579.2657931605
Rt7372 T1119 T2374 4027711.3278546692
Rt7373 T1119 T2580 11041657.567417976
Rt7374 T1119 T3071 2620598.0276936102
Rt7375 T1119 T3212 11163279.346272733
Rt7376 T1119 T3213 3422160.0174769578
Gcorr2877 T1119 T4188 T1119 T4188 -1.1986416765200093e-07
Rt7377 T1120 T1121 2641134.1945182453
Rt7378 T1120 T1122 1421799.2131069826
Rt7379 T1120 T1487 4811173.0685318476
Rt7380 T1120 T1907 2049606.9368478779
Gcorr2878 T1120 T3211 T1120 T3211 -4.4390881970440389e-07
Rt7381 T1120 T3212 563480.05500852491
Gcorr2879 T1120 T3443 T1120 T3443 -2.0801727366494584e-07
Gcorr2880 T1120 T3719 T1120 T3719 -4.2435514414017234e-07
Gcorr2881 T1120 T3834 T1120 T3834 -4.639380984522401e-08
Rt7382 T1121 T1122 14913021.260723671
Rt7383 T1121 T1123 4011976.2565552727
Rt7384 T1121 T1469 2700874.1005874942
Rt7385 T1121 T2580 8951699.9945087135
Gcorr2882 T1121 T3007 T1121 T3007 -1.5026225245381139e-07
Rt7386 T1121 T3071 2400780.4123661579
Rt7387 T1121 T3211 1707506.1574595387
Gcorr2883 T1121 T3212 T1121 T3212 -1.2531653764690071e-07
Rt7388 T1122 T1123 4937325.8428570433
Rt7389 T1122 T1124 17014936.853422008
Rt7390 T1122 T1487 13164231.067341464
Rt7391 T1122 T1890 3971811.9399021752
Rt7392 T1122 T3211 1995377.3576905245
Gcorr2884 T1122 T3212 T1122 T3212 -4.8406040984527092e-07
Rt7393 T1122 T3443 2106249.6631997293
Rt7394 T1122 T3605 4833239.6745533403
Rt7395 T1123 T1124 4318744.7743457658
Rt7396 T1123 T1125 2871613.3576349579
Rt7397 T1123 T1469 12719779.553377371
Rt7398 T1123 T2519 2087255.2624532217
Rt7399 T1123 T3007 14324587.775529813
Gcorr2885 T1123 T3061 T1123 T3061 -4.9393836568773727e-07
Rt7400 T1123 T3211 4778320.1013287809
Gcorr2886 T1123 T3605 T1123 T3605 -1.70997472504125e-07
Rt7401 T1123 T4048 845243.10553656972
Rt7402 T1124 T1125 4353986.3767762575
Rt7403 T1124 T1126 18246159.561246827
Rt7404 T1124 T1128 5510569.6375933895
Rt7405 T1124 T1890 51187121.861982293
Rt7406 T1124 T2629 3995692.1217234363
Rt7407 T1124 T3231 2355947.4450282543
Rt7408 T1124 T3605 1831835.8388251611
Gcorr2887 T1124 T3875 T1124 T3875 -1.3239630578060953e-07
Gcorr2888 T1124 T4048 T1124 T4048 -4.8298045388513609e-08
Rt7409 T1125 T1126 1355419.6809725724
Rt7410 T1125 T1127 2497740.6187850996
Rt7411 T1125 T1470 9713972.5009865984
Rt7412 T1125 T2519 8653741.9532290138
Rt7413 T1125 T3061 599723.86759692873
Gcorr2889 T1125 T3226 T1125 T3226 -4.3944373667558175e-07
Gcorr2890 T1125 T3231 T1125 T3231 -2.006748726574814e-07
Gcorr2891 T1125 T4048 T1125 T4048 -2.1411987800664994e-07
Rt7414 T1126 T1127 17831036.170115933
Rt7415 T1126 T1128 5209571.5173535096
Rt7416 T1126 T1129 11216099.212241847
Rt7417 T1126 T1886 3886598.9826246751
Gcorr2892 T1126 T3061 T1126 T3061 -4.81175778937103e-07
Rt7418 T1126 T3226 1828661.2120082942
Rt7419 T1126 T3231 2315516.0763413901
Rt7420 T1126 T3626 5128514.0830464112
Rt7421 T1127 T1470 4404196.6088965992
Rt7422 T1127 T1471 28997687.89626836
Rt7423 T1127 T1772 5069823.8124282053
Rt7424 T1127 T1886 60323980.708424523
Rt7425 T1127 T2712 3744038.0600933935
Gcorr2893 T1127 T3061 T1127 T3061 -1.296933824508709e-07
Rt7426 T1127 T3062 1684680.5711155748
Rt7427 T1127 T3226 1700690.6439684676
Gcorr2894 T1127 T3227 T1127 T3227 -1.3802115683942087e-07
Rt7428 T1128 T1129 3005648.8941022092
Rt7429 T1128 T1130 5087252.0036108624
Rt7430 T1128 T1478 16796283.733765472
Rt7431 T1128 T2629 2645228.0867890073
Gcorr2895 T1128 T2760 T1128 T2760 -1.0028176198573569e-07
Rt7432 T1128 T3231 251563276.53843498
Gcorr2896 T1128 T3626 T1128 T3626 -1.6166059151811074e-07
Rt7433 T1128 T3875 7352109.1162024671
Rt7434 T1128 T3932 8949182.6311046313
Rt7435 T1128 T4148 1904864.9844547114
Rt7436 T1129 T1130 4064955.8079531663
Rt7437 T1129 T1131 10658084.211240239
Rt7438 T1129 T1886 4726095.2026836211
Rt7439 T1129 T2202 4250324.0133501403
Gcorr2897 T1129 T2760 T1129 T2760 -7.2711177913986126e-09
Rt7440 T1129 T3626 1939262.8116074603
Rt7441 T1129 T3940 3232183.0320543628
Gcorr2898 T1129 T4023 T1129 T4023 -3.8776851693145066e-08
Gcorr2899 T1129 T4148 T1129 T4148 -2.6359577194898016e-07
Rt7442 T1130 T1131 4854374.6690857019
Rt7443 T1130 T1132 4786171.7792930836
Rt7444 T1130 T1478 5255663.5760637624
Rt7445 T1130 T2259 10592981.003224529
Rt7446 T1130 T2760 2471817.7450330565
Gcorr2900 T1130 T3932 T1130 T3932 -5.903158909515502e-08
Gcorr2901 T1130 T3940 T1130 T3940 -1.3681514557311535e-07
Rt7447 T1131 T1132 4638560.5811791262
Rt7448 T1131 T1133 3950676.6703490536
Rt7449 T1131 T1134 4858975.8720360212
Rt7450 T1131 T2202 3714598.2200209522
Gcorr2902 T1131 T2965 T1131 T2965 -1.4512486998280084e-07
Rt7451 T1131 T3940 2952426.6431592973
Rt7452 T1132 T1133 10495585.301745731
Rt7453 T1132 T1139 4342850.6719871853
Rt7454 T1132 T1140 10687627.646190807
Rt7455 T1132 T2259 3935384.167066935
Rt7456 T1133 T1134 5004295.2840943215
Rt7457 T1133 T1135 4919312.2340777004
Rt7458 T1133 T1139 4494557.4860562719
Rt7459 T1133 T2178 4560840.8514781063
Rt7460 T1134 T1135 4628803.7947504418
Rt7461 T1134 T1136 3364194.5438060225
Rt7462 T1134 T1687 9882511.7717811018
Rt7463 T1134 T2202 2608722.0428088452
Gcorr2903 T1134 T2965 T1134 T2965 -2.234551931892747e-07
Rt7464 T1135 T1136 10064006.288813118
Rt7465 T1135 T1137 4527848.9084978066
Rt7466 T1135 T2145 5336317.8565418981
Rt7467 T1135 T2178 10104452.810639534
Rt7468 T1136 T1137 9827291.9840819873
Rt7469 T1136 T1138 2350921.1991664278
Rt7470 T1136 T1687 4762220.8977960832
Rt7471 T1136 T2147 4803126.2315938873
Rt7472 T1137 T1138 2025811.2015715453
Rt7473 T1137 T1146 4971364.6753221229
Rt7474 T1137 T1240 1976571.8404576771
Rt7475 T1137 T2145 2238489.6657348392
Rt7476 T1138 T1146 5159212.6879404727
Rt7477 T1138 T1147 4620092.0311029376
Rt7478 T1138 T1148 2217836.759235411
Rt7479 T1138 T2147 9046713.6321505681
Rt7480 T1139 T1140 4361985.4737755964
Rt7481 T1139 T1141 5058771.3010368068
Rt7482 T1139 T2149 4062517.9293871964
Rt7483 T1139 T2178 10531633.94680489
Rt7484 T1140 T1141 5612155.6310015917
Rt7485 T1140 T1142 4854346.0619796691
Rt7486 T1140 T2144 4548703.2126205601
Rt7487 T1140 T2259 4160184.1436871081
Rt7488 T1141 T1142 4954438.8270535255
Rt7489 T1141 T1143 4442101.6818624558
Rt7490 T1141 T1144 2340954.8979674331
Rt7491 T1141 T2149 4924711.7414759584
Gcorr2904 T1141 T2780 T1141 T2780 -3.3858977588815216e-07
Rt7492 T1142 T1143 4697708.7042845227
Rt7493 T1142 T1145 4744495.2800015816
Rt7494 T1142 T1280 4742213.9119790737
Rt7495 T1142 T2144 10603297.033619307
Gcorr2905 T1142 T3858 T1142 T3858 -1.2119930065012259e-07
Rt7496 T1143 T1144 2787682.2277371869
Rt7497 T1143 T1145 10198260.856448794
Rt7498 T1143 T1247 4496671.0595454564
Rt7499 T1143 T2258 4788651.4824251765
Rt7500 T1143 T3339 2252135.3720153598
Rt7501 T1143 T3858 5152976.8017190173
Gcorr2906 T1143 T3995 T1143 T3995 -1.5900339603217234e-07
Rt7502 T1143 T4149 13337698.639906112
Rt7503 T1144 T2149 17021860.952558324
Rt7504 T1144 T2258 11104834.71371853
Rt7505 T1144 T2638 4168815.1248689098
Rt7506 T1144 T2703 3160626.6377080907
Rt7507 T1144 T2780 1479536.6114562934
Gcorr2907 T1144 T3339 T1144 T3339 -1.3966481110439771e-07
Rt7508 T1144 T3995 4107197.3717491534
Gcorr2908 T1144 T4098 T1144 T4098 -6.189998108949037e-08
Rt7509 T1145 T1247 3650796.6825295272
Rt7510 T1145 T1248 4028926.6835554619
Rt7511 T1145 T1280 4017992.2731876322
Rt7512 T1145 T2078 24819850.881116427
Rt7513 T1145 T2781 3146502.8829018143
Gcorr2909 T1145 T3744 T1145 T3744 -1.4478713320692572e-07
Rt7514 T1145 T3858 2466034.7361573507
Rt7515 T1146 T1147 3702525.2980086552
Rt7516 T1146 T1240 10584134.26451518
Rt7517 T1146 T1245 5561141.8281834973
Rt7518 T1146 T2551 6267021.4367365912
Rt7519 T1147 T1148 8898234.9080870058
Rt7520 T1147 T1149 4945616.5843673265
Rt7521 T1147 T2372 4325884.2841261597
Rt7522 T1147 T2551 6225286.9395948388
Rt7523 T1147 T2720 45058165.380444348
Rt7524 T1148 T1149 3146469.6515445877
Rt7525 T1148 T1150 1399292.7122541531
Rt7526 T1148 T1467 4701852.8924300186
Rt7527 T1148 T2147 4710818.5316103743
Rt7528 T1149 T1150 10919743.394064436
Rt7529 T1149 T1151 4482797.9511916628
Rt7530 T1149 T1274 26420059.120831884
Rt7531 T1149 T2720 2915103.5514274985
Rt7532 T1150 T1151 4718071.6745233536
Rt7533 T1150 T1152 10418078.108907659
Rt7534 T1150 T1467 5307794.6370462403
Rt7535 T1150 T2132 4595495.3380078226
Gcorr2910 T1150 T4055 T1150 T4055 -8.5382568211122313e-08
Rt7536 T1151 T1152 3842364.9352544919
Rt7537 T1151 T1153 10439649.430316932
Rt7538 T1151 T1274 4820831.1750324685
Rt7539 T1151 T2130 4500788.637152574
Rt7540 T1152 T1153 4667785.9527022261
Rt7541 T1152 T1154 10709924.287166184
Rt7542 T1152 T1298 3862715.9287649812
Rt7543 T1152 T2132 4596042.5214985479
Gcorr2911 T1152 T2982 T1152 T2982 -8.6319142604700083e-08
Rt7544 T1153 T1154 4325006.405603433
Rt7545 T1153 T1155 10473831.902512399
Rt7546 T1153 T2123 4329352.7619158318
Rt7547 T1153 T2130 4001649.3982288851
Rt7548 T1154 T1155 4612000.0856963489
Rt7549 T1154 T1156 4339169.5685659945
Rt7550 T1154 T1298 4792967.9648572803
Rt7551 T1154 T2124 4257565.4908061344
Gcorr2912 T1154 T2750 T1154 T2750 -1.6595781689933525e-07
Rt7552 T1154 T4005 5717439.3531202786
Rt7553 T1155 T1156 4403836.5902349325
Rt7554 T1155 T1157 4381660.6316865841
Rt7555 T1155 T1173 3184278.6134957313
Rt7556 T1155 T2123 914574.44068847469
Rt7557 T1156 T1157 10198182.686534569
Rt7558 T1156 T1158 4445759.1367606707
Rt7559 T1156 T1159 4699831.6140748356
Rt7560 T1156 T2124 10694363.580912605
Rt7561 T1156 T2750 3722648.6005744641
Gcorr2913 T1156 T3873 T1156 T3873 -9.9829842352590326e-08
Rt7562 T1157 T1158 4574325.0244031558
Rt7563 T1157 T1173 2022500.2579926434
Rt7564 T1157 T1436 3671166.2257300019
Rt7565 T1157 T2118 4275204.0828442955
Rt7566 T1158 T1159 10635243.175756205
Rt7567 T1158 T1160 4290338.275214755
Rt7568 T1158 T1161 4124678.6603126647
Rt7569 T1158 T2118 10072936.99504504
Gcorr2914 T1158 T2959 T1158 T2959 -8.9296360491242809e-08
Rt7570 T1158 T3873 3169368.4947998635
Rt7571 T1159 T1160 4698785.7227129312
Rt7572 T1159 T1279 9829967.7874991558
Rt7573 T1159 T1705 2560958.1762484196
Rt7574 T1159 T2124 4037313.1337262783
Rt7575 T1159 T2750 17511706.711299315
Gcorr2915 T1159 T3503 T1159 T3503 -2.3943052478038148e-07
Rt7576 T1159 T3683 2097181.0203906172
Rt7577 T1159 T3873 5777026.1731131515
Rt7578 T1160 T1161 4394504.5299293967
Rt7579 T1160 T1162 3717514.4259728394
Rt7580 T1160 T1279 4058795.1311997306
Rt7581 T1160 T2268 10152724.368557189
Rt7582 T1160 T2959 2470960.6016037166
Gcorr2916 T1160 T3608 T1160 T3608 -1.3092363305374674e-07
Rt7583 T1160 T3614 3892908.3066261294
Rt7584 T1160 T3683 20687618.748196568
Gcorr2917 T1160 T3873 T1160 T3873 -1.1673994015106674e-07
Rt7585 T1161 T1162 9429643.4991394598
Rt7586 T1161 T1163 3975169.3773127971
Rt7587 T1161 T2118 3978667.3778165639
Rt7588 T1161 T2120 9503526.8979660179
Rt7589 T1161 T2959 10916900.389671139
Rt7590 T1161 T3608 16697923.069739953
Rt7591 T1162 T1163 4178523.3989557177
Rt7592 T1162 T1164 3873143.8886466539
Rt7593 T1162 T1284 9469378.4528968073
Rt7594 T1162 T2268 4071230.3422914888
Gcorr2918 T1162 T2757 T1162 T2757 -1.1848766727891921e-07
Rt7595 T1162 T3608 2121284.4167999872
Gcorr2919 T1162 T3614 T1162 T3614 -9.6687517812356815e-08
Rt7596 T1162 T3684 4854004.5394680081
Rt7597 T1163 T1164 9190140.1365162544
Rt7598 T1163 T1165 591499.28639023309
Rt7599 T1163 T1242 8830365.0880436134
Rt7600 T1163 T2120 3938679.4298134944
Rt7601 T1163 T2757 5098923.8097445769
Rt7602 T1163 T3608 23215636.667417131
Rt7603 T1164 T1165 4337610.2446956132
Rt7604 T1164 T1166 9420522.8931275103
Rt7605 T1164 T1284 8793817.8593890108
Rt7606 T1164 T2227 1845064.0490017692
Rt7607 T1164 T2757 1976145.8142182478
Gcorr2920 T1164 T3432 T1164 T3432 -2.2861096820937664e-07
Rt7608 T1164 T3684 14641917.984925572
Rt7609 T1164 T3808 8581396.023564456
Rt7610 T1165 T1166 4698906.3129255176
Rt7611 T1165 T1167 9328475.5497713704
Rt7612 T1165 T1242 3930489.1910749157
Rt7613 T1165 T2320 999573.62209807138
Gcorr2921 T1165 T2757 T1165 T2757 -1.2127457652935017e-07
Rt7614 T1165 T3808 14464969.386893151
Rt7615 T1166 T1167 3898355.7231963701
Rt7616 T1166 T1168 10133555.522899238
Rt7617 T1166 T1238 5096676.554037991
Rt7618 T1166 T2227 1562766.3255909553
Rt7619 T1166 T2907 4269911.5353800962
Gcorr2922 T1166 T3432 T1166 T3432 -4.7247206683373138e-07
Rt7620 T1166 T3808 1525585.8211136395
Rt7621 T1166 T4185 6122461.7454267675
Rt7622 T1167 T1168 4303011.9546075631
Rt7623 T1167 T1169 4942677.1791198328
Rt7624 T1167 T2320 1189298.4671019169
Rt7625 T1167 T2330 8867534.332573222
Gcorr2923 T1167 T2907 T1167 T2907 -1.3666722795550721e-07
Rt7626 T1168 T1169 10156353.918143464
Rt7627 T1168 T1170 4801390.4897331782
Rt7628 T1168 T1238 4186482.3878454464
Rt7629 T1168 T2414 3928214.0877374406
Rt7630 T1168 T2907 2872661.9708021255
Rt7631 T1168 T3691 6741361.5636475794
Gcorr2924 T1168 T4191 T1168 T4191 -1.3577903423727185e-07
Rt7632 T1169 T1170 3892185.2419725386
Rt7633 T1169 T1171 4698620.4123209557
Rt7634 T1169 T1239 11120211.944390213
Rt7635 T1169 T2330 3621104.9805550082
Rt7636 T1170 T1171 10654935.868303834
Rt7637 T1170 T1172 4566350.0844152058
Rt7638 T1170 T2364 9591357.1467544753
Rt7639 T1170 T2414 4047429.5387755181
Rt7640 T1170 T2736 8322576.6384726698
Rt7641 T1170 T3691 6755260.2768641952
Rt7642 T1171 T1172 3948623.8779666498
Rt7643 T1171 T1174 4836771.2633627746
Rt7644 T1171 T1239 29443143.866228633
Rt7645 T1171 T2711 2580117.1535477303
Rt7646 T1172 T1174 9895742.6415677723
Rt7647 T1172 T1175 1087483.5982300672
Rt7648 T1172 T1176 10910202.563470099
Rt7649 T1172 T2364 4502426.4175856421
Rt7650 T1172 T2736 22249878.706066482
Rt7651 T1172 T4156 2657246.5241946792
Rt7652 T1173 T1436 10621977.797688633
Rt7653 T1173 T1437 4468459.626473791
Rt7654 T1173 T2108 4604651.3381922171
Rt7655 T1173 T2123 9834080.8702798095
Rt7656 T1174 T1175 3911068.426096722
Gcorr2925 T1174 T1923 T1174 T1923 -2.6963409979932029e-08
Rt7657 T1174 T2109 5264517.1814568602
Rt7658 T1174 T2574 2135318.9005640647
Rt7659 T1174 T2711 2213467.2358625685
Rt7660 T1175 T1176 2931115.7113826652
Rt7661 T1175 T1177 9443889.0523342472
Rt7662 T1175 T1178 4606512.1147072194
Rt7663 T1175 T2109 1183635.2090991342
Gcorr2926 T1175 T3507 T1175 T3507 -1.296606930703092e-07
Rt7664 T1175 T4067 4000663.53844315
Gcorr2927 T1175 T4156 T1175 T4156 -1.4649035473503261e-07
Rt7665 T1176 T1177 2311802.8381630648
Rt7666 T1176 T2082 15755469.985422838
Rt7667 T1176 T2180 3503650.0790198995
Rt7668 T1176 T2364 2281199.0803137352
Rt7669 T1176 T3422 4575280.9939214932
Rt7670 T1176 T3507 1151165.7552502207
Gcorr2928 T1176 T4067 T1176 T4067 -5.3438811607061142e-07
Rt7671 T1176 T4156 4325086.2847134033
Gcorr2929 T1176 T4163 T1176 T4163 -2.9504424192146931e-07
Rt7672 T1177 T1178 600265.03318797145
Rt7673 T1177 T1179 10307433.270886973
Rt7674 T1177 T1180 2694268.2357348106
Rt7675 T1177 T2180 3692959.0331277652
Rt7676 T1177 T2787 3380641.9118039799
Gcorr2930 T1177 T3423 T1177 T3423 -7.9638046714164215e-09
Gcorr2931 T1177 T3507 T1177 T3507 -3.1633744550658905e-07
Gcorr2932 T1177 T3983 T1177 T3983 -1.434292508384531e-07
Rt7677 T1177 T4067 385652.44660070119
Rt7678 T1178 T1179 4454087.8356373738
Rt7679 T1178 T2109 1167978.7964986218
Rt7680 T1178 T2166 4714472.0249960562
Rt7681 T1178 T2201 9612984.7559843138
Gcorr2933 T1178 T2787 T1178 T2787 -1.2014439134462706e-07
Gcorr2934 T1178 T4067 T1178 T4067 -1.940944932556448e-06
Rt7682 T1179 T1180 2309385.8910938022
Rt7683 T1179 T1181 2044921.9599945773
Rt7684 T1179 T1182 10669149.189932577
Rt7685 T1179 T2166 4037269.1149558937
Rt7686 T1179 T2787 1697698.400678786
Gcorr2935 T1179 T3794 T1179 T3794 -3.5292366447773613e-07
Rt7687 T1179 T3845 2225961.7491416936
Gcorr2936 T1179 T3983 T1179 T3983 -1.3404599538251737e-07
Rt7688 T1180 T1181 2696305.3635022221
Rt7689 T1180 T2180 11218770.308507215
Rt7690 T1180 T2281 2521839.9711574763
Rt7691 T1180 T2648 3688781.2269129576
Gcorr2937 T1180 T2787 T1180 T2787 -4.814808330867475e-07
Rt7692 T1180 T3423 236473637.01214334
Gcorr2938 T1180 T3794 T1180 T3794 -4.0859184773620733e-07
Rt7693 T1180 T3983 699988.92055035464
Gcorr2939 T1180 T4147 T1180 T4147 -1.0106120993040666e-07
Rt7694 T1181 T1182 4587763.9491279982
Rt7695 T1181 T1183 4001163.8364154459
Rt7696 T1181 T1184 3175173.4470686372
Rt7697 T1181 T2281 10435728.654245174
Rt7698 T1181 T3704 13650173.425415277
Rt7699 T1181 T3794 966212.49734348746
Gcorr2940 T1181 T3845 T1181 T3845 -4.6883554592443445e-08
Gcorr2941 T1181 T3908 T1181 T3908 -1.1917295859054859e-07
Gcorr2942 T1181 T3983 T1181 T3983 -4.7929177553921771e-07
Rt7700 T1182 T1183 10313172.488385446
Rt7701 T1182 T2086 3811841.3180977255
Rt7702 T1182 T2089 4835777.7358533265
Rt7703 T1182 T2166 4636190.0045881579
Rt7704 T1182 T3704 3323110.3316828688
Rt7705 T1182 T3845 7350133.4515693793
Rt7706 T1183 T1184 9949884.9982159026
Rt7707 T1183 T1185 4778805.4671516623
Rt7708 T1183 T1186 5332867.697373732
Rt7709 T1183 T2086 4768774.8779436033
Rt7710 T1183 T2739 12927045.009434421
Rt7711 T1183 T3704 5953859.2608112376
Rt7712 T1183 T3908 2885947.8320664335
Gcorr2943 T1183 T4158 T1183 T4158 -1.1606708420631081e-07
Rt7713 T1184 T1185 4276110.5962030021
Rt7714 T1184 T1196 9474073.085792169
Rt7715 T1184 T1389 6282291.6268191738
Rt7716 T1184 T2281 4544524.2983582839
Rt7717 T1184 T3400 2438376.3809142979
Gcorr2944 T1184 T3794 T1184 T3794 -3.7241552451656384e-08
Rt7718 T1184 T3908 7127398.0419436712
Gcorr2945 T1184 T4197 T1184 T4197 -7.3157964637090922e-09
Rt7719 T1185 T1186 10645218.841888249
Rt7720 T1185 T1187 4994113.0668596644
Rt7721 T1185 T1196 3810555.8234075243
Rt7722 T1185 T2255 9991421.0330032296
Rt7723 T1185 T3358 3489694.4201411493
Gcorr2946 T1185 T3400 T1185 T3400 -1.0032327100557636e-07
Rt7724 T1185 T3908 14441084.064778831
Rt7725 T1185 T4158 4127110.6140049556
Rt7726 T1186 T1187 5216173.3472746899
Rt7727 T1186 T1188 5525807.0162829356
Rt7728 T1186 T1336 4853141.3758824132
Rt7729 T1186 T2086 4690495.4964072416
Rt7730 T1186 T2739 4541575.2598694973
Rt7731 T1186 T3547 16032156.310805263
Rt7732 T1186 T4145 6693147.9305434087
Rt7733 T1186 T4158 7111375.3681479143
Rt7734 T1187 T1188 4080957.1197755132
Rt7735 T1187 T1189 4184049.0640663859
Rt7736 T1187 T2191 9912552.1442388762
Rt7737 T1187 T2255 3859857.8829679159
Rt7738 T1187 T3358 25082040.307825465
Rt7739 T1187 T3460 4055120.7246608115
Rt7740 T1187 T3547 2544583.1728966748
Gcorr2947 T1187 T3854 T1187 T3854 -1.2711210326054017e-07
Gcorr2948 T1187 T4158 T1187 T4158 -7.7539332500102099e-08
Rt7741 T1188 T1189 10081689.510043526
Rt7742 T1188 T1190 3652842.3763713278
Rt7743 T1188 T1336 5789928.019259138
Rt7744 T1188 T2443 3927665.65649484
Gcorr2949 T1188 T3547 T1188 T3547 -9.9220996817682883e-08
Rt7745 T1188 T3854 1941451.4435389575
Rt7746 T1188 T4145 7575414.8546164604
Rt7747 T1189 T1190 4905032.7230535196
Rt7748 T1189 T1191 4902652.2473453647
Rt7749 T1189 T1306 10312923.239473378
Rt7750 T1189 T2191 4780712.7057192689
Rt7751 T1189 T2795 6466894.3236512458
Rt7752 T1189 T3460 21205250.737615928
Rt7753 T1189 T3854 7909147.4408655977
Rt7754 T1189 T3996 7456366.2445429116
Rt7755 T1190 T1191 4949627.7454025373
Rt7756 T1190 T1192 4926313.7215228565
Rt7757 T1190 T1228 2994670.1061383206
Rt7758 T1190 T2443 6926567.2268884117
Rt7759 T1190 T2795 14071102.249804767
Gcorr2950 T1190 T3854 T1190 T3854 -1.6928379025443811e-07
Rt7760 T1191 T1192 4305346.9163390156
Rt7761 T1191 T1193 9888037.0496979635
Rt7762 T1191 T1306 4492636.7074850909
Rt7763 T1191 T2183 3991447.095613644
Rt7764 T1191 T2795 5055863.9425647678
Gcorr2951 T1191 T3506 T1191 T3506 -6.9660701189234921e-09
Gcorr2952 T1191 T3996 T1191 T3996 -9.0375227560755786e-08
Rt7765 T1191 T4034 2211236.265430775
Rt7766 T1192 T1193 5366004.4615769563
Rt7767 T1192 T1194 5076429.7702156762
Rt7768 T1192 T1228 9862719.8468310833
Rt7769 T1192 T2313 4554832.1717331503
Gcorr2953 T1192 T4034 T1192 T4034 -1.3648995547736921e-07
Rt7770 T1193 T1194 3910165.989295397
Rt7771 T1193 T1195 5366309.8593760021
Rt7772 T1193 T1197 5145281.474629676
Rt7773 T1193 T2183 5516999.0791348554
Rt7774 T1193 T3865 8807395.4648129698
Rt7775 T1193 T4034 19109460.979666516
Rt7776 T1194 T1195 10451751.552456867
Rt7777 T1194 T2275 3019989.4337231386
Rt7778 T1194 T2313 4530346.3572662435
Rt7779 T1194 T2333 4514866.3094431385
Rt7780 T1195 T1197 5270235.2132157534
Rt7781 T1195 T1198 5291089.9786834959
Rt7782 T1195 T1199 3940889.6874041934
Rt7783 T1195 T2275 4733281.3530766228
Rt7784 T1196 T1389 3659592.1289191623
Rt7785 T1196 T1390 6053364.4736810047
Rt7786 T1196 T2255 3271321.0768455756
Rt7787 T1196 T2557 9021064.7577008735
Rt7788 T1196 T3202 2243792.8235384966
Gcorr2954 T1196 T3358 T1196 T3358 -8.1775730222328987e-08
Rt7789 T1196 T3400 3008959.6390646854
Gcorr2955 T1196 T3793 T1196 T3793 -1.1079951993175268e-07
Rt7790 T1197 T1198 5615893.779284413
Rt7791 T1197 T2183 3868402.4251132975
Rt7792 T1197 T2356 4471243.7443627929
Rt7793 T1197 T2415 2870019.5548947272
Rt7794 T1197 T2755 1622415.7824296048
Gcorr2956 T1197 T3836 T1197 T3836 -2.0879028106509151e-07
Gcorr2957 T1197 T3865 T1197 T3865 -1.5649292838044641e-07
Rt7795 T1197 T3869 10618879.226233305
Rt7796 T1198 T1199 10383861.830165874
Rt7797 T1198 T1200 1671832.1783036001
Rt7798 T1198 T1201 9797680.1326065697
Rt7799 T1198 T2356 3382132.7102229195
Gcorr2958 T1198 T3869 T1198 T3869 -1.4072379974998748e-07
Rt7800 T1199 T1200 2110242.1906336043
Rt7801 T1199 T2185 9552912.3220204711
Rt7802 T1199 T2203 4902630.7956888871
Rt7803 T1199 T2275 4620923.7017803481
Rt7804 T1200 T1201 4172128.3456265721
Rt7805 T1200 T1202 4037315.6768036284
Rt7806 T1200 T1203 3962374.8886019709
Rt7807 T1200 T2185 1589308.7305043116
Rt7808 T1201 T1202 10153708.060710207
Rt7809 T1201 T2129 3912639.7959901644
Rt7810 T1201 T2356 4952733.3754184283
Rt7811 T1201 T2430 3302656.0668895487
Rt7812 T1201 T3019 6504380.561256811
Gcorr2959 T1201 T3582 T1201 T3582 -1.5962318138941492e-07
Rt7813 T1202 T1203 3007435.4138542693
Rt7814 T1202 T1204 3376668.1535666836
Rt7815 T1202 T1205 3742994.7702242159
Rt7816 T1202 T2129 4372653.8761111433
Rt7817 T1203 T1204 10635519.835101286
Rt7818 T1203 T1443 4526451.4803495584
Rt7819 T1203 T1444 4172300.7943615899
Rt7820 T1203 T2185 10466087.251560062
Rt7821 T1204 T1205 4046890.1063747508
Rt7822 T1204 T1206 4618108.6723123286
Rt7823 T1204 T1443 3647243.0483482345
Rt7824 T1204 T2126 4312461.811535093
Rt7825 T1205 T1206 10622428.944421081
Rt7826 T1205 T1207 4118532.118299929
Rt7827 T1205 T2121 4014993.2277004407
Rt7828 T1205 T2129 10648710.308761783
Rt7829 T1206 T1207 4022096.6300123688
Rt7830 T1206 T1208 4596975.4184686625
Rt7831 T1206 T1209 4572572.4593865192
Rt7832 T1206 T2126 4863038.0906874537
Rt7833 T1207 T1208 10590350.9814681
Rt7834 T1207 T1230 4110786.8763256301
Rt7835 T1207 T1257 4023728.588877338
Rt7836 T1207 T2121 10622655.109504409
Rt7837 T1208 T1209 10428015.518098524
Rt7838 T1208 T1210 4906353.2840183489
Rt7839 T1208 T1230 3474297.1070440752
Rt7840 T1208 T2436 3582456.9913569773
Rt7841 T1209 T1210 3691028.3049022816
Rt7842 T1209 T1211 4618441.9267873643
Rt7843 T1209 T2126 9445784.8349916097
Rt7844 T1209 T2128 4580386.7279118309
Rt7845 T1210 T1211 10455408.918236814
Rt7846 T1210 T1212 4682047.8980402648
Rt7847 T1210 T2389 8071929.2900871262
Rt7848 T1210 T2436 3732112.3063020175
Rt7849 T1211 T1212 3659431.6754204645
Rt7850 T1211 T1213 4691697.2977298368
Rt7851 T1211 T1215 10649901.975624589
Rt7852 T1211 T2128 3635967.0697234995
Rt7853 T1212 T1213 9135770.0867227968
Rt7854 T1212 T1214 4235055.2673335718
Rt7855 T1212 T1218 9568807.5309379268
Rt7856 T1212 T2389 3707825.6383727468
Rt7857 T1213 T1214 4232284.5042483946
Rt7858 T1213 T1215 4555353.1134898812
Rt7859 T1213 T1216 16275360.998448094
Rt7860 T1213 T2609 2714058.6517459131
Rt7861 T1214 T1216 1364965.8860359711
Rt7862 T1214 T1217 1262648.464244857
Rt7863 T1214 T1218 1354235.9017944362
Rt7864 T1214 T2366 1267412.2391727404
Rt7865 T1215 T2128 5105347.6447123652
Rt7866 T1215 T2596 7202247.5415978655
Rt7867 T1215 T2609 17716321.937819302
Rt7868 T1215 T2688 2673552.8950048699
Rt7869 T1216 T1217 10082798.592944534
Rt7870 T1216 T1219 3716879.7589604664
Rt7871 T1216 T1282 4472957.2724523423
Rt7872 T1216 T2609 3045367.6751820371
Rt7873 T1217 T1219 4485857.1667503826
Rt7874 T1217 T1220 4235972.7576441877
Rt7875 T1217 T1283 3802014.0653251251
Rt7876 T1217 T2366 7881164.2694643829
Rt7877 T1218 T1918 1023387845.4873484
Rt7878 T1218 T2321 2025188.0675193463
Rt7879 T1218 T2366 6811414.1951080989
Rt7880 T1218 T2389 3639548.4684419474
Rt7881 T1219 T1220 10600325.97449963
Rt7882 T1219 T1221 4319073.8823487461
Rt7883 T1219 T1282 12392349.313810216
Rt7884 T1219 T2610 2951134.6684965286
Rt7885 T1220 T1221 4426834.8973624427
Rt7886 T1220 T1222 12816886.265734026
Rt7887 T1220 T1283 11471738.143415676
Rt7888 T1220 T2394 3595289.8772580707
Rt7889 T1221 T1222 4561678.4117053105
Rt7890 T1221 T1223 10693003.289994884
Rt7891 T1221 T2544 4370469.4110472938
Rt7892 T1221 T2610 5375724.55734728
Rt7893 T1222 T1223 3668721.8848004038
Rt7894 T1222 T1224 12766599.961870635
Rt7895 T1222 T2394 3211930.9405878158
Rt7896 T1222 T2407 3795850.781827651
Rt7897 T1223 T1224 4450045.2512810845
Rt7898 T1223 T1225 10195253.932469778
Rt7899 T1223 T1231 4193385.2160994508
Rt7900 T1223 T2544 3142913.524520732
Gcorr2960 T1223 T2772 T1223 T2772 -1.3090556771341838e-07
Rt7901 T1224 T1225 3704318.4835514524
Rt7902 T1224 T1226 10808537.709232362
Rt7903 T1224 T1227 4588116.8955732686
Rt7904 T1224 T2407 3109514.9172783303
Rt7905 T1225 T1226 4246284.4905964285
Rt7906 T1225 T1229 4519209.3606223809
Rt7907 T1225 T1231 1258738.0609261591
Rt7908 T1225 T2117 10294242.720732499
Gcorr2961 T1225 T2772 T1225 T2772 -6.3231764419051594e-07
Rt7909 T1225 T3653 3774820.3701772341
Rt7910 T1226 T1227 4350155.7148552947
Rt7911 T1226 T1229 10749932.694805874
Rt7912 T1226 T1232 4244271.8744920371
Rt7913 T1226 T2107 10671922.982168106
Rt7914 T1227 T2090 4408247.0250276849
Rt7915 T1227 T2107 3575230.4811804257
Rt7916 T1227 T2407 11826273.340399198
Rt7917 T1227 T2479 6288452.4193511419
Rt7918 T1228 T2080 5045289.1092463918
Rt7919 T1228 T2313 1688143.0125715144
Rt7920 T1228 T2371 3722984.0229746471
Rt7921 T1228 T2443 5542369.144581317
Rt7922 T1229 T1232 3722502.6991521143
Rt7923 T1229 T1252 3944761.5556316175
Rt7924 T1229 T1290 10018637.286115512
Rt7925 T1229 T2117 4283228.7426093183
Rt7926 T1229 T3548 4161658.0817337958
Gcorr2962 T1229 T3653 T1229 T3653 -6.7044178737803216e-08
Rt7927 T1230 T1257 10564659.238018734
Rt7928 T1230 T1258 4112417.5052685095
Gcorr2963 T1230 T1957 T1230 T1957 -1.9012818192979405e-09
Rt7929 T1230 T2436 9547572.869580403
Rt7930 T1230 T2650 4483826.7124525523
Gcorr2964 T1230 T3848 T1230 T3848 -1.3715170385064387e-07
Rt7931 T1231 T2066 28837513.862402473
Rt7932 T1231 T2117 3433246.2162967636
Rt7933 T1231 T2544 7585431.0716697564
Rt7934 T1231 T2669 2724749.0233251299
Rt7935 T1231 T2772 910599.21532260254
Gcorr2965 T1231 T3653 T1231 T3653 -1.272432831949681e-07
Rt7936 T1231 T3832 9558967.7953058369
Rt7937 T1232 T1252 9830176.0002481341
Rt7938 T1232 T1253 1271895.5628492448
Rt7939 T1232 T1344 9990474.7485018373
Rt7940 T1232 T2107 4525108.2536570644
Rt7941 T1233 T1234 10667181.731437933
Rt7942 T1233 T1235 4403516.3905389709
Rt7943 T1233 T1517 466011.47137036914
Rt7944 T1233 T2158 2185923.701885696
Rt7945 T1234 T1235 1047286.0187833771
Rt7946 T1234 T1236 11810450.919675549
Rt7947 T1234 T2343 4381423.2544864081
Rt7948 T1234 T2636 5518639.6018183986
Rt7949 T1234 T2783 8891481.9345292877
Rt7950 T1234 T3340 3673361.4895591005
Rt7951 T1235 T1236 4624533.2681182791
Rt7952 T1235 T1237 10690789.753635148
Rt7953 T1235 T1517 4845319.8942421591
Rt7954 T1235 T2097 4012976.0806296435
Gcorr2966 T1235 T3340 T1235 T3340 -1.1288389485451284e-07
Rt7955 T1235 T3812 3314859.8824441922
Rt7956 T1236 T1237 3964640.3207117203
Rt7957 T1236 T1275 4064848.5640295157
Rt7958 T1236 T1276 5394540.845568086
Rt7959 T1236 T2343 4149613.5874461858
Rt7960 T1236 T3294 6589889.6444333009
Rt7961 T1236 T3340 3469323.8226237861
Rt7962 T1236 T3812 8187107.283917116
Gcorr2967 T1236 T3850 T1236 T3850 -1.313909883974494e-07
Rt7963 T1236 T3947 36677734.693272404
Rt7964 T1237 T1275 10125413.254367195
Rt7965 T1237 T1277 5418273.1385636013
Rt7966 T1237 T1337 5400002.0340813175
Rt7967 T1237 T2097 4409895.9732483495
Rt7968 T1237 T2784 11738771.19160991
Rt7969 T1237 T3812 6936995.1018115897
Rt7970 T1237 T3850 3206690.8363863137
Gcorr2968 T1237 T4178 T1237 T4178 -6.8478765665135952e-08
Rt7971 T1238 T2027 35570421.266410328
Rt7972 T1238 T2227 2986872.9141857703
Rt7973 T1238 T2387 3298263.7303244947
Rt7974 T1238 T2414 2680425.2592871971
Gcorr2969 T1238 T2907 T1238 T2907 -8.265040429342718e-08
Gcorr2970 T1238 T3432 T1238 T3432 -2.8282661902415374e-07
Rt7975 T1238 T3537 1915706.6223058559
Rt7976 T1238 T4185 1885220.6054769389
Gcorr2971 T1238 T4191 T1238 T4191 -1.8142961117785852e-07
Rt7977 T1239 T2330 4064822.1746261888
Rt7978 T1239 T2379 3710456.8974669641
Rt7979 T1239 T2522 7589054.0812878273
Rt7980 T1239 T2711 2514186.4120654445
Rt7981 T1240 T1245 2027741.9044715241
Rt7982 T1240 T1246 10312194.579000203
Rt7983 T1240 T2145 10557745.690861413
Rt7984 T1240 T2170 4682718.3341551218
Rt7985 T1240 T3237 3696899.322169235
Gcorr2972 T1240 T3724 T1240 T3724 -3.4990596380086505e-07
Rt7986 T1241 T1958 104795324.0620874
Rt7987 T1241 T2138 3634843.3690631688
Rt7988 T1241 T2139 33352149.305951022
Rt7989 T1241 T2308 13918005.192590414
Rt7990 T1241 T2689 1495410.6942907509
Rt7991 T1241 T2785 2281439.0318829082
Gcorr2973 T1241 T3660 T1241 T3660 -6.9004196337195501e-08
Rt7992 T1242 T2120 4235801.0816233223
Rt7993 T1242 T2217 1548972.0981731613
Rt7994 T1242 T2237 2838313.6707693227
Rt7995 T1242 T2320 4150707.0917996285
Rt7996 T1243 T1244 10445747.374164315
Rt7997 T1243 T1331 9980292.5143363588
Rt7998 T1243 T1332 4184885.5042509134
Rt7999 T1243 T2433 9105459.2534427177
Gcorr2974 T1243 T2833 T1243 T2833 -1.2898640313804874e-07
Rt8000 T1243 T3559 2097976.2208023164
Rt8001 T1243 T3563 7338415.5606181743
Rt8002 T1244 T1355 4695667.4176848782
Rt8003 T1244 T1529 3696300.3231081394
Rt8004 T1244 T1895 10128110.537622456
Rt8005 T1244 T2433 4001021.3105212566
Gcorr2975 T1244 T2791 T1244 T2791 -1.3972961371654865e-07
Rt8006 T1244 T3558 4542477.8089346001
Rt8007 T1244 T3559 11775217.69990015
Rt8008 T1244 T3852 3268667.8308968525
Rt8009 T1245 T1246 2676271.8861646317
Rt8010 T1245 T1271 11649469.776484588
Rt8011 T1245 T2551 3436711.4814734748
Rt8012 T1245 T2637 2818053.1727458024
Gcorr2976 T1245 T2797 T1245 T2797 -8.4294698538916988e-08
Gcorr2977 T1245 T3237 T1245 T3237 -4.3016365835883727e-07
Rt8013 T1245 T3724 941385.97627758072
Rt8014 T1246 T1271 4097404.7349734763
Rt8015 T1246 T1272 4636228.3649590686
Rt8016 T1246 T1491 12597993.808908371
Rt8017 T1246 T2170 4288181.1893306822
Rt8018 T1246 T3237 1950165.9949128935
Rt8019 T1246 T3238 14849577.854229765
Rt8020 T1246 T3239 7979589.4864024483
Gcorr2978 T1246 T3724 T1246 T3724 -2.1871245198371386e-07
Rt8021 T1247 T1248 9384518.7297526449
Rt8022 T1247 T1353 2014553.8062013998
Rt8023 T1247 T1384 4392709.4878385849
Rt8024 T1247 T2258 4017568.6633690656
Gcorr2979 T1247 T3328 T1247 T3328 -1.3217702258753554e-07
Gcorr2980 T1247 T3329 T1247 T3329 -2.2713800645442539e-07
Rt8025 T1247 T3744 1366033.4416198779
Gcorr2981 T1247 T3858 T1247 T3858 -1.8716705359341024e-07
Rt8026 T1247 T4149 3146447.2356409305
Rt8027 T1248 T1353 1308561.8826275989
Rt8028 T1248 T1354 9626456.0394593049
Rt8029 T1248 T1660 4339808.5394916236
Rt8030 T1248 T2078 5628488.0718254149
Rt8031 T1248 T2781 12993752.623017399
Gcorr2982 T1248 T3329 T1248 T3329 -5.444799038929221e-07
Gcorr2983 T1248 T3713 T1248 T3713 -1.3586789090638442e-07
Rt8032 T1248 T3714 1078002.2579349279
Rt8033 T1248 T3744 4058414.6195035651
Rt8034 T1249 T1299 4528525.4111907547
Rt8035 T1249 T1324 4625250.8537453339
Rt8036 T1249 T1373 1635119.545915433
Rt8037 T1249 T2195 10425481.867146213
Rt8038 T1249 T2789 3676943.9067213442
Rt8039 T1249 T3560 8892381.4157208167
Rt8040 T1250 T1251 4564190.7697670059
Rt8041 T1250 T1310 3802247.1016689688
Rt8042 T1250 T1330 8550888.1081910655
Rt8043 T1250 T2327 8848656.5306951087
Rt8044 T1250 T3197 1323785.1836204825
Gcorr2984 T1250 T3524 T1250 T3524 -2.7125136204994849e-07
Gcorr2985 T1250 T3526 T1250 T3526 -1.2919220739778787e-07
Rt8045 T1250 T3976 5991255.3596223118
Rt8046 T1251 T1310 10517255.99585725
Rt8047 T1251 T1311 3843388.4466128433
Rt8048 T1251 T1312 3426613.7912438791
Rt8049 T1251 T2188 13390258.792827031
Rt8050 T1251 T3526 2683885.6382499672
Gcorr2986 T1251 T3976 T1251 T3976 -9.5481751835013991e-08
Rt8051 T1251 T4189 2650469.5263228244
Rt8052 T1252 T1253 3642446.7523011896
Rt8053 T1252 T1290 2675886.0394298378
Rt8054 T1252 T1326 4408877.0124707771
Rt8055 T1252 T2115 9282789.0599342342
Rt8056 T1252 T2773 1828037.2503129188
Gcorr2987 T1252 T3548 T1252 T3548 -1.9195561032326585e-07
Rt8057 T1253 T1326 1599178.6557535823
Rt8058 T1253 T1327 4232837.3278726777
Rt8059 T1253 T1344 4248152.3624331914
Rt8060 T1253 T2106 4330691.6566824103
Gcorr2988 T1253 T3658 T1253 T3658 -4.7462728515140762e-07
Rt8061 T1254 T2152 4887264.6514985468
Rt8062 T1254 T2354 4392111.499402618
Rt8063 T1254 T2355 4144225.4114484508
Rt8064 T1254 T2437 10845848.30393531
Rt8065 T1255 T1256 10598331.201785708
Rt8066 T1255 T1345 4645305.5910234265
Rt8067 T1255 T1347 10206911.027299266
Rt8068 T1255 T2100 4392539.4280414656
Rt8069 T1255 T2748 2961736.7985107261
Rt8070 T1255 T3632 9255121.6896734759
Rt8071 T1256 T1345 4427636.6933930032
Rt8072 T1256 T1346 9356353.7023217455
Rt8073 T1256 T1348 4754067.9208704047
Rt8074 T1256 T2058 12602675.72944227
Rt8075 T1256 T2748 2382332.229450264
Rt8076 T1256 T3634 11737346.53691164
Rt8077 T1256 T3648 2682645.759344006
Rt8078 T1257 T1258 4129167.6971394857
Rt8079 T1257 T1341 4043416.3120439379
Rt8080 T1257 T2121 4119313.6715112468
Rt8081 T1257 T2122 10642649.038088275
Rt8082 T1257 T2752 3319428.8658786439
Gcorr2989 T1257 T2966 T1257 T2966 -7.0474726212715569e-08
Rt8083 T1258 T1341 10546820.756840602
Rt8084 T1258 T1342 3976797.9276327719
Rt8085 T1258 T1343 5309627.2153405016
Rt8086 T1258 T2650 5156101.8997906931
Rt8087 T1258 T2966 3764365.7672749222
Gcorr2990 T1258 T3720 T1258 T3720 -9.0426511291033711e-08
Rt8088 T1258 T3848 2607598.8958534026
Rt8089 T1259 T2345 44467354.460840203
Rt8090 T1259 T2346 4685821.1199422712
Rt8091 T1259 T2425 14795859.908453824
Rt8092 T1259 T2672 3267087.0844921288
Rt8093 T1259 T3284 6039313.5724894311
Rt8094 T1259 T3618 5809589.0811428074
Gcorr2991 T1259 T3893 T1259 T3893 -2.630350308595588e-08
Rt8095 T1259 T4035 4568303.5970843099
Rt8096 T1260 T1265 3525655.5923693385
Rt8097 T1260 T1401 5808987.0440653935
Rt8098 T1260 T2224 210679102.50015953
Rt8099 T1260 T2701 1267309.5834024765
Rt8100 T1260 T3209 2150292.1565641752
Gcorr2992 T1260 T3210 T1260 T3210 -3.7502907599483371e-07
Rt8101 T1260 T3734 1037688.2831226089
Gcorr2993 T1260 T3735 T1260 T3735 -3.0537412144842617e-08
Rt8102 T1261 T1472 4215556.5247647464
Rt8103 T1261 T1762 10015463.793729044
Rt8104 T1261 T1974 4228295.7679122388
Rt8105 T1261 T2083 22051781.941454928
Rt8106 T1262 T1263 2895337.9929218423
Rt8107 T1262 T1264 22897762.715558041
Rt8108 T1262 T2299 35539157.313983135
Rt8109 T1262 T2496 2983939.4605486738
Rt8110 T1262 T3077 4364538.7045351118
Rt8111 T1262 T3333 5222517.3372464264
Gcorr2994 T1262 T3469 T1262 T3469 -9.5903387255877929e-08
Rt8112 T1262 T4174 2633713.2939230395
Rt8113 T1263 T1264 568397.50958955172
Rt8114 T1263 T1270 15204730.253046205
Rt8115 T1263 T1809 4809930.2857786277
Rt8116 T1263 T2565 2234104.3748255624
Rt8117 T1263 T3034 3706366.6125830146
Gcorr2995 T1263 T3176 T1263 T3176 -1.4786290007621913e-07
Gcorr2996 T1263 T3333 T1263 T3333 -1.1582207196365233e-06
Rt8118 T1263 T3469 497397.12401971989
Rt8119 T1264 T1270 3785460.5332589997
Rt8120 T1264 T1431 5591150.9009929253
Rt8121 T1264 T2357 901545.61922469048
Rt8122 T1264 T2496 50636480.959030934
Rt8123 T1264 T3034 13907516.515786933
Rt8124 T1264 T3333 610157.18414977903
Gcorr2997 T1264 T3469 T1264 T3469 -1.1539905441725276e-06
Gcorr2998 T1264 T3931 T1264 T3931 -9.2648206154353869e-07
Rt8125 T1264 T4094 679876.8561184823
Rt8126 T1265 T1401 35293259.94345466
Rt8127 T1265 T1402 6915449.1997917034
Rt8128 T1265 T2301 5770759.2302631019
Rt8129 T1265 T2328 3696885.9900168483
Gcorr2999 T1265 T2953 T1265 T2953 -1.7647095484978272e-07
Rt8130 T1265 T2954 1622936.4413211069
Gcorr3000 T1265 T3734 T1265 T3734 -1.4022230303135622e-07
Rt8131 T1265 T3735 1486267.5638579612
Rt8132 T1265 T4181 3026168.575599282
Rt8133 T1266 T1910 6625476.6075958181
Rt8134 T1266 T1912 4404147.7173729567
Rt8135 T1266 T2260 4853167.1732683256
Rt8136 T1266 T2267 4227927.5895823892
Rt8137 T1266 T2751 9531434.2123929691
Rt8138 T1266 T3913 2934508.7831075457
Rt8139 T1267 T1268 3166632.364810959
Rt8140 T1267 T1269 17687571.092245106
Rt8141 T1267 T2071 6532037.6704669604
Rt8142 T1267 T2352 7039570.5571234562
Rt8143 T1267 T3067 3601582.5848931139
Rt8144 T1267 T3117 3573979.1221809671
Rt8145 T1267 T3190 6155653.0399243711
Rt8146 T1268 T1269 2600493.8534840895
Rt8147 T1268 T1395 51929007.621372804
Rt8148 T1268 T2368 2731423.2775430051
Rt8149 T1268 T2641 3058336.1710633961
Gcorr3001 T1268 T3067 T1268 T3067 -1.7085211524932007e-07
Rt8150 T1268 T3088 1689761.9378301648
Rt8151 T1268 T3117 2625347.0959853106
Gcorr3002 T1268 T3118 T1268 T3118 -8.3604185430084746e-08
Rt8152 T1269 T1395 4084588.5212346623
Rt8153 T1269 T1396 11170399.352897376
Rt8154 T1269 T2071 15406081.786735833
Rt8155 T1269 T2370 5098103.530882474
Rt8156 T1269 T3014 4343766.4489346119
Rt8157 T1269 T3067 1136814.8969843199
Rt8158 T1269 T3088 38660806.886163332
Rt8159 T1270 T1431 3628180.9187702606
Rt8160 T1270 T1433 3612169.9099277691
Rt8161 T1270 T1809 27489395.181643464
Rt8162 T1270 T2714 2289496.8959056577
Gcorr3003 T1270 T2941 T1270 T2941 -8.5375528635235037e-08
Rt8163 T1270 T3034 680762.3433457741
Rt8164 T1270 T3224 152468915.76148662
Rt8165 T1270 T4094 331992855.8500365
Rt8166 T1271 T1272 4084048.3820383893
Rt8167 T1271 T1358 3328972.0329860155
Rt8168 T1271 T1359 29250761.119265296
Rt8169 T1271 T2637 2488469.2185467421
Rt8170 T1271 T3239 4763244.0337863993
Gcorr3004 T1271 T3244 T1271 T3244 -1.4621317821082679e-07
Rt8171 T1271 T3360 2498516.1403889931
Rt8172 T1271 T3724 24483357.350965191
Rt8173 T1272 T1358 9850259.9296376593
Rt8174 T1272 T1383 5936026.1152003966
Rt8175 T1272 T1491 3685227.5548159471
Rt8176 T1272 T2500 10386197.080450147
Gcorr3005 T1272 T3238 T1272 T3238 -1.2812066202349972e-07
Rt8177 T1272 T3239 4717478.0952610644
Rt8178 T1272 T3240 2573640.071814802
Rt8179 T1272 T3244 8555348.974400362
Rt8180 T1273 T1962 4999450.8663431183
Rt8181 T1273 T2421 23574717.89327747
Rt8182 T1273 T2483 2574693.6702982653
Rt8183 T1273 T2497 1628081.7023375852
Gcorr3006 T1273 T3030 T1273 T3030 -2.4974374243609045e-07
Rt8184 T1273 T3032 2026090.1783164027
Rt8185 T1273 T3132 1797050.0227951044
Rt8186 T1273 T3133 5811955.2070575804
Gcorr3007 T1273 T4097 T1273 T4097 -1.029650300275665e-07
Rt8187 T1274 T1993 25056097.345721167
Rt8188 T1274 T2130 4816468.6055016033
Rt8189 T1274 T2351 3568626.7416787641
Rt8190 T1274 T2720 2433472.4930633274
Rt8191 T1275 T1276 9856441.6141454205
Rt8192 T1275 T1277 4634113.8622722933
Rt8193 T1275 T1339 11295435.18186081
Rt8194 T1275 T2488 2403597.2711701393
Gcorr3008 T1275 T3288 T1275 T3288 -1.4965216220333399e-07
Rt8195 T1275 T3294 2106386.6285876692
Rt8196 T1275 T3850 6143932.4757361682
Rt8197 T1276 T1339 3963127.180592706
Rt8198 T1276 T1360 12959286.442101454
Rt8199 T1276 T2025 4857714.0259542884
Rt8200 T1276 T2343 4008142.5510703549
Rt8201 T1276 T3294 6778275.7232507085
Rt8202 T1276 T3299 3255476.3048391743
Gcorr3009 T1276 T3451 T1276 T3451 -9.9466181548769453e-08
Rt8203 T1276 T3947 4765921.9208139973
Rt8204 T1277 T1337 5568296.9546883693
Rt8205 T1277 T1338 9364028.5590159073
Rt8206 T1277 T1379 4133382.0828597159
Rt8207 T1277 T2488 9583722.1688473523
Rt8208 T1277 T3288 3558367.6412939192
Rt8209 T1277 T3492 13248393.486182233
Gcorr3010 T1277 T3850 T1277 T3850 -1.8994003633507921e-08
Rt8210 T1277 T4178 6478419.9369728733
Rt8211 T1278 T1351 4688650.1155019812
Rt8212 T1278 T1352 13121409.970775377
Rt8213 T1278 T2148 4748484.4410669226
Rt8214 T1278 T2542 2765775.3218837152
Rt8215 T1278 T2831 2982035.6128108418
Rt8216 T1278 T3669 5505216.7984640766
Gcorr3011 T1278 T3757 T1278 T3757 -1.4081288024224565e-07
Rt8217 T1279 T1705 1292506.1388574028
Rt8218 T1279 T1969 9585280.3444073461
Rt8219 T1279 T1970 17432014.612637501
Rt8220 T1279 T2268 2966571.0687530795
Rt8221 T1279 T3324 1293599.9947403551
Gcorr3012 T1279 T3503 T1279 T3503 -5.1112283721435567e-07
Gcorr3013 T1279 T3614 T1279 T3614 -1.2468293349715286e-07
Rt8222 T1279 T3683 2711330.6454163892
Rt8223 T1280 T2078 5893135.9872565521
Rt8224 T1280 T2144 4767906.5624701232
Rt8225 T1280 T2336 5042446.8195603704
Rt8226 T1280 T2508 3475796.6901678927
Gcorr3014 T1280 T2781 T1280 T2781 -1.0993066360996408e-07
Rt8227 T1281 T2059 4885455.5071517164
Rt8228 T1281 T2060 10676953.710251318
Rt8229 T1281 T2061 1401464.8123159586
Rt8230 T1281 T2236 10308039.995680679
Gcorr3015 T1282 T1873 T1282 T1873 -1.6056873165988615e-08
Rt8231 T1282 T2088 3601193.2600530107
Rt8232 T1282 T2545 2673621.4858619543
Rt8233 T1282 T2609 18025222.661058851
Rt8234 T1282 T2610 25719132.953721289
Rt8235 T1282 T2771 5748095.1746776579
Rt8236 T1283 T1953 53095934.43944589
Rt8237 T1283 T2366 4156673.9421820948
Rt8238 T1283 T2394 3993558.6161155808
Rt8239 T1283 T2405 2838845.5315924347
Rt8240 T1284 T2227 1196942.3680762763
Rt8241 T1284 T2228 4195150.3763165539
Rt8242 T1284 T2268 10888636.98062196
Rt8243 T1284 T2671 2536306.6526670502
Gcorr3016 T1284 T3165 T1284 T3165 -7.6249566719026627e-08
Gcorr3017 T1284 T3432 T1284 T3432 -5.0716766420230122e-07
Rt8244 T1284 T3684 971180.94462795102
Rt8245 T1285 T1286 4727303.2806162797
Rt8246 T1285 T1287 4718897.4471758027
Rt8247 T1285 T2098 9075918.8705761265
Rt8248 T1285 T2162 4688006.8168092202
Rt8249 T1286 T1287 5266647.4349208046
Rt8250 T1286 T1288 10590028.587896628
Rt8251 T1286 T1696 4865482.9101040298
Rt8252 T1286 T2111 10294484.314870998
Rt8253 T1286 T4172 5388048.7613066388
Rt8254 T1287 T1288 4532159.1052246308
Rt8255 T1287 T1289 4335520.4665272217
Rt8256 T1287 T1291 10033791.263681268
Rt8257 T1287 T2098 2777451.596333669
Rt8258 T1287 T2767 1837540.5415630289
Gcorr3018 T1287 T3594 T1287 T3594 -1.1664218142866059e-07
Rt8259 T1287 T4172 10915010.777056428
Rt8260 T1288 T1289 8897832.2741132267
Rt8261 T1288 T1370 3323379.1860127249
Rt8262 T1288 T1696 3553915.3769655158
Rt8263 T1288 T2283 1484336.9640585787
Gcorr3019 T1288 T3204 T1288 T3204 -5.0183438563946944e-07
Rt8264 T1288 T3594 1007514.1798393507
Gcorr3020 T1288 T3655 T1288 T3655 -1.6106333896391224e-07
Rt8265 T1288 T4172 7538384.9245764017
Rt8266 T1289 T1291 4699716.1098919883
Rt8267 T1289 T1292 4693921.780078304
Rt8268 T1289 T1370 4585886.5293270294
Rt8269 T1289 T2339 4450304.0617851429
Rt8270 T1289 T2767 12776855.347055146
Rt8271 T1289 T3425 3396177.681142373
Rt8272 T1289 T3594 12919259.307434531
Rt8273 T1289 T3747 6857961.0447540861
Gcorr3021 T1289 T4151 T1289 T4151 -1.3368215819615585e-07
Rt8274 T1290 T2115 3952732.2589242156
Rt8275 T1290 T2116 10413234.08524652
Rt8276 T1290 T2117 4060700.5958054755
Rt8277 T1290 T2341 3177779.0774923586
Gcorr3022 T1290 T2773 T1290 T2773 -1.9200895621927828e-07
Gcorr3023 T1290 T3283 T1290 T3283 -1.3156345166246904e-07
Rt8278 T1290 T3435 4088675.9427293069
Rt8279 T1290 T3548 1843435.7030769656
Rt8280 T1291 T1292 4414354.2325233156
Rt8281 T1291 T1293 3041524.8389702565
Rt8282 T1291 T2001 10129346.282153696
Rt8283 T1291 T2098 1704266.104135945
Rt8284 T1291 T2767 3357402.376675359
Rt8285 T1291 T3654 1313861.1387605625
Rt8286 T1291 T3747 12531384.683731269
Gcorr3024 T1291 T4176 T1291 T4176 -2.3993239134868826e-07
Rt8287 T1292 T1293 4678107.9959402168
Rt8288 T1292 T1307 10014822.16743074
Rt8289 T1292 T1382 4569306.7036585193
Rt8290 T1292 T2339 9593174.0459078588
Rt8291 T1292 T3142 3636883.3924110252
Rt8292 T1292 T3747 5879277.3174195597
Rt8293 T1292 T4151 6381386.9149231464
Gcorr3025 T1292 T4176 T1292 T4176 -1.0854823185522226e-07
Rt8294 T1293 T1307 4262963.0198153332
Rt8295 T1293 T1308 12158597.800575115
Rt8296 T1293 T1463 4796827.2266671686
Rt8297 T1293 T2001 2600373.123236136
Gcorr3026 T1293 T3142 T1293 T3142 -3.6675143170774209e-08
Rt8298 T1293 T3619 5910108.3242481146
Gcorr3027 T1293 T3654 T1293 T3654 -4.6270309188267453e-07
Gcorr3028 T1293 T3659 T1293 T3659 -8.4254263706332525e-08
Rt8299 T1293 T4176 1089635.700791256
Rt8300 T1294 T1295 4714183.3648364423
Rt8301 T1294 T1296 4323852.353508167
Rt8302 T1294 T2113 10015766.922186464
Rt8303 T1294 T2114 2927655.8348697471
Gcorr3029 T1294 T3557 T1294 T3557 -1.8624454906569369e-07
Rt8304 T1294 T3675 7283824.2104205145
Rt8305 T1295 T1296 4639326.3028090661
Rt8306 T1295 T1297 2486885.4855252858
Rt8307 T1295 T2020 13118745.911136195
Rt8308 T1295 T2311 4268276.6313509494
Rt8309 T1295 T2765 1925498.3816938328
Rt8310 T1295 T3675 9080874.4938647244
Gcorr3030 T1295 T3872 T1295 T3872 -2.3866401611136885e-07
Rt8311 T1296 T1297 3800942.5103025916
Rt8312 T1296 T1371 9595278.854081152
Rt8313 T1296 T1579 4827871.0676540062
Rt8314 T1296 T2114 10266065.725787047
Rt8315 T1296 T3234 3775456.2184747555
Rt8316 T1296 T3557 7464689.6205220716
Rt8317 T1296 T3675 5344459.2234130399
Gcorr3031 T1296 T3872 T1296 T3872 -1.150214840665346e-07
Rt8318 T1297 T1371 1642821.8862101429
Rt8319 T1297 T1372 3748014.2595301368
Rt8320 T1297 T1434 11570524.736251457
Rt8321 T1297 T2020 5791211.9704056578
Gcorr3032 T1297 T2765 T1297 T2765 -2.5219014112340266e-07
Gcorr3033 T1297 T3234 T1297 T3234 -6.2386460771716216e-07
Rt8322 T1297 T3542 13912228.327318277
Rt8323 T1297 T3872 753835.61404356023
Gcorr3034 T1298 T2065 T1298 T2065 -1.4401300088610271e-08
Rt8324 T1298 T2124 5687832.9892814606
Rt8325 T1298 T2132 17454913.121129323
Rt8326 T1298 T2664 4895409.743876406
Rt8327 T1298 T2695 2281183.9018688952
Rt8328 T1298 T2982 2080455.5093056678
Rt8329 T1298 T3694 14259050.318457112
Gcorr3035 T1298 T3892 T1298 T3892 -4.3574630581702827e-08
Rt8330 T1298 T4005 7982931.4857983626
Rt8331 T1299 T1324 4594563.5056744274
Rt8332 T1299 T1325 2971361.6635220298
Rt8333 T1299 T2160 4746587.385357718
Rt8334 T1299 T2276 10733428.497438578
Rt8335 T1299 T2834 2625089.3228604207
Rt8336 T1299 T3560 6203456.7669276129
Gcorr3036 T1299 T3607 T1299 T3607 -1.5213101373528624e-07
Rt8337 T1300 T1301 10145206.191784887
Rt8338 T1300 T1302 1766009.9847890651
Rt8339 T1300 T1528 10407927.972554313
Rt8340 T1300 T2151 5197641.2098402986
Rt8341 T1301 T1302 1925704.4162231518
Rt8342 T1301 T1303 9461147.3933280986
Rt8343 T1301 T1305 2789923.2531693284
Rt8344 T1301 T2367 3832170.2062428351
Rt8345 T1301 T2782 1289033.9909990665
Gcorr3037 T1301 T3257 T1301 T3257 -2.09103251711351e-07
Rt8346 T1301 T3587 20565418.698992323
Rt8347 T1302 T1303 4583532.7807679242
Rt8348 T1302 T1304 5286203.0714909546
Rt8349 T1302 T1528 1794338.337881177
Rt8350 T1302 T2470 3867678.2102665482
Gcorr3038 T1302 T2782 T1302 T2782 -2.5193166756062773e-07
Rt8351 T1302 T3255 14385842.478890037
Rt8352 T1303 T1304 4642671.2538759792
Rt8353 T1303 T1305 4456333.7224286282
Rt8354 T1303 T1333 10602806.326597771
Rt8355 T1303 T2278 2831310.5352147184
Rt8356 T1303 T2782 12718770.396306809
Rt8357 T1303 T3255 6512527.2950450657
Rt8358 T1303 T3256 2418761.6981651941
Gcorr3039 T1303 T3699 T1303 T3699 -1.8320799319029848e-07
Rt8359 T1304 T2070 9652661.3865395356
Rt8360 T1304 T2278 4500800.8730058717
Rt8361 T1304 T2279 2680514.2286634063
Rt8362 T1304 T2470 3562237.2175185336
Rt8363 T1304 T3255 6552522.45616291
Rt8364 T1304 T3699 304366840.91254085
Rt8365 T1304 T3797 1427473.5376982521
Gcorr3040 T1304 T4002 T1304 T4002 -2.1727943061012323e-07
Rt8366 T1305 T1333 4391332.0587956309
Rt8367 T1305 T1334 1626120.5796487902
Rt8368 T1305 T1655 3343792.1485343063
Rt8369 T1305 T2367 7280034.292365185
Gcorr3041 T1305 T2782 T1305 T2782 -2.0001273318984043e-07
Rt8370 T1305 T3256 11291016.110838657
Rt8371 T1305 T3257 865794.76516220358
Gcorr3042 T1305 T3258 T1305 T3258 -1.3997736023230219e-07
Gcorr3043 T1305 T3259 T1305 T3259 -4.3103896667675405e-07
Rt8372 T1306 T2183 12777158.305050375
Rt8373 T1306 T2191 4967349.6836173981
Rt8374 T1306 T2512 3491903.6983034397
Rt8375 T1306 T2732 3343719.5867999718
Rt8376 T1306 T3141 120801746.77858533
Rt8377 T1306 T3506 6885671.4757316429
Rt8378 T1306 T3996 2720914.729855455
Gcorr3044 T1306 T4078 T1306 T4078 -1.0329980755208275e-07
Rt8379 T1307 T1308 4413524.4772251621
Rt8380 T1307 T1382 1840162.8315679065
Rt8381 T1307 T1397 5680974.2480388815
Rt8382 T1307 T2590 3605146.9770022286
Rt8383 T1307 T3060 8198564.7415732881
Gcorr3045 T1307 T3090 T1307 T3090 -2.8406735713065078e-07
Rt8384 T1307 T3142 1424258.4956313935
Gcorr3046 T1307 T3619 T1307 T3619 -1.2564516532931799e-07
Rt8385 T1307 T4133 7949584.9643321093
Rt8386 T1308 T1397 11295525.075106079
Rt8387 T1308 T1463 11273009.100528615
Rt8388 T1308 T1680 5390542.8780671516
Rt8389 T1308 T2248 3393378.5405533216
Gcorr3047 T1308 T3356 T1308 T3356 -4.1357577473392202e-08
Rt8390 T1308 T3619 2606574.1611370714
Rt8391 T1308 T4133 4705496.1283072671
Gcorr3048 T1309 T2074 T1309 T2074 -3.277535516692447e-08
Rt8392 T1309 T2282 3573684.3668383099
Rt8393 T1309 T2378 2976196.7026763102
Rt8394 T1309 T2622 2459737.272999078
Rt8395 T1309 T3135 72309464.564824477
Gcorr3049 T1309 T3540 T1309 T3540 -1.8168987419291456e-07
Rt8396 T1309 T3749 1869228.9007941613
Rt8397 T1309 T4115 11492417.697616927
Rt8398 T1309 T4142 7024075.6192860901
Rt8399 T1310 T1311 4101129.4690267984
Rt8400 T1310 T1330 3926112.4164868211
Rt8401 T1310 T1356 11789187.198992535
Rt8402 T1310 T2218 3669935.0306148869
Gcorr3050 T1310 T2892 T1310 T2892 -1.011459334625078e-07
Rt8403 T1310 T2901 2223935.3239272824
Gcorr3051 T1310 T3197 T1310 T3197 -1.2110044434891324e-07
Rt8404 T1310 T3526 3865293.6339812377
Rt8405 T1311 T1312 10535520.651602566
Rt8406 T1311 T1313 4558528.9501834475
Rt8407 T1311 T1329 4369409.6950862091
Rt8408 T1311 T2218 9748402.0808353536
Gcorr3052 T1311 T2891 T1311 T2891 -8.0977501245975895e-08
Rt8409 T1311 T2892 2674381.5918166311
Gcorr3053 T1311 T3526 T1311 T3526 -1.1577043351388408e-07
Rt8410 T1312 T1313 4535904.3464162583
Rt8411 T1312 T1314 4860716.6718201516
Rt8412 T1312 T1500 5014711.9947301643
Rt8413 T1312 T2188 6458554.9423857117
Gcorr3054 T1312 T4189 T1312 T4189 -1.2385776026525506e-07
Rt8414 T1313 T1314 10677604.090216644
Rt8415 T1313 T1315 4474734.6307641612
Rt8416 T1313 T1329 10318542.408777537
Rt8417 T1313 T2174 4337170.5037712287
Rt8418 T1313 T2891 2941778.129769661
Gcorr3055 T1313 T3762 T1313 T3762 -5.2060785255928986e-08
Rt8419 T1314 T1315 4513015.8580449531
Rt8420 T1314 T1316 4412837.0154914809
Rt8421 T1314 T1500 4735503.4229383133
Rt8422 T1314 T2161 4590513.4808002273
Rt8423 T1315 T1316 4530662.4158617677
Rt8424 T1315 T1317 4537218.44871228
Rt8425 T1315 T1328 4143754.7514981227
Rt8426 T1315 T2174 4388918.0758744171
Rt8427 T1315 T2824 2912953.1029264047
Rt8428 T1315 T3762 3798150.9131761454
Gcorr3056 T1315 T4061 T1315 T4061 -1.6430766517679144e-07
Rt8429 T1316 T1317 10619783.361073282
Rt8430 T1316 T1318 4900039.109984736
Rt8431 T1316 T2137 4649644.6031940402
Rt8432 T1316 T2161 10177287.595505573
Rt8433 T1317 T1318 4553207.5620426694
Rt8434 T1317 T1319 4831617.5945340861
Rt8435 T1317 T1328 2190582.3750359034
Rt8436 T1317 T2365 2422322.5637988262
Gcorr3057 T1317 T2824 T1317 T2824 -1.1146398612704843e-07
Gcorr3058 T1317 T3220 T1317 T3220 -1.6492044575414355e-07
Gcorr3059 T1317 T3956 T1317 T3956 -4.530653637460107e-07
Rt8437 T1317 T4193 1053631.7885601351
Rt8438 T1318 T1319 10506476.886275362
Rt8439 T1318 T1320 3077545.3530711196
Rt8440 T1318 T1321 4894424.5408932669
Rt8441 T1318 T2137 5310635.0118002053
Gcorr3060 T1318 T2868 T1318 T2868 -1.7125376010982627e-07
Rt8442 T1319 T1320 1790153.270700284
Rt8443 T1319 T2230 11649753.812300427
Rt8444 T1319 T2365 9882068.7141194716
Rt8445 T1319 T2441 3982228.4809306976
Gcorr3061 T1319 T2868 T1319 T2868 -4.229549480460001e-07
Rt8446 T1319 T2869 2574381.5101540079
Rt8447 T1319 T3220 7528257.5749414973
Rt8448 T1320 T1321 2875225.2760930876
Rt8449 T1320 T1322 1486502.4405487508
Rt8450 T1320 T1323 4197502.4028042546
Rt8451 T1320 T2230 4455161.2068833541
Rt8452 T1320 T2868 599604.26066688052
Gcorr3062 T1320 T2869 T1320 T2869 -1.5704306903255841e-07
Rt8453 T1320 T2870 20696180.693846207
Gcorr3063 T1320 T3596 T1320 T3596 -2.5416564883401902e-07
Gcorr3064 T1320 T3755 T1320 T3755 -4.2348296400047591e-07
Rt8454 T1321 T1322 10534593.015997918
Rt8455 T1321 T1387 4721615.0939835114
Rt8456 T1321 T1393 9663955.7136930265
Rt8457 T1321 T2137 4647706.2747009443
Gcorr3065 T1321 T2868 T1321 T2868 -1.8345733008124929e-07
Rt8458 T1321 T3755 2462586.7512972732
Rt8459 T1322 T1323 10023987.514811266
Rt8460 T1322 T1387 4752685.9999001594
Rt8461 T1322 T1388 10994138.062608821
Rt8462 T1322 T2513 4333864.9993322697
Gcorr3066 T1322 T2868 T1322 T2868 -4.7325600515407831e-07
Rt8463 T1322 T3596 1976698.1270921223
Rt8464 T1322 T3755 3000883.4497495811
Rt8465 T1322 T4021 10942602.85092102
Rt8466 T1323 T2223 434532201.79273719
Rt8467 T1323 T2230 10166774.067191757
Rt8468 T1323 T2231 1509693.3958785704
Rt8469 T1323 T2513 3606063.9524650848
Rt8470 T1323 T2870 2211649.6814343985
Gcorr3067 T1323 T2879 T1323 T2879 -4.0825204140875667e-07
Rt8471 T1323 T2900 2637296.4917944092
Rt8472 T1323 T3596 10130188.32058611
Rt8473 T1324 T1325 8205735.3421100592
Rt8474 T1324 T1367 4079474.773664881
Rt8475 T1324 T1473 14458077.351618174
Rt8476 T1324 T2195 3492672.8531860821
Gcorr3068 T1324 T2789 T1324 T2789 -1.2126192495961546e-07
Rt8477 T1324 T3560 6235978.7026829692
Rt8478 T1324 T3561 2522056.6468132036
Rt8479 T1324 T3607 19330163.474857979
Rt8480 T1325 T1367 2579762.9458015161
Rt8481 T1325 T1368 1506463.393632465
Rt8482 T1325 T1400 4592332.0300254859
Rt8483 T1325 T2276 1562477.0725686103
Gcorr3069 T1325 T2834 T1325 T2834 -4.3489649818496728e-07
Gcorr3070 T1325 T3314 T1325 T3314 -2.2249467277141602e-07
Gcorr3071 T1325 T3316 T1325 T3316 -3.9429590575314236e-07
Rt8484 T1325 T3607 587176.55308485287
Gcorr3072 T1325 T3959 T1325 T3959 -1.2292661482578018e-07
Rt8485 T1326 T1327 8705393.1843956131
Rt8486 T1326 T1365 8553337.9623915832
Rt8487 T1326 T1366 3470860.5599676394
Rt8488 T1326 T2115 4312568.1410739953
Rt8489 T1326 T2773 19067647.735802274
Rt8490 T1326 T3658 1010431.04227497
Gcorr3073 T1326 T3696 T1326 T3696 -1.1297266331382484e-07
Rt8491 T1327 T1365 4475237.402419786
Rt8492 T1327 T1404 4350777.3663757285
Rt8493 T1327 T1943 3643530.8247739365
Rt8494 T1327 T2106 8983559.5826611314
Rt8495 T1327 T3656 15988474.389166743
Rt8496 T1327 T3658 27423500.271236412
Rt8497 T1328 T1964 4077480.5605809642
Rt8498 T1328 T2174 10347830.665217616
Rt8499 T1328 T2310 1783139.9916197564
Rt8500 T1328 T2365 7902565.7658427004
Rt8501 T1328 T2824 17327840.125363857
Gcorr3074 T1328 T3219 T1328 T3219 -2.2338042019797944e-07
Rt8502 T1328 T3956 1343192.3179892537
Gcorr3075 T1328 T4013 T1328 T4013 -1.5929957021976379e-07
Rt8503 T1328 T4061 2009960.5952647948
Gcorr3076 T1328 T4193 T1328 T4193 -4.1001450900822448e-07
Rt8504 T1329 T2174 3621947.2597685219
Rt8505 T1329 T2175 3791121.2156526269
Rt8506 T1329 T2176 11754301.758512365
Rt8507 T1329 T2218 3930673.4977032775
Rt8508 T1329 T2891 3751169.0373270712
Gcorr3077 T1329 T2892 T1329 T2892 -1.045703604274425e-07
Rt8509 T1329 T2893 2417976.9204724901
Gcorr3078 T1329 T3565 T1329 T3565 -1.0822819613213902e-07
Rt8510 T1330 T1356 3739320.3645615843
Rt8511 T1330 T1357 12661573.972620709
Rt8512 T1330 T2327 3964305.0386784319
Rt8513 T1330 T2603 3889059.0687086578
Gcorr3079 T1330 T2901 T1330 T2901 -8.0296528388625628e-08
Rt8514 T1330 T2903 1930029.8603112614
Rt8515 T1330 T3197 4758293.085053145
Gcorr3080 T1330 T3831 T1330 T3831 -1.2637524007687683e-07
Rt8516 T1331 T1332 3914015.9808088001
Rt8517 T1331 T1412 5295744.4767297357
Rt8518 T1331 T1990 25098867.617514618
Rt8519 T1331 T2148 3900110.5721180621
Rt8520 T1331 T3309 4110341.9028173024
Rt8521 T1331 T3563 2931099.8575022803
Gcorr3081 T1331 T4116 T1331 T4116 -7.2100603224135725e-08
Rt8522 T1331 T4117 19389900.999673788
Rt8523 T1332 T1412 4582447.981631184
Rt8524 T1332 T1490 13284576.374288337
Rt8525 T1332 T1524 27035851.889814295
Rt8526 T1332 T2433 2038049.6183701972
Rt8527 T1332 T3298 1576857.9859493417
Gcorr3082 T1332 T3559 T1332 T3559 -4.9141705877402701e-09
Gcorr3083 T1332 T3563 T1332 T3563 -1.4806171725327002e-07
Rt8528 T1332 T4117 5364540.4334130287
Rt8529 T1333 T1334 9444370.3675269485
Rt8530 T1333 T1398 4574875.1585645555
Rt8531 T1333 T1413 21931916.102381047
Rt8532 T1333 T2278 1608810.0628703176
Rt8533 T1333 T3256 2640408.7436126284
Rt8534 T1333 T3258 6661324.0242394619
Rt8535 T1333 T3260 2459178.221515601
Gcorr3084 T1333 T3699 T1333 T3699 -4.0954014199822376e-07
Rt8536 T1334 T1398 1658583.3939903716
Rt8537 T1334 T1399 25083774.776482958
Rt8538 T1334 T1655 12908508.518678771
Rt8539 T1334 T2587 4194222.057547743
Gcorr3085 T1334 T3257 T1334 T3257 -4.3724933058749547e-07
Rt8540 T1334 T3258 1470088.0728891604
Rt8541 T1334 T3259 2946245.2920062779
Gcorr3086 T1334 T3261 T1334 T3261 -4.41619524293543e-07
Rt8542 T1334 T3965 2345253.8398893755
Rt8543 T1335 T2376 8465090.3286709618
Rt8544 T1335 T2377 4146036.2639414449
Rt8545 T1335 T2390 3624340.0931580099
Rt8546 T1335 T2681 6881740.4754353249
Rt8547 T1335 T3053 14336676.535939608
Gcorr3087 T1335 T3186 T1335 T3186 -5.6133754561517701e-08
Rt8548 T1335 T3187 1822187.9427244253
Rt8549 T1336 T2086 9527717.7118686456
Rt8550 T1336 T2087 2087255.1925140617
Rt8551 T1336 T2443 5125384.6042686198
Rt8552 T1336 T2548 3263837.6708339043
Gcorr3088 T1336 T4145 T1336 T4145 -5.1085912465706447e-08
Rt8553 T1337 T1338 10094153.42571296
Rt8554 T1337 T1403 4635310.2926348317
Rt8555 T1337 T1683 4348506.4215001175
Rt8556 T1337 T2097 1274028.3769894
Gcorr3089 T1337 T2784 T1337 T2784 -8.4032547765759256e-08
Rt8557 T1337 T3492 18824353.771257196
Rt8558 T1337 T3815 895181.17491605622
Rt8559 T1337 T4178 5649176.8116844585
Rt8560 T1338 T1379 2794217.35812124
Rt8561 T1338 T1380 5629035.9316571075
Rt8562 T1338 T1403 4003609.4718369227
Rt8563 T1338 T2092 10157556.35196266
Gcorr3090 T1338 T3289 T1338 T3289 -1.5030462358016064e-07
Rt8564 T1338 T3492 2171383.9168060478
Rt8565 T1338 T4022 5023992.4312350852
Rt8566 T1339 T1360 2871163.6974225454
Rt8567 T1339 T1476 7886534.999087289
Rt8568 T1339 T2252 120056198.40380706
Rt8569 T1339 T2488 2537087.2374240975
Rt8570 T1339 T3280 1359350.4221772633
Rt8571 T1339 T3294 16330722.46801172
Gcorr3091 T1339 T3299 T1339 T3299 -1.0232935555254018e-07
Rt8572 T1340 T2207 4654581.7588453023
Rt8573 T1340 T2266 4794824.3131006733
Rt8574 T1340 T2297 4184773.258860948
Rt8575 T1340 T2616 13132053.634448348
Gcorr3092 T1340 T2862 T1340 T2862 -1.5526652323378054e-07
Rt8576 T1340 T3595 2288272.8424979569
Rt8577 T1340 T3764 9551611.4272673074
Rt8578 T1340 T3972 4238676.1085656881
Gcorr3093 T1340 T4018 T1340 T4018 -1.283394521596639e-07
Rt8579 T1341 T1342 3978924.7218080638
Rt8580 T1341 T1406 3976799.2635711976
Rt8581 T1341 T1407 13027095.242003586
Rt8582 T1341 T2122 3990192.0896276208
Gcorr3094 T1341 T2752 T1341 T2752 -1.2346488205201422e-07
Rt8583 T1341 T2966 2737346.8933709054
Rt8584 T1341 T2967 3404104.8101136731
Gcorr3095 T1341 T2968 T1341 T2968 -6.0889480300921138e-08
Rt8585 T1342 T1343 10628459.673135297
Rt8586 T1342 T1363 3892287.7745647542
Rt8587 T1342 T1406 11141905.135591213
Rt8588 T1342 T2458 3790342.1211898774
Gcorr3096 T1342 T2966 T1342 T2966 -1.2337413867142626e-07
Rt8589 T1342 T2968 3569893.3387016091
Gcorr3097 T1342 T2976 T1342 T2976 -8.7533468797591062e-08
Rt8590 T1342 T3720 2487254.059953881
Rt8591 T1343 T1363 3313400.9369282634
Rt8592 T1343 T1364 4445313.4636153886
Rt8593 T1343 T2650 2516616.3804884208
Rt8594 T1343 T2722 5011668.3696130449
Rt8595 T1343 T3720 3652214.0337909758
Gcorr3098 T1343 T3848 T1343 T3848 -1.8756352168929596e-07
Rt8596 T1343 T3943 2107369.3198724454
Gcorr3099 T1343 T4102 T1343 T4102 -1.5452188584077331e-07
Rt8597 T1344 T2106 11273600.858590407
Rt8598 T1344 T2107 3708764.0418019718
Rt8599 T1344 T2386 3466321.035180564
Rt8600 T1344 T2535 4712712.0712585263
Rt8601 T1345 T1346 2910292.3109584623
Rt8602 T1345 T1347 5124655.281689073
Rt8603 T1345 T1361 4195591.3393628951
Rt8604 T1345 T2298 9882279.1743940879
Rt8605 T1345 T2748 10724219.495378423
Rt8606 T1345 T3632 22259172.524610568
Rt8607 T1345 T3633 1684425.987508148
Gcorr3100 T1345 T3634 T1345 T3634 -1.8813342410461631e-07
Gcorr3101 T1345 T4159 T1345 T4159 -8.1460022106479178e-08
Rt8608 T1346 T1348 9762199.3301690184
Rt8609 T1346 T1349 2330005.2571096839
Rt8610 T1346 T1376 5397627.923517256
Rt8611 T1346 T2298 4322101.0698915981
Gcorr3102 T1346 T3633 T1346 T3633 -1.6289832481106623e-07
Rt8612 T1346 T3634 1327034.2672528836
Rt8613 T1346 T3635 8905771.8521367889
Gcorr3103 T1346 T3636 T1346 T3636 -2.1462268669201088e-07
Rt8614 T1347 T1361 5191040.8237734232
Rt8615 T1347 T1362 4510551.4816987859
Rt8616 T1347 T2044 5177943.2208638582
Rt8617 T1347 T2100 2958912.874882713
Gcorr3104 T1347 T3058 T1347 T3058 -9.6353030828551911e-08
Rt8618 T1347 T3632 2422014.8111626087
Rt8619 T1347 T3994 3823962.1909446218
Rt8620 T1347 T4159 13460818.445873704
Rt8621 T1348 T1349 1553920.4668448404
Rt8622 T1348 T1350 11460217.440937305
Rt8623 T1348 T1823 3763520.9692912884
Rt8624 T1348 T2058 4446026.8685052693
Rt8625 T1348 T3634 3732020.7695371779
Gcorr3105 T1348 T3636 T1348 T3636 -4.3801749165292635e-07
Rt8626 T1348 T3638 1436287.3473453003
Rt8627 T1348 T3648 9686327.8185448721
Gcorr3106 T1348 T3756 T1348 T3756 -1.3034116095233451e-07
Rt8628 T1349 T1350 4417795.4393703202
Rt8629 T1349 T1376 11201866.86435454
Rt8630 T1349 T1377 5503347.636913605
Rt8631 T1349 T2709 3298184.736663139
Gcorr3107 T1349 T3634 T1349 T3634 -4.4371838357338208e-07
Rt8632 T1349 T3636 813053.8031507344
Gcorr3108 T1349 T3638 T1349 T3638 -1.9711210799195967e-07
Rt8633 T1349 T3640 17927652.767748717
Gcorr3109 T1349 T4153 T1349 T4153 -1.1803564787708344e-07
Rt8634 T1350 T1377 11099120.143686779
Rt8635 T1350 T1378 5274230.1882551266
Rt8636 T1350 T1823 6183824.0461991625
Rt8637 T1350 T2643 4669623.0072286371
Rt8638 T1350 T3638 11278803.137499826
Rt8639 T1350 T3640 4644906.4607572593
Rt8640 T1350 T3877 4796499.4879268995
Rt8641 T1351 T1352 4520810.9012592053
Rt8642 T1351 T1408 3275732.8598438911
Rt8643 T1351 T1466 9242493.8338239063
Rt8644 T1351 T2150 2809939.1940574017
Rt8645 T1351 T2831 13479926.00914974
Gcorr3110 T1351 T3676 T1351 T3676 -1.555977328066665e-07
Rt8646 T1352 T1408 10433689.000027966
Rt8647 T1352 T1409 4110367.9811500572
Rt8648 T1352 T1410 11832287.515656833
Rt8649 T1352 T2542 3783572.8484431054
Rt8650 T1352 T2831 7786169.2194118807
Rt8651 T1352 T3676 8200297.1304005198
Rt8652 T1352 T3914 5089623.737724077
Rt8653 T1353 T1354 3417941.7850955236
Rt8654 T1353 T1384 8003274.5981954606
Rt8655 T1353 T1385 9876704.0873190239
Rt8656 T1353 T2601 5877839.8337719385
Rt8657 T1353 T3329 614541.73122261325
Gcorr3111 T1353 T3714 T1353 T3714 -5.1657262398567886e-07
Gcorr3112 T1353 T3744 T1353 T3744 -5.080035192018235e-07
Rt8658 T1354 T1660 4240871.0591041241
Rt8659 T1354 T1661 9104752.9244241994
Rt8660 T1354 T1662 10758293.082675835
Rt8661 T1354 T2601 2760661.9433672098
Gcorr3113 T1354 T3329 T1354 T3329 -1.5124628803118904e-07
Rt8662 T1354 T3330 1456496.0809871184
Rt8663 T1354 T3714 9460680.7621063683
Rt8664 T1355 T1529 9644143.5943493061
Rt8665 T1355 T1530 4689421.1919662347
Rt8666 T1355 T1692 4029409.8275378137
Rt8667 T1355 T2197 1533726.1031867682
Rt8668 T1355 T2791 15689734.786656417
Rt8669 T1355 T3558 8929671.5485628601
Rt8670 T1356 T1357 4169278.656790121
Rt8671 T1356 T1474 16997292.327671703
Rt8672 T1356 T2218 4019869.1296915021
Rt8673 T1356 T2583 3331217.0783810103
Gcorr3114 T1356 T2894 T1356 T2894 -5.7594182734071791e-08
Rt8674 T1356 T2901 4756732.8644686686
Rt8675 T1356 T2902 1893572.3105888064
Gcorr3115 T1356 T2903 T1356 T2903 -1.3072466969233378e-07
Rt8676 T1357 T1474 3962586.8669426921
Rt8677 T1357 T1475 9969830.3750936352
Rt8678 T1357 T1795 5479479.8177860603
Rt8679 T1357 T2603 654737.84170181386
Gcorr3116 T1357 T2902 T1357 T2902 -6.1143833623232428e-08
Rt8680 T1357 T2903 17065438.301066406
Rt8681 T1357 T2908 568516.67330278887
Gcorr3117 T1357 T2909 T1357 T2909 -1.0383033628122536e-06
Rt8682 T1358 T1359 4675711.493253761
Rt8683 T1358 T1383 13289221.978744604
Rt8684 T1358 T1489 16777104.499823637
Rt8685 T1358 T2678 1230307.5074154111
Rt8686 T1358 T3244 969809.89710162289
Gcorr3118 T1358 T3360 T1358 T3360 -7.4108317901199317e-08
Rt8687 T1358 T3361 3107646.1416233559
Gcorr3119 T1358 T3970 T1358 T3970 -5.7134376654433692e-07
Rt8688 T1359 T1489 3509742.1935009169
Rt8689 T1359 T1511 21189924.417467777
Rt8690 T1359 T1755 6375815.1399636753
Rt8691 T1359 T1994 265257955.31810442
Rt8692 T1359 T2637 4633500.4909401676
Rt8693 T1359 T3360 3265601.9842711664
Gcorr3120 T1359 T3361 T1359 T3361 -2.4328969976966533e-08
Rt8694 T1359 T3362 2210836.9485983709
Rt8695 T1359 T3918 12445534.462047026
Rt8696 T1360 T1476 3751145.9419142399
Rt8697 T1360 T1504 4841327.6535293702
Rt8698 T1360 T1938 76250568.851386681
Rt8699 T1360 T2025 3839871.0390117704
Rt8700 T1360 T3277 13177722.585835326
Gcorr3121 T1360 T3280 T1360 T3280 -1.5665705565504037e-07
Rt8701 T1360 T3299 1690249.3370102169
Rt8702 T1360 T3871 3079648.6920275069
Rt8703 T1361 T1362 10395304.05430923
Rt8704 T1361 T1369 3386303.019671035
Rt8705 T1361 T2298 4362621.211283653
Rt8706 T1361 T2446 4064545.2113590813
Rt8707 T1361 T3058 3606137.5205095881
Gcorr3122 T1361 T3633 T1361 T3633 -1.1930603834107359e-07
Rt8708 T1361 T3639 6604642.59459625
Gcorr3123 T1361 T3729 T1361 T3729 -1.3352722710757046e-07
Rt8709 T1361 T4159 3405009.1127686398
Rt8710 T1362 T1369 4178784.9148900835
Rt8711 T1362 T1430 10995190.936022978
Rt8712 T1362 T1568 4700710.2450885838
Rt8713 T1362 T2044 4845332.7943165107
Rt8714 T1362 T2801 10714524.848987086
Rt8715 T1362 T2803 10889793.762145264
Rt8716 T1362 T3058 2665337.2808728926
Gcorr3124 T1362 T3994 T1362 T3994 -6.7894068673259302e-08
Rt8717 T1363 T1364 10377492.443581028
Rt8718 T1363 T1464 3683175.0509358016
Rt8719 T1363 T1485 5738990.3517280994
Rt8720 T1363 T2458 7879712.9469048362
Rt8721 T1363 T2976 2858732.1510464917
Gcorr3125 T1363 T3029 T1363 T3029 -1.4216568831913603e-07
Gcorr3126 T1363 T3720 T1363 T3720 -1.3552503373865165e-07
Rt8722 T1363 T4102 2037065.6937775197
Rt8723 T1364 T1464 3876564.4704901902
Rt8724 T1364 T1465 10669771.940975061
Rt8725 T1364 T1535 4722289.7271386068
Rt8726 T1364 T1917 48021093.73822739
Rt8727 T1364 T2722 4649780.4156349003
Rt8728 T1364 T3181 16211214.418815145
Rt8729 T1364 T3342 1885063.2631804487
Gcorr3127 T1364 T3943 T1364 T3943 -1.8486789938061596e-07
Rt8730 T1364 T4102 3577669.6336297295
Rt8731 T1365 T1366 3366935.1189720463
Rt8732 T1365 T1404 9897053.9673818555
Rt8733 T1365 T1405 3682858.6250862419
Rt8734 T1365 T2241 4263524.6056904746
Gcorr3128 T1365 T3163 T1365 T3163 -1.2152682360687554e-08
Rt8735 T1365 T3656 2158623.4785240265
Rt8736 T1365 T3658 16999220.942500085
Gcorr3129 T1365 T3697 T1365 T3697 -4.7678946219876693e-08
Rt8737 T1366 T2115 10172715.531760927
Rt8738 T1366 T2241 11129553.339452669
Rt8739 T1366 T2384 1555050.2799926593
Rt8740 T1366 T2724 7249062.3725274
Rt8741 T1366 T3163 1697371.8250726112
Gcorr3130 T1366 T3658 T1366 T3658 -1.3816119110867678e-07
Rt8742 T1366 T3696 2157650.4438004289
Gcorr3131 T1366 T4177 T1366 T4177 -4.7139955978777181e-07
Rt8743 T1367 T1368 10890032.916781694
Rt8744 T1367 T1473 3360883.9116226234
Rt8745 T1367 T1477 3902054.8655446512
Gcorr3132 T1367 T2455 T1367 T2455 -6.5574897782840243e-09
Rt8746 T1367 T3316 1771660.3835002843
Rt8747 T1367 T3318 8414625.545921389
Rt8748 T1367 T3561 6700440.6128372317
Gcorr3133 T1367 T3607 T1367 T3607 -1.5958054310351123e-07
Rt8749 T1368 T1400 8477637.4285211451
Rt8750 T1368 T1477 4391455.7435894962
Rt8751 T1368 T1486 10816021.011205897
Rt8752 T1368 T2035 10713612.987043284
Rt8753 T1368 T3314 2020407.5443086508
Rt8754 T1368 T3315 4972417.3278780989
Rt8755 T1368 T3316 1906383.250460461
Gcorr3134 T1368 T3607 T1368 T3607 -3.9921422404437548e-07
Rt8756 T1369 T1430 4309432.6837831773
Rt8757 T1369 T1432 2096042.6890856964
Rt8758 T1369 T1503 13103318.137303967
Rt8759 T1369 T2446 6759975.9287906652
Rt8760 T1369 T2803 21673439.156906042
Gcorr3135 T1369 T2805 T1369 T2805 -3.1625333401087846e-07
Gcorr3136 T1369 T3058 T1369 T3058 -1.1763625591363116e-07
Rt8761 T1369 T3729 1082968.0130284084
Rt8762 T1370 T2283 15045139.59481593
Rt8763 T1370 T2339 4054902.3478401448
Rt8764 T1370 T2602 8982596.7650083862
Rt8765 T1370 T2686 2980293.2436083611
Rt8766 T1370 T3092 26564128.068080816
Rt8767 T1370 T3204 3033578.0352709661
Rt8768 T1370 T3425 5449103.9047231749
Gcorr3137 T1370 T3594 T1370 T3594 -1.0316982485750695e-07
Rt8769 T1371 T1372 3272405.126901086
Rt8770 T1371 T1531 4467329.0916202739
Rt8771 T1371 T1579 2742548.6840040651
Rt8772 T1371 T2427 3850025.8872927912
Rt8773 T1371 T3096 13602730.433505898
Rt8774 T1371 T3119 64559000.682674602
Rt8775 T1371 T3234 908996.47261308122
Gcorr3138 T1371 T3467 T1371 T3467 -1.9237903012266864e-07
Gcorr3139 T1371 T3872 T1371 T3872 -4.7841591600590739e-07
Rt8776 T1372 T1434 1050665.4972548711
Rt8777 T1372 T1435 2744730.8383608731
Rt8778 T1372 T1531 10607887.853548424
Rt8779 T1372 T2570 8401115.1460838951
Rt8780 T1372 T3119 726620.63493460952
Gcorr3140 T1372 T3121 T1372 T3121 -4.2943602281524865e-07
Gcorr3141 T1372 T3542 T1372 T3542 -2.8119539169322766e-07
Gcorr3142 T1372 T3872 T1372 T3872 -9.0044045006516171e-08
Rt8781 T1373 T1374 1648219.6834940009
Rt8782 T1373 T1523 4714308.7702803621
Rt8783 T1373 T1784 4778719.4984388882
Rt8784 T1373 T2195 4705935.0724963257
Gcorr3143 T1373 T2789 T1373 T2789 -1.274420091259585e-07
Rt8785 T1373 T3742 21410995.065273043
Rt8786 T1374 T1523 9441621.6563778315
Rt8787 T1374 T1545 3858692.5364441941
Rt8788 T1374 T1674 4509161.3702552533
Rt8789 T1374 T2142 4513835.7056728499
Gcorr3144 T1375 T2008 T1375 T2008 -1.7513957320526661e-08
Rt8790 T1375 T2193 4776166.1481403997
Rt8791 T1375 T2194 15605692.054002581
Rt8792 T1375 T2589 9677486.0355716143
Rt8793 T1375 T2628 3172359.233762491
Rt8794 T1375 T3717 2010967.1032528395
Gcorr3145 T1375 T3907 T1375 T3907 -1.7416405074215584e-07
Rt8795 T1376 T2298 11954292.309058122
Rt8796 T1376 T2491 24049540.554139245
Rt8797 T1376 T2709 3908275.2001153235
Rt8798 T1376 T2721 2473174.0069384892
Rt8799 T1376 T3635 5050267.305336317
Rt8800 T1376 T3636 17674414.9462169
Rt8801 T1376 T3637 3648381.5979909166
Rt8802 T1377 T1378 4758143.8292860547
Rt8803 T1377 T1454 5432573.2975408016
Rt8804 T1377 T1482 58350472.791567765
Rt8805 T1377 T2709 3238004.3324480825
Rt8806 T1377 T3185 3166149.0407910869
Rt8807 T1377 T3640 3442020.9814462531
Rt8808 T1377 T4153 23625209.362050585
Rt8809 T1377 T4154 87534349.63066566
Rt8810 T1378 T1454 4099540.9428308085
Rt8811 T1378 T1455 4945389.8017631229
Rt8812 T1378 T1518 6480473.5224056682
Rt8813 T1378 T1878 5210906.4936768301
Rt8814 T1378 T2643 6124498.2075714571
Gcorr3146 T1378 T3079 T1378 T3079 -6.8025778531036101e-08
Rt8815 T1378 T3236 1528124.2937534957
Gcorr3147 T1378 T3640 T1378 T3640 -9.3665213008014007e-08
Rt8816 T1378 T3877 16974073.849035028
Gcorr3148 T1378 T3929 T1378 T3929 -1.5843461506336556e-07
Rt8817 T1378 T4154 2159578.6980876639
Gcorr3149 T1378 T4162 T1378 T4162 -7.6626783620846863e-08
Rt8818 T1379 T1380 10683477.406485457
Rt8819 T1379 T1658 4286839.2994632386
Rt8820 T1379 T2252 22154658.791455682
Rt8821 T1379 T2488 3357889.6938501731
Rt8822 T1379 T3281 8923446.2757630982
Rt8823 T1379 T3288 7193166.2674568482
Rt8824 T1379 T3289 1889406.0025954787
Gcorr3150 T1379 T3492 T1379 T3492 -1.6262313812378226e-07
Rt8825 T1380 T1658 1238091.9253514921
Rt8826 T1380 T1676 18981956.439062808
Rt8827 T1380 T1846 6939562.3410224654
Rt8828 T1380 T2092 3150700.3808016558
Rt8829 T1380 T3289 2358832.9948701118
Gcorr3151 T1380 T3290 T1380 T3290 -5.4613672365917434e-07
Rt8830 T1380 T3291 1352627.3974909121
Gcorr3152 T1380 T3453 T1380 T3453 -1.2882051115832987e-07
Rt8831 T1380 T4022 4564714.2912132265
Rt8832 T1381 T2280 31028024.615519796
Rt8833 T1381 T2555 5865384.3582925014
Rt8834 T1381 T2615 2296714.2383530731
Rt8835 T1381 T2997 3410655.4586294359
Rt8836 T1381 T2998 2375567.3810042925
Rt8837 T1381 T3025 3068577.1390536521
Rt8838 T1381 T4075 28671488.622648839
Rt8839 T1382 T1893 10490706.811952638
Rt8840 T1382 T2016 3499994.571622978
Rt8841 T1382 T2339 1394906.8777599218
Rt8842 T1382 T2590 1752730.8398400301
Rt8843 T1382 T2602 341606.36274060589
Gcorr3153 T1382 T3089 T1382 T3089 -1.3303877116543927e-07
Rt8844 T1382 T3090 191727.52650043048
Gcorr3154 T1382 T3091 T1382 T3091 -2.0377355481974632e-07
Gcorr3155 T1382 T3092 T1382 T3092 -3.4591799700312503e-06
Gcorr3156 T1382 T3142 T1382 T3142 -3.5081786191029512e-07
Gcorr3157 T1382 T4151 T1382 T4151 -9.1907508650268206e-08
Rt8845 T1383 T2055 5090124.1389295384
Rt8846 T1383 T2462 2565870.8932665559
Rt8847 T1383 T2500 1664667.4038894421
Rt8848 T1383 T2678 435079.06980490597
Gcorr3158 T1383 T3240 T1383 T3240 -1.588399886859269e-07
Gcorr3159 T1383 T3242 T1383 T3242 -8.1131703962032939e-08
Rt8849 T1383 T3244 4708070.4962138394
Gcorr3160 T1383 T3246 T1383 T3246 -2.3464976328097042e-07
Gcorr3161 T1383 T3970 T1383 T3970 -2.0898153186909614e-06
Rt8850 T1383 T4072 308750.83574173081
Rt8851 T1384 T1385 4001527.7261786936
Rt8852 T1384 T1386 3483907.0807625041
Rt8853 T1384 T2052 5170397.2291977787
Rt8854 T1384 T2258 5883571.1770623
Gcorr3162 T1384 T3248 T1384 T3248 -1.4216969901604437e-07
Rt8855 T1384 T3250 5976599.2310318965
Rt8856 T1384 T3328 1586748.5718053419
Rt8857 T1384 T3329 10435383.754352301
Rt8858 T1385 T1386 12345560.333977984
Rt8859 T1385 T1635 2898762.3875778983
Rt8860 T1385 T2403 10143524.626420112
Rt8861 T1385 T2601 944846.17275887181
Rt8862 T1385 T3250 715844.9313299245
Gcorr3163 T1385 T3252 T1385 T3252 -6.6629316446472908e-08
Gcorr3164 T1385 T3253 T1385 T3253 -2.0308046636235123e-07
Gcorr3165 T1385 T3329 T1385 T3329 -1.6311722106498929e-07
Rt8863 T1386 T1635 4833303.6963602928
Rt8864 T1386 T1636 587725.91787316522
Rt8865 T1386 T1698 4953703.99658354
Rt8866 T1386 T2052 26660954.560907844
Gcorr3166 T1386 T3247 T1386 T3247 -1.5853886239763209e-06
Rt8867 T1386 T3248 417467.63663020328
Rt8868 T1386 T3249 9145377.3799383566
Rt8869 T1386 T3250 3873250.2148940861
Rt8870 T1387 T1388 4688713.7632940039
Rt8871 T1387 T1393 2873205.6921900748
Rt8872 T1387 T1526 9598568.7618077584
Rt8873 T1387 T2233 2891596.8979548025
Rt8874 T1387 T2769 1415635.5851767703
Rt8875 T1387 T3755 12933901.627583044
Gcorr3167 T1387 T3903 T1387 T3903 -2.3184346200510258e-07
Rt8876 T1387 T4021 10518446.016565809
Rt8877 T1388 T2233 9170070.5377734844
Rt8878 T1388 T2234 4688549.3188014301
Rt8879 T1388 T2263 5920085.473460285
Rt8880 T1388 T2513 2709277.0986794406
Rt8881 T1388 T3327 4798061.8235907564
Rt8882 T1388 T3903 18447120.681210764
Gcorr3168 T1388 T4020 T1388 T4020 -1.7512819183037542e-07
Rt8883 T1388 T4021 2579907.7815625872
Rt8884 T1389 T1390 10619016.30913862
Rt8885 T1389 T1391 17987872.714813445
Rt8886 T1389 T2281 4679132.3481196631
Rt8887 T1389 T2630 2183554.6078400435
Gcorr3169 T1389 T3087 T1389 T3087 -1.4895302243896468e-07
Gcorr3170 T1389 T3400 T1389 T3400 -9.1742520529363837e-08
Rt8888 T1389 T3793 1315608.9563204395
Rt8889 T1389 T4197 7517420.865691145
Rt8890 T1390 T1391 4827756.1715110652
Rt8891 T1390 T1414 27949618.00350206
Rt8892 T1390 T1415 4769050.3650916424
Rt8893 T1390 T2557 3141995.5390600367
Gcorr3171 T1390 T3068 T1390 T3068 -6.6288861113519638e-08
Rt8894 T1390 T3202 3577031.0258697537
Rt8895 T1390 T3624 1753039.4999008046
Rt8896 T1390 T3793 5562986.4976183698
Rt8897 T1391 T1414 5662410.0918281749
Rt8898 T1391 T1479 4768281.2014475586
Gcorr3172 T1391 T1483 T1391 T1483 -6.4486136569004172e-09
Rt8899 T1391 T2630 3606260.9148155516
Rt8900 T1391 T3049 1329259.7249165678
Rt8901 T1391 T3624 3804232.5403421666
Rt8902 T1391 T3793 8887926.2571623642
Rt8903 T1391 T4057 15931337.582756992
Rt8904 T1392 T1947 263378984.46802428
Rt8905 T1392 T1960 5546812.67242359
Rt8906 T1392 T2211 3344873.9961698321
Rt8907 T1392 T2240 8251928.1708739391
Gcorr3173 T1392 T2863 T1392 T2863 -9.5297434465309313e-08
Rt8908 T1392 T2866 2863683.4495139224
Rt8909 T1392 T3199 15046621.439371828
Rt8910 T1392 T3556 4231351.8717120485
Rt8911 T1393 T1526 4562471.5327736074
Rt8912 T1393 T1527 4662895.0194998868
Rt8913 T1393 T2127 4683877.4000361366
Rt8914 T1393 T2137 3162567.5717992345
Gcorr3174 T1393 T2769 T1393 T2769 -1.9913209927093905e-07
Rt8915 T1394 T1488 4129779.082308488
Rt8916 T1394 T1532 10688300.967495421
Rt8917 T1394 T1704 4135021.9654340604
Rt8918 T1394 T2105 4158937.5664742286
Rt8919 T1395 T1396 16758758.238468811
Rt8920 T1395 T1632 7287461.6134869391
Rt8921 T1395 T1633 7895721.7093165517
Rt8922 T1395 T2641 3126075.0213928986
Rt8923 T1395 T3014 3204645.7528537046
Rt8924 T1395 T3088 1488608.3620359143
Rt8925 T1395 T3408 2109661.2355908398
Gcorr3175 T1395 T3457 T1395 T3457 -1.2112377090178876e-07
Rt8926 T1396 T1632 2436227.9854555158
Rt8927 T1396 T1634 1160298.1095803748
Gcorr3176 T1396 T2319 T1396 T2319 -1.4153469019947376e-07
Rt8928 T1396 T2370 631832.93451772851
Rt8929 T1396 T2986 4310515.8829428731
Gcorr3177 T1396 T3013 T1396 T3013 -7.267520653085229e-07
Rt8930 T1396 T3014 358336.97088623885
Gcorr3178 T1396 T3069 T1396 T3069 -5.6970674393274974e-07
Rt8931 T1397 T1680 557305.65139015054
Rt8932 T1397 T1681 3662571.1326312693
Rt8933 T1397 T1682 2973078.0933849202
Rt8934 T1397 T2590 7611718.2489120821
Rt8935 T1397 T3055 5115025.9825422224
Gcorr3179 T1397 T3059 T1397 T3059 -2.0822949184851765e-07
Rt8936 T1397 T3060 1828863.6641078254
Gcorr3180 T1397 T3356 T1397 T3356 -2.2598114734214628e-06
Rt8937 T1397 T4133 418108.82255010895
Rt8938 T1398 T1399 3582879.4436073438
Rt8939 T1398 T1413 5716444.6471098522
Rt8940 T1398 T1514 2480911.8475683876
Rt8941 T1398 T2717 1128392.2629592861
Gcorr3181 T1398 T3258 T1398 T3258 -1.9936008831539273e-07
Rt8942 T1398 T3260 10298892.477858372
Rt8943 T1398 T3261 515336.58627758001
Gcorr3182 T1398 T3262 T1398 T3262 -3.0112437089651344e-07
Gcorr3183 T1398 T3263 T1398 T3263 -4.5520434734469264e-07
Gcorr3184 T1398 T3965 T1398 T3965 -4.1731421949410029e-07
Rt8944 T1399 T1514 4563356.5302983169
Rt8945 T1399 T1515 17941601.744766127
Rt8946 T1399 T1938 20099002.467271775
Rt8947 T1399 T2381 6160251.2354369015
Rt8948 T1399 T2587 2593384.0559438705
Gcorr3185 T1399 T3261 T1399 T3261 -8.6102071097076426e-08
Rt8949 T1399 T3264 1285490.6388754968
Gcorr3186 T1399 T3275 T1399 T3275 -1.8601098807991692e-07
Rt8950 T1399 T3965 2035850.6393589464
Rt8951 T1399 T3966 8706216.8696657661
Rt8952 T1400 T2035 4118489.0405904651
Rt8953 T1400 T2276 4009000.6670656721
Rt8954 T1400 T2369 2129962.5963604986
Gcorr3187 T1400 T3312 T1400 T3312 -1.0102266497343961e-07
Rt8955 T1400 T3314 1974237.130718254
Rt8956 T1400 T3359 5357864.9536109362
Gcorr3188 T1400 T3959 T1400 T3959 -1.1780936415497261e-08
Rt8957 T1401 T1402 3027544.5620808476
Gcorr3189 T1401 T1677 T1401 T1677 -8.0618203437532112e-08
Gcorr3190 T1401 T2224 T1401 T2224 -2.4698596629215214e-09
Rt8958 T1401 T2625 3509625.7349781753
Rt8959 T1401 T3209 3020450.837089777
Rt8960 T1401 T3735 1630095.293410751
Rt8961 T1401 T3840 1762280.1239969179
Rt8962 T1402 T1677 4295196.1477304595
Rt8963 T1402 T1678 5432494.5499992836
Gcorr3191 T1402 T1679 T1402 T1679 -1.433307871970791e-07
Rt8964 T1402 T2301 6936256.9818809666
Rt8965 T1402 T3009 1826924.8557405809
Rt8966 T1402 T3160 1088778.8431281182
Rt8967 T1402 T3735 3218830.0022139931
Gcorr3192 T1402 T3840 T1402 T3840 -3.4822719534029859e-07
Rt8968 T1402 T4181 1338511.9521537526
Rt8969 T1403 T1683 4660184.2676663743
Rt8970 T1403 T1773 4557569.5097847758
Rt8971 T1403 T1824 8597775.4528509583
Rt8972 T1403 T2092 2492225.012462873
Rt8973 T1403 T2790 1572632.8521836323
Rt8974 T1403 T3492 22298148.803454649
Rt8975 T1403 T3815 14158551.329126257
Gcorr3193 T1403 T4022 T1403 T4022 -1.773036510638533e-07
Rt8976 T1404 T1405 4535392.6123259813
Rt8977 T1404 T1586 4582173.4295641836
Rt8978 T1404 T1943 15655032.707682787
Rt8979 T1404 T2567 2802202.7080674907
Rt8980 T1404 T2774 7558150.582536485
Rt8981 T1404 T3656 11808778.217159092
Rt8982 T1405 T1586 10987212.440010594
Rt8983 T1405 T1587 914467.50598942512
Rt8984 T1405 T1588 3523910.1359654563
Rt8985 T1405 T2241 10495065.942712085
Rt8986 T1405 T2774 991587.91810200782
Rt8987 T1405 T3357 54799197.319521539
Gcorr3194 T1405 T3488 T1405 T3488 -7.77769976756387e-07
Gcorr3195 T1405 T3656 T1405 T3656 -1.3192168472821839e-07
Rt8988 T1405 T3697 2896765.999755756
Rt8989 T1406 T1407 4165064.4221694032
Rt8990 T1406 T1501 14794822.903894313
Rt8991 T1406 T2458 3739237.6491903192
Rt8992 T1406 T2560 3785462.0381110394
Gcorr3196 T1406 T2967 T1406 T2967 -1.2431340658077598e-07
Rt8993 T1406 T2968 2634682.404695848
Rt8994 T1406 T2969 3159214.0545545695
Gcorr3197 T1406 T2973 T1406 T2973 -6.8519111080486009e-08
Rt8995 T1407 T1501 4078359.4494055146
Rt8996 T1407 T1502 20442050.950225145
Rt8997 T1407 T2122 14507991.68094385
Rt8998 T1407 T2614 2590352.6791952737
Rt8999 T1407 T2967 2874680.8892757487
Gcorr3198 T1407 T2969 T1407 T2969 -3.1150943179024189e-08
Rt9000 T1407 T2970 5154294.027343723
Rt9001 T1408 T1409 4455195.6440349007
Rt9002 T1408 T1466 4795329.3217698056
Rt9003 T1408 T1516 10505210.991886532
Rt9004 T1408 T2101 4684801.692603997
Rt9005 T1408 T3579 9584744.9464856777
Rt9006 T1408 T3676 2599553.2990875854
Rt9007 T1409 T1410 4351508.6741430769
Rt9008 T1409 T1411 11927501.398339681
Rt9009 T1409 T1516 4500274.7390606143
Rt9010 T1409 T2362 2822870.1082068998
Rt9011 T1409 T3310 1827400.917935455
Rt9012 T1409 T3579 11657747.46149867
Rt9013 T1409 T3676 13556780.418547565
Gcorr3199 T1409 T3914 T1409 T3914 -1.202875807347044e-07
Gcorr3200 T1409 T4065 T1409 T4065 -1.0945523945057652e-07
Rt9014 T1410 T1411 2710469.3976833564
Rt9015 T1410 T1525 2993623.971810095
Rt9016 T1410 T1990 739870569.98639965
Rt9017 T1410 T2542 2975709.3169164048
Gcorr3201 T1410 T3306 T1410 T3306 -1.835153831102988e-07
Rt9018 T1410 T3308 2823428.8893789547
Rt9019 T1410 T3310 4572619.2070541522
Rt9020 T1410 T3914 6065544.0327841956
Rt9021 T1411 T1525 11424372.014170248
Rt9022 T1411 T1685 13836876.023118917
Rt9023 T1411 T1802 5960575.3294152822
Rt9024 T1411 T2362 3054542.8789688065
Rt9025 T1411 T3306 1909776.7421779376
Rt9026 T1411 T3310 8115946.4371543294
Gcorr3202 T1411 T3311 T1411 T3311 -2.0002627930730226e-08
Rt9027 T1412 T1490 3374226.1730475924
Rt9028 T1412 T1543 40224347.614095025
Rt9029 T1412 T1990 5283193.2107929895
Rt9030 T1412 T2338 5083599.6838563699
Gcorr3203 T1412 T3298 T1412 T3298 -5.9899888621851413e-08
Rt9031 T1412 T3301 1910014.4690045658
Gcorr3204 T1412 T3309 T1412 T3309 -7.709501275370476e-08
Rt9032 T1412 T4117 2991593.305006776
Rt9033 T1412 T4165 15247612.444557227
Rt9034 T1413 T2278 5228364.2929909443
Gcorr3205 T1413 T2314 T1413 T2314 -4.802892770337334e-08
Rt9035 T1413 T2315 34301000.50271178
Rt9036 T1413 T2645 2489611.2054513558
Rt9037 T1413 T2717 3118110.4519102382
Rt9038 T1413 T3260 6833804.7568941042
Rt9039 T1413 T3262 36761870.924621649
Rt9040 T1413 T4081 5353855.5338103697
Rt9041 T1413 T4144 3545901.1657549501
Rt9042 T1414 T1415 4845399.2726117037
Rt9043 T1414 T1479 134695663.26627296
Gcorr3206 T1414 T1578 T1414 T1578 -1.6446423279279756e-08
Rt9044 T1414 T2550 3422477.1073231786
Rt9045 T1414 T3074 1967542.6135438469
Rt9046 T1414 T3624 1887162.6667730638
Rt9047 T1414 T4057 2507562.7044905396
Rt9048 T1415 T1578 6284117.7338250168
Gcorr3207 T1415 T2363 T1415 T2363 -1.8131081567295626e-08
Gcorr3208 T1415 T2416 T1415 T2416 -6.5084696819175158e-08
Rt9049 T1415 T2484 2539400.1016528653
Rt9050 T1415 T2557 19249976.98916753
Rt9051 T1415 T3040 3481040.139795912
Rt9052 T1415 T3068 958431.50263929425
Rt9053 T1415 T3074 3031107.7237321213
Gcorr3209 T1415 T3624 T1415 T3624 -1.3190191769303582e-07
Rt9054 T1416 T1417 4841067.5693768524
Rt9055 T1416 T1418 10196201.585978573
Rt9056 T1416 T1787 1825508.7365372311
Rt9057 T1416 T2084 11776177.564576132
Gcorr3210 T1416 T2735 T1416 T2735 -1.5384077685665685e-07
Rt9058 T1417 T1418 3105376.4043717822
Rt9059 T1417 T1419 9411264.4443593267
Rt9060 T1417 T2063 11273421.015751738
Rt9061 T1417 T2186 4609681.3926017974
Rt9062 T1418 T1419 975814.50405833661
Rt9063 T1418 T1420 10630590.349263519
Rt9064 T1418 T1787 1900204.7694526387
Rt9065 T1418 T2179 3625104.8024584157
Rt9066 T1419 T1420 4779116.6831888007
Rt9067 T1419 T1421 1904245.1036138458
Rt9068 T1419 T1423 4974003.6088352501
Rt9069 T1419 T2186 2520424.7743099956
Rt9070 T1420 T1421 10569176.62786602
Rt9071 T1420 T1422 1888397.3942748229
Rt9072 T1420 T1456 10595331.94639346
Rt9073 T1420 T2179 1834923.3809655714
Gcorr3211 T1420 T2843 T1420 T2843 -4.2572134052843677e-07
Rt9074 T1421 T1422 4548401.5789300036
Rt9075 T1421 T1423 10435747.843809707
Rt9076 T1421 T1424 1919101.0283831342
Rt9077 T1421 T2153 10573657.075238846
Gcorr3212 T1421 T2842 T1421 T2842 -4.0078984441499765e-07
Rt9078 T1421 T3752 3258180.4053390245
Rt9079 T1422 T1456 1895479.6723847147
Rt9080 T1422 T1457 4956583.0857794946
Rt9081 T1422 T1484 4850761.007431088
Rt9082 T1422 T2153 4560489.2298002783
Rt9083 T1422 T2843 853885.62717982347
Rt9084 T1422 T3752 20280187.558087301
Gcorr3213 T1422 T3774 T1422 T3774 -2.6514674476182647e-07
Rt9085 T1422 T3819 69945136.05232884
Rt9086 T1422 T4137 10851856.208724689
Rt9087 T1423 T1424 4755513.4502723394
Rt9088 T1423 T1425 10815683.225240668
Rt9089 T1423 T2186 10186056.583524346
Rt9090 T1423 T2212 1661283.8869866177
Rt9091 T1424 T1425 4945763.3611488091
Rt9092 T1424 T1426 4639857.1289223256
Rt9093 T1424 T2153 2830865.6397286891
Rt9094 T1424 T2155 2831535.5497978968
Rt9095 T1424 T2842 801599.04897490039
Gcorr3214 T1424 T3752 T1424 T3752 -4.1822306954675639e-07
Rt9096 T1424 T3860 33593711.828111172
Gcorr3215 T1424 T4131 T1424 T4131 -2.4144089049640866e-07
Rt9097 T1425 T1426 10643297.116781805
Rt9098 T1425 T1427 1330314.6650302864
Rt9099 T1425 T1508 10497711.559366006
Rt9100 T1425 T2212 1886977.3837234506
Gcorr3216 T1425 T3716 T1425 T3716 -6.7912228370727646e-07
Rt9101 T1425 T3860 1461962.3317336617
Rt9102 T1426 T1427 4165076.1620187522
Rt9103 T1426 T1428 4462470.0960276444
Rt9104 T1426 T1604 10780320.212208411
Rt9105 T1426 T2155 4300071.7280626949
Rt9106 T1426 T3383 3001058.7554876711
Gcorr3217 T1426 T3716 T1426 T3716 -7.453699052431815e-08
Rt9107 T1426 T3860 3614410.8589618271
Gcorr3218 T1426 T4131 T1426 T4131 -7.1866976723617504e-08
Rt9108 T1427 T1428 2916035.4715851531
Rt9109 T1427 T1429 1873589.8468226173
Rt9110 T1427 T1508 4757495.9445447549
Rt9111 T1427 T2312 4463419.1421914222
Gcorr3219 T1427 T2838 T1427 T2838 -7.7745559766509484e-08
Gcorr3220 T1427 T3519 T1427 T3519 -4.4079033787579577e-07
Rt9112 T1427 T3716 590085.63642669714
Gcorr3221 T1427 T3860 T1427 T3860 -6.5631451438134344e-07
Rt9113 T1428 T1429 9819796.7539276723
Rt9114 T1428 T1480 10044160.89705235
Rt9115 T1428 T1604 4021658.6388246734
Rt9116 T1428 T2388 2402671.5158162266
Gcorr3222 T1428 T3377 T1428 T3377 -2.032382266356471e-07
Rt9117 T1428 T3383 13799312.819486152
Rt9118 T1428 T3519 1359747.7665533437
Gcorr3223 T1428 T3716 T1428 T3716 -1.3839013035799096e-07
Rt9119 T1429 T1480 4197593.4298479781
Rt9120 T1429 T1481 12038951.447044831
Rt9121 T1429 T1589 1685032.5497803856
Rt9122 T1429 T2312 8908607.5614678077
Rt9123 T1429 T2838 1638241.808833715
Gcorr3224 T1429 T3398 T1429 T3398 -4.3980724367286939e-07
Rt9124 T1429 T3519 3122776.5173830404
Rt9125 T1429 T3528 2664077.5814595125
Gcorr3225 T1429 T3716 T1429 T3716 -3.9238625150786792e-07
Rt9126 T1430 T1432 10569529.224069223
Rt9127 T1430 T1568 3592174.3970614905
Rt9128 T1430 T1569 4513295.7023570072
Rt9129 T1430 T2452 4338813.7465947028
Gcorr3226 T1430 T2802 T1430 T2802 -1.235521486924384e-07
Rt9130 T1430 T2803 2163276.0484963413
Rt9131 T1430 T2804 8731948.3934202958
Rt9132 T1430 T2805 14144329.944148542
Rt9133 T1431 T1433 10673961.150664294
Rt9134 T1431 T1710 5079203.872951109
Gcorr3227 T1431 T2357 T1431 T2357 -8.5538366036522154e-08
Rt9135 T1431 T2453 1683660.6990751862
Gcorr3228 T1431 T2676 T1431 T2676 -7.5506896738245458e-08
Rt9136 T1431 T3224 556781.59726071032
Gcorr3229 T1431 T3922 T1431 T3922 -2.1552142658124152e-07
Rt9137 T1431 T3931 5150329.4016392929
Rt9138 T1431 T4094 11421486.896169422
Rt9139 T1432 T1503 2142060.8322962313
Rt9140 T1432 T1533 12463932.215266602
Rt9141 T1432 T1804 6620471.8636935093
Rt9142 T1432 T2452 3274183.7262865324
Rt9143 T1432 T2805 1039493.8467983645
Gcorr3230 T1432 T2806 T1432 T2806 -9.1523547130507095e-08
Rt9144 T1432 T2807 3521418.1832821257
Gcorr3231 T1432 T2875 T1432 T2875 -1.5990332146358957e-07
Gcorr3232 T1432 T3729 T1432 T3729 -2.857506705641218e-07
Rt9145 T1433 T1710 913466.14648732916
Rt9146 T1433 T1825 2101499.8370368606
Gcorr3233 T1433 T2319 T1433 T2319 -4.0482997444724744e-09
Gcorr3234 T1433 T2521 T1433 T2521 -1.0290412396510967e-07
Rt9147 T1433 T2714 12694209.279532013
Gcorr3235 T1433 T2816 T1433 T2816 -6.1908014437654638e-07
Rt9148 T1433 T2941 318923.62430285977
Rt9149 T1433 T3224 19541986.072982885
Rt9150 T1434 T1435 12652811.997590505
Rt9151 T1434 T1582 5261653.3113012407
Rt9152 T1434 T1897 10755822.311089622
Rt9153 T1434 T2020 4361399.1553747514
Gcorr3236 T1434 T3119 T1434 T3119 -5.5900912959721206e-07
Rt9154 T1434 T3121 1977754.0213214229
Rt9155 T1434 T3232 25214790.621422075
Rt9156 T1434 T3542 1551515.9545593744
Rt9157 T1435 T1582 4657403.1346625015
Rt9158 T1435 T1583 2716211.5809264821
Gcorr3237 T1435 T2439 T1435 T2439 -1.9112789337562994e-08
Rt9159 T1435 T2570 3164189.5668906574
Gcorr3238 T1435 T3119 T1435 T3119 -1.4440345803989517e-07
Rt9160 T1435 T3120 1889442.9026161463
Rt9161 T1435 T3121 1987825.5079435024
Gcorr3239 T1435 T3122 T1435 T3122 -1.2243611810322942e-07
Rt9162 T1436 T1437 4470105.4924536319
Rt9163 T1436 T1438 4623682.0158670256
Rt9164 T1436 T1792 4931787.840069782
Rt9165 T1436 T2118 4016311.2844617772
Rt9166 T1437 T1438 10527402.938541697
Rt9167 T1437 T1439 4385306.5677604387
Rt9168 T1437 T1440 4399029.2749612909
Rt9169 T1437 T2108 10565291.490416663
Gcorr3240 T1437 T2826 T1437 T2826 -6.3784323212296028e-08
Rt9170 T1438 T1439 4487001.8362568356
Rt9171 T1438 T1441 4139215.0183380479
Rt9172 T1438 T1792 4496628.7531513004
Rt9173 T1438 T2096 4906021.0741735287
Gcorr3241 T1438 T3409 T1438 T3409 -1.3493707627264204e-07
Rt9174 T1438 T3740 13683962.85936065
Rt9175 T1439 T1440 4415296.49623584
Rt9176 T1439 T1441 4374483.3310327316
Rt9177 T1439 T1442 4018765.0756309298
Rt9178 T1439 T2290 10799363.789840069
Rt9179 T1439 T2826 8477176.7408963647
Gcorr3242 T1439 T3412 T1439 T3412 -1.5192064606050299e-07
Rt9180 T1439 T3740 3076909.766844782
Rt9181 T1439 T3957 3267888.3321624398
Rt9182 T1440 T2108 4337882.0595783368
Rt9183 T1440 T2290 4709028.0946574351
Rt9184 T1440 T2448 11706868.878705157
Rt9185 T1440 T2618 3435359.2724673059
Rt9186 T1440 T2826 3201210.5004361533
Rt9187 T1440 T3611 3198087.9505976927
Rt9188 T1440 T3612 12450503.563599354
Gcorr3243 T1440 T3957 T1440 T3957 -1.3744943773393547e-07
Rt9189 T1441 T1442 9286389.2662156671
Rt9190 T1441 T1492 4204855.6028850619
Rt9191 T1441 T1493 4073878.5356782
Rt9192 T1441 T2096 10836142.094007084
Rt9193 T1441 T3409 2316196.9212344931
Gcorr3244 T1441 T3410 T1441 T3410 -1.1806661432209897e-07
Rt9194 T1441 T3412 4684536.9034793684
Gcorr3245 T1441 T3740 T1441 T3740 -4.7616038109677929e-08
Rt9195 T1442 T1492 4064711.1140230801
Rt9196 T1442 T1509 4221820.3392368518
Rt9197 T1442 T1510 20063804.043737959
Rt9198 T1442 T2290 3605498.4024902531
Rt9199 T1442 T3412 2291907.9560413277
Gcorr3246 T1442 T3707 T1442 T3707 -1.3707024342225895e-07
Gcorr3247 T1442 T3957 T1442 T3957 -7.6233935475573168e-08
Rt9200 T1442 T4068 3542789.9171795268
Rt9201 T1443 T1444 10375311.209218469
Rt9202 T1443 T1445 3670819.5022894079
Rt9203 T1443 T1793 4504672.8538999846
Rt9204 T1443 T2126 9991241.7132382747
Gcorr3248 T1443 T3215 T1443 T3215 -1.1947289858607059e-07
Rt9205 T1444 T1445 1290357.2097466565
Rt9206 T1444 T1446 9236738.2608795594
Rt9207 T1444 T2040 5081002.961574371
Rt9208 T1444 T2185 4680134.9539803946
Gcorr3249 T1444 T3215 T1444 T3215 -6.2632671701620022e-07
Rt9209 T1444 T3661 3716531.0117926318
Rt9210 T1445 T1446 4513237.7354644286
Rt9211 T1445 T1447 15264870.307316907
Rt9212 T1445 T1793 5009169.8488099501
Rt9213 T1445 T2626 2831539.6187891746
Rt9214 T1445 T3215 906593.5626727523
Gcorr3250 T1445 T3661 T1445 T3661 -1.0840054036992526e-07
Rt9215 T1445 T3895 6690122.7912673932
Gcorr3251 T1445 T4095 T1445 T4095 -9.7765696382529951e-08
Rt9216 T1446 T1447 9350630.3008971978
Rt9217 T1446 T1448 3609022.888952917
Rt9218 T1446 T1449 4340202.0377667984
Rt9219 T1446 T2040 3899560.0702443374
Gcorr3252 T1446 T2786 T1446 T2786 -9.5178052323994917e-08
Rt9220 T1446 T3580 46141429.554077506
Rt9221 T1446 T3661 2183188.9757619984
Rt9222 T1446 T3895 10079828.464997321
Rt9223 T1447 T1448 3962263.8343648501
Rt9224 T1447 T1452 10035983.497452639
Rt9225 T1447 T1512 4913391.2650703741
Rt9226 T1447 T2626 2466689.1928414721
Rt9227 T1447 T3152 7063236.3417714564
Gcorr3253 T1447 T3668 T1447 T3668 -9.828258901965107e-08
Rt9228 T1447 T3895 2367496.5702260877
Rt9229 T1448 T1449 10405849.51801965
Rt9230 T1448 T1450 3993015.3630957631
Rt9231 T1448 T1452 11382046.998708306
Rt9232 T1448 T2466 3049115.0432790322
Rt9233 T1448 T3152 3924907.943509426
Gcorr3254 T1448 T3153 T1448 T3153 -1.1518423561756284e-07
Rt9234 T1448 T3580 2079727.4358773017
Gcorr3255 T1448 T3895 T1448 T3895 -1.1990902966559755e-07
Rt9235 T1449 T1450 4817441.1177202268
Rt9236 T1449 T1451 5315887.7381683942
Rt9237 T1449 T1979 3911405.876096047
Rt9238 T1449 T2040 9498518.5248061512
Rt9239 T1449 T2786 3977694.9235574608
Gcorr3256 T1449 T3544 T1449 T3544 -1.25742799952919e-07
Rt9240 T1449 T3580 12000229.807644233
Rt9241 T1449 T3991 3407728.9681492867
Rt9242 T1450 T1451 5344675.9085071636
Rt9243 T1450 T1505 3409553.98797325
Rt9244 T1450 T1507 3619608.5105246897
Rt9245 T1450 T2466 8101470.4948255531
Rt9246 T1450 T3153 3561785.4858210525
Gcorr3257 T1450 T3155 T1450 T3155 -1.5596210511701047e-07
Rt9247 T1450 T3217 2474085.6079661711
Rt9248 T1450 T3580 21646937.16190996
Gcorr3258 T1450 T3991 T1450 T3991 -3.2273812408152409e-08
Rt9249 T1451 T1505 3678708.8876662985
Rt9250 T1451 T1506 13188444.544621136
Rt9251 T1451 T1580 11562121.140155198
Rt9252 T1451 T1979 3015871.6498202747
Rt9253 T1451 T3217 28220825.954708379
Gcorr3259 T1451 T3544 T1451 T3544 -1.1791617609046582e-07
Rt9254 T1451 T3665 1804347.9580058015
Rt9255 T1451 T3991 14126318.227003764
Rt9256 T1452 T1512 3315774.3400286841
Rt9257 T1452 T1513 3095735.0162293394
Rt9258 T1452 T2466 771823.49315605219
Gcorr3260 T1452 T2467 T1452 T2467 -7.1116559147969869e-08
Gcorr3261 T1452 T3150 T1452 T3150 -1.0594577439129709e-07
Rt9259 T1452 T3151 2531716.7705956195
Rt9260 T1452 T3152 906819.68068443169
Gcorr3262 T1452 T3153 T1452 T3153 -6.9942072867875158e-07
Rt9261 T1453 T2141 10241433.467185799
Rt9262 T1453 T2157 4624116.2876279373
Rt9263 T1453 T2184 4198714.0995395435
Rt9264 T1453 T2229 3839575.1622712053
Rt9265 T1454 T1455 17303258.11885725
Rt9266 T1454 T1482 4601532.1376749417
Rt9267 T1454 T1887 18148005.590277486
Rt9268 T1454 T2531 4362385.5906757712
Rt9269 T1454 T3079 2338568.5051226667
Rt9270 T1454 T3184 8107066.600219246
Rt9271 T1454 T3185 3245356.4010408465
Rt9272 T1454 T4154 54512988.928355478
Rt9273 T1455 T1518 5461234.9060858702
Rt9274 T1455 T1519 1012503.264595404
Rt9275 T1455 T1520 2518461.6515257331
Rt9276 T1455 T2531 15477443.170633523
Gcorr3263 T1455 T3078 T1455 T3078 -1.6709775918419412e-07
Rt9277 T1455 T3079 1803139.0841920008
Gcorr3264 T1455 T3235 T1455 T3235 -1.084622251953283e-06
Rt9278 T1455 T4162 659743.08721140411
Rt9279 T1456 T1457 9928034.9288157374
Rt9280 T1456 T1458 3576791.3638667609
Rt9281 T1456 T1801 5011362.6864784751
Rt9282 T1456 T2179 4966808.7851870842
Gcorr3265 T1456 T2843 T1456 T2843 -4.1873761147962401e-07
Gcorr3266 T1456 T3766 T1456 T3766 -1.6288212970230668e-07
Rt9283 T1456 T3774 1531047.0521618098
Rt9284 T1457 T1458 4830273.8470786475
Rt9285 T1457 T1459 10423980.735339589
Rt9286 T1457 T1484 10136726.309635026
Rt9287 T1457 T2300 1104395.6222368439
Rt9288 T1457 T3768 2424165.7938613426
Gcorr3267 T1457 T3770 T1457 T3770 -6.8952811622809216e-07
Rt9289 T1457 T3774 16793109.794025321
Rt9290 T1457 T4137 1471194.7940719712
Rt9291 T1458 T1459 4481861.0005762819
Rt9292 T1458 T1460 4567941.5957189221
Rt9293 T1458 T1801 8729421.2456916403
Rt9294 T1458 T2045 3277276.9915453796
Gcorr3268 T1458 T2846 T1458 T2846 -2.3252287060130922e-07
Rt9295 T1458 T3766 1414750.8360058763
Rt9296 T1458 T3767 12525292.534564991
Rt9297 T1458 T3768 15286477.168214288
Gcorr3269 T1458 T3774 T1458 T3774 -1.3424022431950433e-07
Rt9298 T1459 T1460 10691188.928200791
Rt9299 T1459 T1571 4111498.6966449581
Rt9300 T1459 T1572 15608813.8204237
Rt9301 T1459 T2300 1488082.1631305504
Rt9302 T1459 T3767 8455781.0059473701
Rt9303 T1459 T3768 2977323.6550993617
Rt9304 T1459 T3769 2044643.4688435199
Gcorr3270 T1459 T3770 T1459 T3770 -4.5039283677597262e-07
Rt9305 T1460 T1571 2984120.9484104747
Rt9306 T1460 T1573 4564370.9832338728
Rt9307 T1460 T1593 11950907.220114997
Rt9308 T1460 T2045 3850133.8439663961
Gcorr3271 T1460 T2846 T1460 T2846 -1.2937156856181448e-07
Rt9309 T1460 T3767 2408056.4477600115
Gcorr3272 T1460 T3771 T1460 T3771 -1.4318210171491258e-07
Rt9310 T1460 T3919 2689231.6184088299
Rt9311 T1461 T2069 4695036.1706031784
Rt9312 T1461 T2182 10281071.693207759
Rt9313 T1461 T2214 4883865.49281123
Rt9314 T1461 T2413 10365718.50692036
Gcorr3273 T1462 T2304 T1462 T2304 -7.7837951370020539e-08
Rt9315 T1462 T2305 20367889.715024251
Rt9316 T1462 T2306 1446104.4842786812
Rt9317 T1462 T2510 1602389.2341149633
Rt9318 T1462 T2561 1349556.3739791862
Rt9319 T1462 T3000 9395514.8316600807
Rt9320 T1462 T3114 379700.67933800799
Rt9321 T1462 T3115 62693738.830317788
Gcorr3274 T1462 T3575 T1462 T3575 -9.6123490672363911e-08
Gcorr3275 T1462 T3576 T1462 T3576 -4.643248691485115e-07
Gcorr3276 T1462 T3925 T1462 T3925 -3.6884291422909477e-07
Rt9322 T1463 T2001 13157848.221325951
Rt9323 T1463 T2002 1669651.0720667054
Rt9324 T1463 T2125 10515119.583721215
Rt9325 T1463 T2248 4017088.770517143
Rt9326 T1463 T2768 1988461.5652642872
Rt9327 T1463 T3619 9971142.8828636538
Rt9328 T1463 T3659 3134306.4557038662
Rt9329 T1464 T1465 3483377.0957485973
Rt9330 T1464 T1485 15194018.063355207
Rt9331 T1464 T1570 9820582.2713648453
Rt9332 T1464 T2727 3304987.1213305462
Rt9333 T1464 T3029 1332835.1896873715
Rt9334 T1464 T3180 24082641.547001589
Rt9335 T1464 T3181 30854418.05197164
Gcorr3277 T1464 T4102 T1464 T4102 -9.6265979955992539e-08
Rt9336 T1465 T1535 10197155.656590868
Rt9337 T1465 T1536 3418616.4603160443
Rt9338 T1465 T1570 8634646.8597860653
Rt9339 T1465 T2476 2937075.0548818158
Rt9340 T1465 T3180 20162248.434866332
Rt9341 T1465 T3181 1201294.9050354282
Gcorr3278 T1465 T3182 T1465 T3182 -1.106540352578419e-07
Rt9342 T1466 T2101 5129521.7861987464
Rt9343 T1466 T2150 4740680.0061972961
Rt9344 T1466 T2245 11396784.518454434
Rt9345 T1466 T2349 3235254.1330210115
Rt9346 T1467 T2132 3669692.3448879416
Rt9347 T1467 T2147 27051708.365396872
Rt9348 T1467 T2692 6151532.780053379
Rt9349 T1467 T2734 2941150.9494982772
Rt9350 T1467 T2777 2929032.7448006496
Gcorr3279 T1467 T4055 T1467 T4055 -1.3853758164127857e-07
Rt9351 T1468 T2146 9173392.8775713686
Rt9352 T1468 T2285 2875589.6640864792
Rt9353 T1468 T2368 3904236.7199033638
Rt9354 T1468 T2715 3273238.2967205495
Rt9355 T1468 T3118 17474969.085988726
Gcorr3280 T1468 T3533 T1468 T3533 -2.7094201259715628e-07
Rt9356 T1468 T3535 1216542.4385546152
Gcorr3281 T1468 T3536 T1468 T3536 -1.6175419018194401e-07
Rt9357 T1469 T2393 7642513.6911969976
Rt9358 T1469 T2519 6793048.790501208
Rt9359 T1469 T2580 702724.70305699983
Rt9360 T1469 T2662 2936032.3083462655
Rt9361 T1469 T3007 548810.42327232589
Gcorr3282 T1469 T3008 T1469 T3008 -1.7434716684287077e-07
Gcorr3283 T1469 T3071 T1469 T3071 -7.6867634505553741e-07
Rt9362 T1470 T1471 4449389.9546859404
Rt9363 T1470 T1601 4427955.4017865555
Gcorr3284 T1470 T1939 T1470 T1939 -1.953137303596147e-08
Rt9364 T1470 T2519 2945186.7898495267
Rt9365 T1470 T2995 1338350.8344880294
Rt9366 T1470 T3061 7679810.9335894296
Rt9367 T1470 T3062 3139344.8840290983
Gcorr3285 T1470 T3581 T1470 T3581 -1.2747546074523613e-07
Rt9368 T1471 T1601 30660717.52516187
Rt9369 T1471 T1654 6291597.5618524952
Rt9370 T1471 T1772 5097906.7916956944
Rt9371 T1471 T1948 4737548.1982099414
Rt9372 T1471 T3062 3065453.0241275206
Rt9373 T1471 T3228 3041693.2020228254
Rt9374 T1471 T3581 1717893.0202424293
Gcorr3286 T1471 T3841 T1471 T3841 -1.073563174575198e-07
Rt9375 T1472 T1762 4634248.130965854
Rt9376 T1472 T1884 4943923.5760312015
Rt9377 T1472 T1885 3619614.3628913024
Rt9378 T1472 T2235 803145.2203518704
Rt9379 T1473 T2195 4724461.000938355
Rt9380 T1473 T2429 8204991.5671844836
Rt9381 T1473 T2454 3136251.5440491266
Rt9382 T1473 T2455 8936315.6911228374
Rt9383 T1473 T3318 3565353.2361676381
Gcorr3287 T1473 T3343 T1473 T3343 -7.361868934886733e-08
Rt9384 T1473 T3561 6105354.6817660192
Rt9385 T1473 T4039 4273089.5952139562
Rt9386 T1474 T1475 4298725.5688801799
Rt9387 T1474 T1596 10989162.860931128
Rt9388 T1474 T1684 5914119.3115312466
Rt9389 T1474 T2583 3000487.3366365242
Rt9390 T1474 T2902 6228463.1815624628
Gcorr3288 T1474 T2908 T1474 T2908 -1.0776546019232133e-07
Rt9391 T1474 T2948 1270505.5458732154
Gcorr3289 T1474 T3792 T1474 T3792 -8.891303104923962e-09
Rt9392 T1475 T1596 5623768.5644817147
Rt9393 T1475 T1638 3697793.3920269199
Rt9394 T1475 T1795 4127107.7404168788
Rt9395 T1475 T2493 36104406.181327477
Rt9396 T1475 T2908 3029070.286624297
Gcorr3290 T1475 T2948 T1475 T2948 -3.1694239346951259e-08
Rt9397 T1475 T2952 2665807.2963694488
Gcorr3291 T1475 T3286 T1475 T3286 -9.9094635643410119e-08
Rt9398 T1475 T4014 1427193.8934213775
Rt9399 T1476 T1504 17934377.543654989
Rt9400 T1476 T1763 4334928.2618589308
Rt9401 T1476 T1813 99616738.749403462
Rt9402 T1476 T2252 7911028.9074482471
Rt9403 T1476 T3277 1923713.5997704158
Rt9404 T1476 T3279 2709016.2036468252
Rt9405 T1476 T3280 3725039.0870569674
Rt9406 T1477 T1486 4608291.9907013997
Rt9407 T1477 T1607 4216451.0932556856
Rt9408 T1477 T1608 108734811.84644224
Rt9409 T1477 T2455 3014712.5027678111
Rt9410 T1477 T3315 9225673.0268756542
Rt9411 T1477 T3316 5219537.6821784116
Rt9412 T1477 T3317 1010073.457516739
Gcorr3292 T1477 T3318 T1477 T3318 -1.3462966475611996e-07
Gcorr3293 T1477 T4196 T1477 T4196 -1.6208168579290839e-07
Rt9413 T1478 T2259 5086944.1547111664
Rt9414 T1478 T2564 3765302.2785968874
Rt9415 T1478 T2629 3329173.9409890752
Rt9416 T1478 T2644 4663822.5625781938
Rt9417 T1478 T2963 9086705.2465301305
Rt9418 T1478 T3932 3233968.1614783383
Rt9419 T1479 T1483 1395728.6296860934
Gcorr3294 T1479 T1640 T1479 T1640 -1.0205674441628987e-08
Rt9420 T1479 T1713 4790473.7609921852
Rt9421 T1479 T2550 2894143.218544649
Rt9422 T1479 T3048 1459837.3905131829
Gcorr3295 T1479 T3049 T1479 T3049 -8.4920628561427728e-07
Rt9423 T1479 T3485 21304255.20938962
Rt9424 T1479 T4057 554857.84394391836
Rt9425 T1480 T1481 4464131.7097329507
Rt9426 T1480 T2239 4403529.6854826948
Rt9427 T1480 T2388 1231931.7476306327
Rt9428 T1480 T2524 53721165.536688611
Gcorr3296 T1480 T3377 T1480 T3377 -4.3267472744768001e-07
Rt9429 T1480 T3379 1602770.7783683196
Rt9430 T1480 T3519 2780036.9306277926
Rt9431 T1480 T3528 10698629.311875837
Gcorr3297 T1480 T4110 T1480 T4110 -9.6900494931422661e-08
Rt9432 T1481 T1589 4664276.9668992469
Rt9433 T1481 T1590 10908915.282057721
Rt9434 T1481 T1591 4425595.0966072604
Rt9435 T1481 T2239 11984735.469762703
Rt9436 T1481 T3528 7228980.4612054806
Rt9437 T1481 T3851 7648987.6148385396
Rt9438 T1481 T4110 4132269.945632861
Rt9439 T1482 T1887 3011497.566058428
Rt9440 T1482 T2491 3465387.2710077604
Rt9441 T1482 T2492 14879593.693733294
Rt9442 T1482 T2709 2145037.8482586895
Gcorr3298 T1482 T3184 T1482 T3184 -1.2478565613246048e-07
Rt9443 T1482 T3185 1303792.9959117288
Rt9444 T1482 T3829 1601507.2313177967
Gcorr3299 T1482 T4153 T1482 T4153 -3.3899358269921973e-07
Rt9445 T1483 T1640 4230831.5508951684
Gcorr3300 T1483 T1641 T1483 T1641 -1.89704067677324e-08
Gcorr3301 T1483 T1779 T1483 T1779 -8.2055507917564205e-10
Rt9446 T1483 T1869 970588.0181191829
Gcorr3302 T1483 T2630 T1483 T2630 -1.0905437100557998e-07
Rt9447 T1483 T3047 647053.29703786236
Rt9448 T1483 T3048 2850381.249356614
Rt9449 T1483 T3049 728477.06624211627
Gcorr3303 T1483 T3086 T1483 T3086 -6.9338671034326092e-07
Gcorr3304 T1483 T4057 T1483 T4057 -8.4880490820011942e-07
Rt9450 T1484 T2153 9334596.8526491411
Rt9451 T1484 T2154 3761858.9372206526
Rt9452 T1484 T2300 3548118.7061268031
Rt9453 T1484 T2706 3157762.8640421554
Gcorr3305 T1484 T3380 T1484 T3380 -1.2387439684454203e-07
Gcorr3306 T1484 T3770 T1484 T3770 -2.3005158882066929e-08
Rt9454 T1484 T3819 2062218.0437588505
Rt9455 T1484 T4137 9199245.781081358
Rt9456 T1485 T2458 2610062.4473237027
Rt9457 T1485 T2727 2173530.7620252222
Rt9458 T1485 T2729 368665.73148262495
Gcorr3307 T1485 T2976 T1485 T2976 -1.3897956750685359e-07
Rt9459 T1485 T3028 1236032.5854508181
Rt9460 T1485 T3029 4084035.2956835092
Rt9461 T1485 T3179 701216.14078961872
Gcorr3308 T1485 T3183 T1485 T3183 -1.7878648286657698e-06
Rt9462 T1486 T1607 17400178.791337285
Rt9463 T1486 T1780 7150068.8395836195
Rt9464 T1486 T2035 3142351.3046408989
Rt9465 T1486 T2485 3872663.3546701279
Gcorr3309 T1486 T3313 T1486 T3313 -1.69503106275373e-07
Rt9466 T1486 T3315 1075459.3151126681
Rt9467 T1486 T3590 8319832.436885166
Rt9468 T1486 T4196 4313017.106809712
Rt9469 T1487 T1890 2222859.0761735211
Rt9470 T1487 T1907 18429910.137114026
Rt9471 T1487 T1913 4520909.44954322
Rt9472 T1487 T2238 4257512.2663201718
Rt9473 T1487 T2730 8367962.7195019498
Rt9474 T1487 T2741 3587380.5500346324
Rt9475 T1487 T3443 2012530.7327175341
Gcorr3310 T1487 T3708 T1487 T3708 -3.3640640908147015e-07
Rt9476 T1487 T3834 3136907.2090686802
Rt9477 T1487 T3874 20250500.743363153
Gcorr3311 T1487 T3885 T1487 T3885 -1.952885613316181e-07
Rt9478 T1488 T1532 4122512.1422601207
Rt9479 T1488 T1785 10808392.260720391
Rt9480 T1488 T1794 4089414.6094524125
Rt9481 T1488 T2136 4058869.3423673613
Rt9482 T1489 T1511 4543716.1277007442
Rt9483 T1489 T1781 5126312.8882110203
Rt9484 T1489 T1782 576079262.7972554
Rt9485 T1489 T2678 1427641.7547125006
Rt9486 T1489 T3361 1071897.7302399341
Gcorr3312 T1489 T3362 T1489 T3362 -1.8791666427132429e-07
Rt9487 T1489 T3363 4967064.8399538202
Rt9488 T1489 T3366 2498695.7361379992
Gcorr3313 T1489 T3970 T1489 T3970 -4.264104840601363e-07
Rt9489 T1490 T1524 4571321.6481477013
Rt9490 T1490 T1543 4546472.454227265
Rt9491 T1490 T1546 4691023.4709080113
Rt9492 T1490 T2537 19643854.823908638
Gcorr3314 T1490 T3296 T1490 T3296 -8.7735966189646807e-09
Rt9493 T1490 T3298 2355444.2966751964
Rt9494 T1490 T3300 1480290.5234431776
Gcorr3315 T1490 T3301 T1490 T3301 -1.1497284832196249e-07
Rt9495 T1491 T2053 75835792.126537293
Rt9496 T1491 T2170 10093374.859036004
Rt9497 T1491 T2500 3897859.1285107518
Rt9498 T1491 T2515 1302971.8406196027
Rt9499 T1491 T3238 1380429.7001472497
Gcorr3316 T1491 T3240 T1491 T3240 -1.1595378185614974e-07
Rt9500 T1491 T3241 2945972.269862229
Gcorr3317 T1491 T3622 T1491 T3622 -3.7273922250545455e-07
Rt9501 T1492 T1493 10115535.898607731
Rt9502 T1492 T1494 4097310.8742152015
Rt9503 T1492 T1509 11333928.87366044
Rt9504 T1492 T2419 3911987.0825384618
Rt9505 T1492 T3410 2339269.8197461953
Gcorr3318 T1492 T3412 T1492 T3412 -8.6217982402581815e-08
Gcorr3319 T1492 T3413 T1492 T3413 -1.1044906648013135e-07
Rt9506 T1492 T3707 3759310.6491934834
Rt9507 T1493 T1494 4054086.4647943554
Rt9508 T1493 T1495 4111409.6945150602
Rt9509 T1493 T2043 10904532.75794325
Rt9510 T1493 T2096 3925411.711001812
Rt9511 T1493 T2856 2307173.0282874331
Gcorr3320 T1493 T3409 T1493 T3409 -8.3070661210997486e-08
Rt9512 T1493 T3410 4149451.4866331178
Gcorr3321 T1493 T3411 T1493 T3411 -1.0737241622844091e-07
Rt9513 T1494 T1495 10184237.267495524
Rt9514 T1494 T1496 3831938.7979358085
Rt9515 T1494 T1851 4255862.9987299396
Rt9516 T1494 T2419 9864379.6685198955
Gcorr3322 T1494 T3410 T1494 T3410 -8.8693764345790405e-08
Rt9517 T1494 T3411 2279743.3571605999
Rt9518 T1494 T3413 3943329.8313301727
Gcorr3323 T1494 T3414 T1494 T3414 -1.1158218443519799e-07
Rt9519 T1495 T1496 3995857.9515081812
Rt9520 T1495 T1497 4086782.9281582329
Rt9521 T1495 T1691 9614517.9648477267
Rt9522 T1495 T2043 3889535.3219270715
Gcorr3324 T1495 T2856 T1495 T2856 -9.7142083490011796e-08
Rt9523 T1495 T3411 4290594.078046957
Gcorr3325 T1495 T3415 T1495 T3415 -1.1300350556073362e-07
Rt9524 T1495 T3592 2165651.5063062608
Rt9525 T1496 T1497 10740664.987944147
Rt9526 T1496 T1498 3954378.2287194543
Rt9527 T1496 T1851 11737582.532056358
Rt9528 T1496 T2447 3878447.7901142477
Gcorr3326 T1496 T3411 T1496 T3411 -8.6065578183634588e-08
Rt9529 T1496 T3414 3578960.4379841434
Rt9530 T1496 T3415 2385056.2594211432
Gcorr3327 T1496 T3416 T1496 T3416 -1.1144372776062351e-07
Rt9531 T1497 T1498 4057434.7408085619
Rt9532 T1497 T1499 4342422.4461924359
Rt9533 T1497 T1691 4456462.9009178691
Rt9534 T1497 T2010 4391591.0957023902
Gcorr3328 T1497 T2854 T1497 T2854 -1.1305865834472439e-07
Rt9535 T1497 T3415 3466837.8391347062
Gcorr3329 T1497 T3592 T1497 T3592 -1.0717977770127113e-07
Rt9536 T1497 T3600 37069834.954305269
Rt9537 T1497 T3818 2446024.1480412274
Rt9538 T1498 T1499 11006260.301920112
Rt9539 T1498 T1584 3101020.8790183277
Rt9540 T1498 T1651 4277385.4588757353
Rt9541 T1498 T2447 9771407.5044131707
Gcorr3330 T1498 T3415 T1498 T3415 -8.5413284212495787e-08
Rt9542 T1498 T3416 3272368.2113433238
Gcorr3331 T1498 T3419 T1498 T3419 -1.5422480155725489e-07
Rt9543 T1498 T3600 2205397.9590641912
Rt9544 T1499 T1584 4959299.132148074
Rt9545 T1499 T1585 11541239.219522772
Rt9546 T1499 T1829 567773.2566732961
Rt9547 T1499 T2010 9651317.8280805144
Rt9548 T1499 T2854 3622570.9199339678
Rt9549 T1499 T3600 9150229.683921596
Gcorr3332 T1499 T3615 T1499 T3615 -1.9028540403843805e-06
Rt9550 T1499 T4063 494495.27445102012
Rt9551 T1500 T2032 3678893.2127179303
Rt9552 T1500 T2161 4443829.9076949861
Rt9553 T1500 T2188 4123206.7206762354
Rt9554 T1500 T2213 8942840.9206590466
Rt9555 T1501 T1502 4304357.5557597484
Rt9556 T1501 T1602 4446980.729664648
Rt9557 T1501 T1675 85041227.53570269
Rt9558 T1501 T2560 3397623.3240076466
Rt9559 T1501 T2969 2855525.9253372368
Gcorr3333 T1501 T2970 T1501 T2970 -1.1866546781194038e-07
Rt9560 T1501 T2971 4911174.5011548903
Rt9561 T1501 T4060 3934352.9643962379
Rt9562 T1502 T1602 4155364.5487004127
Rt9563 T1502 T1666 21357689.080548424
Rt9564 T1502 T1667 5589241.8580169659
Gcorr3334 T1502 T1876 T1502 T1876 -3.420579659708526e-08
Rt9565 T1502 T2614 3734323.5275678732
Rt9566 T1502 T2970 2694148.9167030393
Rt9567 T1502 T2971 102638788.44050461
Rt9568 T1502 T2972 1907661.2022157381
Gcorr3335 T1502 T3161 T1502 T3161 -1.1685741004281755e-08
Rt9569 T1503 T1533 1896316.8475357147
Rt9570 T1503 T1995 1270653.9213958064
Rt9571 T1503 T2094 5456588.6568088448
Rt9572 T1503 T2446 1741019.5429239885
Gcorr3336 T1503 T2807 T1503 T2807 -4.9759526292558909e-07
Rt9573 T1503 T2875 456382.59847959719
Gcorr3337 T1503 T3729 T1503 T3729 -1.4865972767903277e-07
Gcorr3338 T1503 T3730 T1503 T3730 -7.5530227022763592e-08
Gcorr3339 T1503 T3731 T1503 T3731 -6.5250021953035025e-07
Rt9574 T1504 T1763 4559111.3540567616
Rt9575 T1504 T1908 55488560.128781505
Rt9576 T1504 T1938 5869887.0264586601
Rt9577 T1504 T2381 4614807.1575164795
Rt9578 T1504 T3275 4678231.1318106232
Rt9579 T1504 T3276 4064455.2437507901
Rt9580 T1504 T3277 1348303.0303703197
Rt9581 T1504 T3871 175290037.52269161
Rt9582 T1505 T1506 3960806.232957691
Rt9583 T1505 T1507 11525913.976963257
Rt9584 T1505 T1757 5090805.2884205012
Rt9585 T1505 T2481 12604812.975168789
Rt9586 T1505 T3155 5421792.9296268644
Rt9587 T1505 T3217 4821359.534103944
Rt9588 T1505 T3218 2527898.4384972882
Gcorr3340 T1505 T3665 T1505 T3665 -1.5460899578572988e-07
Rt9589 T1506 T1580 4709346.7750937371
Rt9590 T1506 T1581 11255577.088930121
Rt9591 T1506 T1609 1155219.740843842
Rt9592 T1506 T2481 13859227.578726728
Rt9593 T1506 T3218 1956476.8133179289
Gcorr3341 T1506 T3583 T1506 T3583 -5.1752819107019733e-07
Rt9594 T1506 T3584 2225340.0898695104
Rt9595 T1506 T3665 7898824.4334976673
Rt9596 T1507 T1757 13242296.252252867
Rt9597 T1507 T1858 4647818.0646857331
Rt9598 T1507 T2466 2875469.798328917
Rt9599 T1507 T2467 15546493.042477945
Gcorr3342 T1507 T3153 T1507 T3153 -3.9044472207855712e-08
Rt9600 T1507 T3154 5532170.0589658935
Rt9601 T1507 T3155 1638230.7596006829
Rt9602 T1508 T1998 5090499.6215596469
Rt9603 T1508 T2205 4182542.3859821553
Rt9604 T1508 T2212 4499402.3121947795
Rt9605 T1508 T2312 9859525.5412378963
Rt9606 T1509 T1510 11809383.785914203
Rt9607 T1509 T1688 3364844.8722707471
Rt9608 T1509 T1888 7765310.7372493763
Rt9609 T1509 T2419 4018265.0348556838
Rt9610 T1509 T3403 30242928.019866079
Rt9611 T1509 T3707 2297733.5299553075
Rt9612 T1509 T4068 4748872.9631024599
Gcorr3343 T1509 T4126 T1509 T4126 -3.2730838139651287e-08
Rt9613 T1510 T1688 3108790.0109418402
Rt9614 T1510 T1689 4568234.7714485619
Rt9615 T1510 T2290 3579861.5872095986
Rt9616 T1510 T2291 10135821.137182405
Rt9617 T1510 T3679 2393566.2742757965
Gcorr3344 T1510 T3921 T1510 T3921 -1.1262496442280309e-07
Rt9618 T1510 T4068 2655718.7433949509
Rt9619 T1511 T1755 4944689.2630538167
Rt9620 T1511 T1756 7482729.5397338895
Rt9621 T1511 T1781 5003739.4734849026
Rt9622 T1511 T2472 6320217.4460905185
Rt9623 T1511 T3362 4287641.3132239906
Rt9624 T1511 T3363 2394707.3591642738
Rt9625 T1511 T3364 2007125.8526629722
Gcorr3345 T1511 T3365 T1511 T3365 -1.4265336172268169e-07
Rt9626 T1512 T1513 12618753.59645891
Rt9627 T1512 T1574 100113594.72395241
Rt9628 T1512 T2019 574738254.95774734
Rt9629 T1512 T2626 14693095.718543826
Rt9630 T1512 T2725 850240.88771483721
Rt9631 T1512 T3150 2030171.4793433961
Gcorr3346 T1512 T3152 T1512 T3152 -1.3867111600165307e-07
Rt9632 T1512 T3668 1202318.9480521332
Gcorr3347 T1512 T4086 T1512 T4086 -6.013347960491803e-07
Rt9633 T1513 T1574 3383025.7394056665
Rt9634 T1513 T1575 3850744.4229500638
Rt9635 T1513 T1826 3744134.8387508579
Gcorr3348 T1513 T2467 T1513 T2467 -5.8638830164762935e-08
Gcorr3349 T1513 T3128 T1513 T3128 -1.773609207452199e-07
Rt9636 T1513 T3129 4190725.4361326271
Rt9637 T1513 T3150 1921108.7894999832
Rt9638 T1513 T3151 3448688.3915121225
Rt9639 T1514 T1515 4934301.7246756731
Rt9640 T1514 T1668 5555451.7309177853
Rt9641 T1514 T1855 1863110.0452896859
Rt9642 T1514 T2717 2846992.2290564827
Gcorr3350 T1514 T3261 T1514 T3261 -2.7395973944457139e-07
Rt9643 T1514 T3263 558759.38988223835
Rt9644 T1514 T3264 6135189.4069231497
Rt9645 T1514 T3265 8043664.4718614686
Gcorr3351 T1514 T3267 T1514 T3267 -5.0958440902483431e-07
Gcorr3352 T1514 T4003 T1514 T4003 -1.2043458125217526e-07
Rt9646 T1515 T1668 61752584.911898851
Rt9647 T1515 T1711 4882010.027387497
Rt9648 T1515 T2381 2895736.5230745077
Rt9649 T1515 T3264 2314680.9902815442
Rt9650 T1515 T3265 1968517.2963118125
Rt9651 T1515 T3266 3589932.5394192887
Rt9652 T1516 T2101 3305415.7188673746
Rt9653 T1516 T2102 4685751.4402446952
Rt9654 T1516 T2103 4957371.0686299168
Rt9655 T1516 T2362 10477251.092905968
Rt9656 T1516 T2832 11885523.107148109
Rt9657 T1516 T3579 2580140.2393786693
Rt9658 T1516 T4065 6399361.0808926439
Rt9659 T1517 T2091 5511439.3636364965
Rt9660 T1517 T2097 5598617.089397761
Rt9661 T1517 T2158 3698534.40179139
Rt9662 T1517 T2246 1674632.8933083906
Rt9663 T1518 T1519 14660822.547934208
Rt9664 T1518 T1639 1609809.5436854649
Rt9665 T1518 T1712 10101611.33444858
Rt9666 T1518 T1878 3917407.505237828
Rt9667 T1518 T3235 2008445.8070012161
Rt9668 T1518 T3236 96445031.522278741
Rt9669 T1518 T3758 1666952.9585252369
Gcorr3353 T1518 T3980 T1518 T3980 -4.973336158164441e-07
Rt9670 T1518 T4162 16207782.480599729
Rt9671 T1519 T1520 13329075.17113702
Rt9672 T1519 T1521 5840630.4162388323
Rt9673 T1519 T1639 4187164.0367332278
Rt9674 T1519 T2041 4187059.621148922
Rt9675 T1519 T3078 2980309.8825598075
Rt9676 T1519 T3149 10988090.269327724
Rt9677 T1519 T3235 684021.60690715432
Gcorr3354 T1519 T3980 T1519 T3980 -1.0239585472266842e-07
Gcorr3355 T1519 T4162 T1519 T4162 -1.0604717280701394e-06
Rt9678 T1520 T1521 14065276.179974021
Rt9679 T1520 T1522 895191.67044221668
Rt9680 T1520 T1672 38301257.624804392
Rt9681 T1520 T2531 3982621.794727304
Gcorr3356 T1520 T3021 T1520 T3021 -6.0243109066322686e-07
Rt9682 T1520 T3022 2595598.1257452178
Rt9683 T1520 T3078 768594.24822306447
Gcorr3357 T1520 T3079 T1520 T3079 -1.5390036525586321e-07
Rt9684 T1521 T1522 961796.54767691193
Rt9685 T1521 T1629 25508601.731669903
Gcorr3358 T1521 T1861 T1521 T1861 -1.2397956406497936e-08
Rt9686 T1521 T2041 11582465.567953115
Rt9687 T1521 T2708 3307057.1945104334
Gcorr3359 T1521 T3021 T1521 T3021 -6.7050020759605082e-07
Rt9688 T1521 T3078 2520564.9827046068
Rt9689 T1521 T3098 863455.13036590698
Rt9690 T1521 T3149 26371878.944871616
Rt9691 T1522 T1629 3447880.1920892
Rt9692 T1522 T1630 14820246.92939675
Rt9693 T1522 T1672 1665174.2592009334
Rt9694 T1522 T2586 8845971.4671534691
Rt9695 T1522 T3021 357309.64980678889
Gcorr3360 T1522 T3022 T1522 T3022 -4.6421032760276344e-07
Gcorr3361 T1522 T3078 T1522 T3078 -5.8363464202581544e-07
Gcorr3362 T1522 T3098 T1522 T3098 -6.6084105137968033e-07
Rt9696 T1523 T1545 4942924.6615576232
Rt9697 T1523 T1784 3324437.4820807585
Rt9698 T1523 T1811 4256372.0819544625
Rt9699 T1523 T2077 8343622.7529937346
Gcorr3363 T1523 T3739 T1523 T3739 -1.4662863647682112e-07
Rt9700 T1524 T1546 14418814.054024983
Rt9701 T1524 T2243 2676248.5235755895
Rt9702 T1524 T2433 3615837.1534722499
Rt9703 T1524 T2710 4149552.1016869941
Gcorr3364 T1524 T3293 T1524 T3293 -1.6833512444295096e-07
Rt9704 T1524 T3296 1321935.2288415676
Rt9705 T1524 T3297 3667778.0430412153
Rt9706 T1524 T3298 21149739.862588711
Rt9707 T1525 T1685 3213421.0911915353
Rt9708 T1525 T1850 16868767.006993387
Gcorr3365 T1525 T1990 T1525 T1990 -5.635959738740426e-08
Rt9709 T1525 T2338 3008773.7690284136
Rt9710 T1525 T3303 3661257.0406641494
Rt9711 T1525 T3306 4430146.8823309233
Rt9712 T1525 T3308 3157371.7311445023
Rt9713 T1526 T1527 10482191.787512206
Rt9714 T1526 T1673 2873221.398841022
Rt9715 T1526 T1842 4763695.6929878965
Rt9716 T1526 T2233 4693867.078491942
Rt9717 T1526 T2769 13240579.938834762
Rt9718 T1526 T3652 6687939.2162480187
Rt9719 T1527 T1673 1716177.8337875481
Rt9720 T1527 T1701 10417143.630007725
Rt9721 T1527 T1703 1703895.2638277034
Rt9722 T1527 T2127 10382221.686309082
Rt9723 T1528 T2151 1809861.4412856027
Rt9724 T1528 T2206 9679315.1200283729
Rt9725 T1528 T2344 1570979.0281231815
Rt9726 T1528 T2470 3358424.3321204176
Rt9727 T1529 T1530 13053102.331867453
Rt9728 T1529 T1895 4795497.9184856592
Rt9729 T1529 T2509 4955881.8461759351
Rt9730 T1529 T2534 581700.49024613295
Rt9731 T1529 T2791 592915.41421565833
Gcorr3366 T1529 T3568 T1529 T3568 -7.9470427700221633e-08
Gcorr3367 T1529 T3852 T1529 T3852 -1.2995864203026407e-07
Gcorr3368 T1529 T4173 T1529 T4173 -1.3085174389663132e-06
Rt9732 T1529 T4180 3785777.9271302302
Rt9733 T1530 T1692 4639078.2929183058
Rt9734 T1530 T1693 4770738.0768144578
Rt9735 T1530 T2347 1232225.2421404759
Rt9736 T1530 T2534 3346849.4523424995
Rt9737 T1530 T2791 8773719.2234006133
Rt9738 T1530 T4173 6076827.0599581841
Rt9739 T1531 T2427 9404495.8220260106
Rt9740 T1531 T2570 3548930.4067279752
Rt9741 T1531 T2571 36237878.098534904
Rt9742 T1531 T2640 3248510.4756811126
Rt9743 T1531 T3096 3541450.8630614243
Rt9744 T1531 T3097 4049194.8574928646
Rt9745 T1531 T3119 9270041.3080017418
Rt9746 T1532 T1704 4124676.0507287243
Rt9747 T1532 T1778 4929802.6756969802
Rt9748 T1532 T1785 4419681.2755479179
Rt9749 T1532 T2597 5782755.2102804696
Rt9750 T1533 T1804 3599209.616335562
Rt9751 T1533 T1805 1429328.5868243107
Rt9752 T1533 T1995 3139266.1535887271
Rt9753 T1533 T2552 4028293.2282263464
Rt9754 T1533 T2807 530237.38786873827
Gcorr3369 T1533 T2808 T1533 T2808 -6.0846096479960581e-07
Gcorr3370 T1533 T2809 T1533 T2809 -8.467173936851141e-09
Gcorr3371 T1533 T2875 T1533 T2875 -2.4384910232759706e-07
Gcorr3372 T1533 T3731 T1533 T3731 -1.4083575850419354e-08
Rt9755 T1534 T2119 10869736.895414742
Rt9756 T1534 T2244 13931115.197524291
Rt9757 T1534 T2254 3038686.9613525644
Rt9758 T1534 T2501 4255890.5435844809
Rt9759 T1535 T1536 3647276.5694374377
Rt9760 T1535 T1537 4949234.5001793131
Rt9761 T1535 T1916 4372776.2825119216
Rt9762 T1535 T1917 3354025.1170096318
Rt9763 T1535 T3181 5200708.8664526856
Gcorr3373 T1535 T3191 T1535 T3191 -2.0365630751955937e-08
Rt9764 T1535 T3196 1520895.5306713562
Gcorr3374 T1535 T3342 T1535 T3342 -6.8295525621500964e-08
Gcorr3375 T1535 T3838 T1535 T3838 -8.9318484741305264e-08
Rt9765 T1536 T1537 10556104.087467032
Rt9766 T1536 T1538 950249.89031068434
Rt9767 T1536 T1539 2555356.3768556658
Rt9768 T1536 T2476 7478494.0617300412
Gcorr3376 T1536 T3181 T1536 T3181 -1.0245785074343566e-07
Rt9769 T1536 T3182 22746384.205420863
Rt9770 T1536 T3191 479789.37176724611
Gcorr3377 T1536 T3997 T1536 T3997 -1.3196522416579732e-06
Rt9771 T1537 T1538 2832376.936163778
Rt9772 T1537 T1540 13831713.698198961
Rt9773 T1537 T1765 3426315.1163224024
Rt9774 T1537 T1916 4808492.7552090958
Gcorr3378 T1537 T2884 T1537 T2884 -1.26474180592005e-07
Rt9775 T1537 T3191 5454846.5774781778
Rt9776 T1537 T3645 2157686.2228629165
Rt9777 T1537 T3838 2850686.8258360927
Gcorr3379 T1537 T3997 T1537 T3997 -2.5483440347147913e-07
Rt9778 T1538 T1539 2219515.2439975715
Rt9779 T1538 T1540 4658844.2190021062
Rt9780 T1538 T1541 11277006.873915642
Rt9781 T1538 T2438 2121562.577532148
Gcorr3380 T1538 T3191 T1538 T3191 -1.3033946638183991e-06
Gcorr3381 T1538 T3192 T1538 T3192 -4.7780177843574286e-07
Rt9782 T1538 T3490 13816001.234034596
Gcorr3382 T1538 T3645 T1538 T3645 -1.5072218271160497e-07
Rt9783 T1538 T3997 401879.0549792145
Gcorr3383 T1539 T2318 T1539 T2318 -4.4824211607495771e-08
Rt9784 T1539 T2438 2582052.214860735
Rt9785 T1539 T2476 2956834.6270029894
Rt9786 T1539 T2520 1208885.0469522795
Rt9787 T1539 T3182 11345011.912681038
Gcorr3384 T1539 T3191 T1539 T3191 -1.3446948473764094e-07
Rt9788 T1539 T3192 573566.77764420188
Gcorr3385 T1539 T3193 T1539 T3193 -3.3050454611499206e-07
Gcorr3386 T1539 T3194 T1539 T3194 -1.5184675918012671e-07
Gcorr3387 T1539 T3997 T1539 T3997 -2.9891375904855134e-07
Rt9789 T1540 T1541 4723040.9148182506
Rt9790 T1540 T1542 11445300.941399986
Rt9791 T1540 T1765 4425297.7526055276
Rt9792 T1540 T1952 4016383.0341181997
Gcorr3388 T1540 T3490 T1540 T3490 -8.5781567946055332e-08
Gcorr3389 T1540 T3644 T1540 T3644 -5.5671806982213948e-08
Rt9793 T1540 T3645 3345799.1509774271
Rt9794 T1540 T4070 2520483.768897749
Rt9795 T1541 T1542 4358668.5011336943
Rt9796 T1541 T1547 9540007.0021715313
Rt9797 T1541 T1603 3937385.2176964134
Rt9798 T1541 T2438 3634700.1895574569
Gcorr3390 T1541 T3195 T1541 T3195 -6.3856161219113779e-08
Rt9799 T1541 T3489 4847135.7961421758
Rt9800 T1541 T3490 1936788.7888213014
Gcorr3391 T1541 T4070 T1541 T4070 -9.468284376440953e-08
Rt9801 T1542 T1547 10426013.569879562
Rt9802 T1542 T1548 3592949.6861008084
Rt9803 T1542 T1952 5900958.8530705385
Rt9804 T1542 T1977 4410477.0309941974
Rt9805 T1542 T2749 4040015.2126282584
Rt9806 T1542 T3489 5229047.751506309
Gcorr3392 T1542 T3630 T1542 T3630 -7.3358682932472763e-08
Rt9807 T1542 T4070 5979093.4287827928
Rt9808 T1543 T1850 7867005.7462100657
Rt9809 T1543 T2338 3024494.4861738738
Rt9810 T1543 T2525 12801911.226244202
Rt9811 T1543 T2537 3457259.2805521949
Rt9812 T1543 T3300 35520421.370252132
Rt9813 T1543 T3301 2233692.1997001749
Rt9814 T1543 T3302 1198828.7384594702
Gcorr3393 T1543 T3303 T1543 T3303 -1.3582054678697622e-07
Rt9815 T1544 T1841 27070955.844617177
Rt9816 T1544 T1843 4174268.3858544827
Gcorr3394 T1544 T2072 T1544 T2072 -5.0599912099482632e-08
Rt9817 T1544 T2613 2197584.1129365666
Gcorr3395 T1544 T2867 T1544 T2867 -1.5510259329124957e-07
Rt9818 T1544 T2905 1557094.6051796847
Rt9819 T1544 T2949 3946168.3325017067
Rt9820 T1544 T2960 2885088.0383516778
Rt9821 T1545 T1674 11590288.898709375
Rt9822 T1545 T1811 3645045.0896379664
Rt9823 T1545 T1812 4928771.3846568149
Rt9824 T1545 T2631 3271227.5610284265
Rt9825 T1546 T1967 52716839.877690591
Gcorr3396 T1546 T1976 T1546 T1976 -5.1199274216066804e-08
Rt9826 T1546 T2243 10311974.307889389
Gcorr3397 T1546 T2402 T1546 T2402 -3.2774325855040208e-08
Rt9827 T1546 T2537 3132141.0344254891
Rt9828 T1546 T3295 2224390.1934811957
Rt9829 T1546 T3296 1631210.0789644592
Gcorr3398 T1546 T3300 T1546 T3300 -6.6191770059260398e-08
Rt9830 T1546 T3601 1020770.3256291649
Rt9831 T1547 T1548 4023599.5754830055
Rt9832 T1547 T1549 10612389.704205997
Rt9833 T1547 T1603 3767940.3064417788
Rt9834 T1547 T2316 3235580.7691972437
Gcorr3399 T1547 T3225 T1547 T3225 -1.4123452598656284e-07
Rt9835 T1547 T3489 1992870.7781083968
Rt9836 T1547 T3751 6015203.8948843069
Rt9837 T1548 T1549 4730890.416314193
Rt9838 T1548 T1550 9464238.297796784
Rt9839 T1548 T1670 1366680.7519730949
Rt9840 T1548 T1977 13179827.563053638
Rt9841 T1548 T2883 4461398.8496195655
Gcorr3400 T1548 T3489 T1548 T3489 -1.3187762391083085e-07
Rt9842 T1548 T3630 1140415.0881768821
Rt9843 T1548 T3751 10837138.120668298
Rt9844 T1549 T1550 3222438.3710155017
Rt9845 T1549 T1551 11102746.877182931
Rt9846 T1549 T2284 4114698.9815512053
Rt9847 T1549 T2316 2284061.3548350483
Gcorr3401 T1549 T2883 T1549 T2883 -1.2405174947807322e-07
Gcorr3402 T1549 T3225 T1549 T3225 -2.8500795168891107e-07
Rt9848 T1549 T3555 3273636.5976921599
Rt9849 T1549 T3751 1696964.0202893591
Rt9850 T1550 T1551 1323742.695891835
Rt9851 T1550 T1552 4578514.2057968788
Rt9852 T1550 T1670 1446288.3001495542
Rt9853 T1550 T2204 9619058.3952872697
Rt9854 T1550 T2883 710120.72325727576
Gcorr3403 T1550 T3555 T1550 T3555 -5.4512042305910538e-07
Gcorr3404 T1550 T3641 T1550 T3641 -9.569054289406641e-08
Rt9855 T1551 T1552 10622623.517300423
Rt9856 T1551 T1656 4181741.509125533
Rt9857 T1551 T1783 3488640.9684690069
Rt9858 T1551 T2284 11062899.429084506
Gcorr3405 T1551 T2883 T1551 T2883 -5.4687058842803692e-07
Gcorr3406 T1551 T3498 T1551 T3498 -5.0873824522463891e-08
Rt9859 T1551 T3555 1405088.9726833464
Rt9860 T1551 T3641 2847017.1820516326
Rt9861 T1552 T1656 3695132.6883935202
Rt9862 T1552 T1657 4733121.9353749594
Rt9863 T1552 T1790 10935429.377882399
Rt9864 T1552 T2204 3466209.4923764169
Rt9865 T1552 T3641 3022943.8102434552
Gcorr3407 T1552 T3813 T1552 T3813 -1.0444396425359474e-07
Rt9866 T1553 T1554 3962287.6162300427
Rt9867 T1553 T2133 1571809.3469161715
Rt9868 T1553 T2134 1950128.0830486943
Rt9869 T1553 T2302 2441401.4449290433
Gcorr3408 T1553 T2742 T1553 T2742 -1.2387951560188129e-07
Gcorr3409 T1553 T3554 T1553 T3554 -4.1485101008606003e-07
Rt9870 T1553 T3647 4598619.7194311479
Gcorr3410 T1553 T3711 T1553 T3711 -5.0666286939465281e-07
Gcorr3411 T1553 T3954 T1553 T3954 -1.7114176000542833e-07
Rt9871 T1553 T4160 684307.48836551257
Rt9872 T1554 T1555 9780668.6345616914
Rt9873 T1554 T1556 2971220.5599077353
Rt9874 T1554 T1557 2138507.3419301207
Rt9875 T1554 T2302 1523660.3552432626
Gcorr3412 T1554 T3033 T1554 T3033 -1.9634455248571124e-07
Rt9876 T1554 T3407 4200874.3974999068
Gcorr3413 T1554 T3647 T1554 T3647 -1.0360947859846185e-07
Rt9877 T1554 T3954 702317.45057869144
Gcorr3414 T1554 T4138 T1554 T4138 -7.4661458308642218e-07
Gcorr3415 T1554 T4164 T1554 T4164 -1.5308182977585413e-07
Rt9878 T1555 T1556 2349800.3851570981
Rt9879 T1555 T1558 2567646.493421963
Rt9880 T1555 T1796 5513923.1538712373
Rt9881 T1555 T2140 5136526.4146766029
Rt9882 T1555 T3407 1008379.2227383201
Gcorr3416 T1555 T4164 T1555 T4164 -5.4493237152057445e-07
Rt9883 T1556 T1557 9407441.1682651062
Rt9884 T1556 T1558 4579252.9280046504
Rt9885 T1556 T1559 4725877.5989439143
Rt9886 T1556 T2190 9902713.9206728376
Rt9887 T1556 T2850 14775116.5504549
Rt9888 T1556 T3033 15973074.451202992
Gcorr3417 T1556 T3407 T1556 T3407 -5.2936312877411425e-07
Rt9889 T1556 T4164 1150165.9175333644
Rt9890 T1557 T1559 4363333.6083152201
Rt9891 T1557 T1560 15757516.832234586
Rt9892 T1557 T2302 9240390.8906278331
Rt9893 T1557 T2543 2319830.3770048055
Rt9894 T1557 T3033 2003495.4595668972
Gcorr3418 T1557 T3553 T1557 T3553 -2.8778669739260321e-07
Gcorr3419 T1557 T3954 T1557 T3954 -3.4248401961575738e-07
Rt9895 T1557 T4040 3819853.6743651452
Rt9896 T1557 T4138 2769780.1999057312
Rt9897 T1558 T1796 4678449.8415432926
Rt9898 T1558 T1797 3206151.660030887
Rt9899 T1558 T1833 8762710.3154124748
Rt9900 T1558 T2190 2774167.689823539
Gcorr3420 T1558 T2822 T1558 T2822 -1.8058552456002289e-07
Rt9901 T1558 T2823 1262513.5443635739
Gcorr3421 T1558 T2850 T1558 T2850 -1.6909593495352986e-07
Gcorr3422 T1558 T3407 T1558 T3407 -1.9208091282275554e-07
Rt9902 T1558 T4164 8919915.8079411071
Rt9903 T1559 T1560 3592319.7029791484
Rt9904 T1559 T1561 2730658.6538201799
Rt9905 T1559 T1563 2053404.3145405911
Rt9906 T1559 T2190 3744427.0527397869
Rt9907 T1559 T2850 12154366.208444571
Gcorr3423 T1559 T2851 T1559 T2851 -1.9423030982205063e-07
Rt9908 T1559 T2852 792435.05691112904
Gcorr3424 T1559 T2889 T1559 T2889 -4.4852052879031044e-07
Rt9909 T1559 T3033 30644244.121629544
Gcorr3425 T1559 T4040 T1559 T4040 -1.4109326192349172e-07
Rt9910 T1560 T1561 4720315.9810147891
Rt9911 T1560 T1562 16528105.38989971
Rt9912 T1560 T1600 2676292.5561080747
Rt9913 T1560 T2543 1438221.7921664284
Gcorr3426 T1560 T2852 T1560 T2852 -1.0520374175403739e-07
Rt9914 T1560 T2890 1933812.8579300756
Gcorr3427 T1560 T2936 T1560 T2936 -1.504708324649889e-07
Gcorr3428 T1560 T3553 T1560 T3553 -4.182720472767098e-07
Rt9915 T1560 T4040 1153294.8751246398
Rt9916 T1561 T1562 4960018.8350564968
Rt9917 T1561 T1563 9639576.368444398
Rt9918 T1561 T1564 2892260.862085918
Rt9919 T1561 T2326 32043522.875144809
Gcorr3429 T1561 T2852 T1561 T2852 -1.7947914582011767e-07
Rt9920 T1561 T2889 975213.01771072729
Rt9921 T1561 T2890 4753890.4730799822
Gcorr3430 T1561 T2934 T1561 T2934 -1.5369159181237807e-07
Rt9922 T1562 T1564 13917536.381423736
Rt9923 T1562 T1565 7082960.8274649344
Rt9924 T1562 T1600 1393515.8866802445
Rt9925 T1562 T2529 24037994.90457968
Rt9926 T1562 T2890 1560604.5652786
Rt9927 T1562 T2934 4818780.5872205561
Rt9928 T1562 T2935 1477955.9005009166
Gcorr3431 T1562 T2936 T1562 T2936 -4.5178947189944632e-07
Rt9929 T1563 T2190 21703872.025161415
Rt9930 T1563 T2325 5717066.992821523
Rt9931 T1563 T2326 5891162.7172930306
Rt9932 T1563 T2639 2531682.1655160235
Rt9933 T1563 T2851 1582543.4222630085
Gcorr3432 T1563 T2852 T1563 T2852 -4.3805501815989851e-07
Rt9934 T1563 T2889 3343924.5653162622
Gcorr3433 T1563 T3791 T1563 T3791 -6.5251888776926927e-08
Rt9935 T1563 T4038 3949089.0404574233
Rt9936 T1564 T1565 3201108.6896873638
Rt9937 T1564 T1566 8223441.3816415574
Rt9938 T1564 T1899 12167596.449864684
Rt9939 T1564 T2326 5212760.0901765581
Gcorr3434 T1564 T2889 T1564 T2889 -2.3614847107454673e-07
Rt9940 T1564 T2934 807381.04757101589
Rt9941 T1564 T2943 4389796.4068694161
Rt9942 T1564 T3041 3191484.6261852719
Gcorr3435 T1564 T4001 T1564 T4001 -1.0585305450324644e-07
Rt9943 T1565 T1566 43377302.413973443
Rt9944 T1565 T1567 5117643.4012960084
Gcorr3436 T1565 T1758 T1565 T1758 -9.1448903627003903e-08
Rt9945 T1565 T2529 3398826.3072188008
Gcorr3437 T1565 T2934 T1565 T2934 -2.0311731943210454e-07
Rt9946 T1565 T2935 3378211.7467650552
Rt9947 T1565 T3001 2255136.1708644154
Rt9948 T1565 T4001 834415.72586695652
Rt9949 T1566 T1567 8377899.2749715103
Rt9950 T1566 T1761 21336132.675945219
Gcorr3438 T1566 T1899 T1566 T1899 -3.3912713621193005e-08
Rt9951 T1566 T2563 2807344.6586040333
Rt9952 T1566 T3041 860137.47192214848
Rt9953 T1566 T3384 27677662.781532705
Rt9954 T1566 T3520 1679464.6065616815
Rt9955 T1566 T4001 3446810.5558968037
Rt9956 T1567 T1758 9028076.8836813197
Rt9957 T1567 T1761 4500529.9069385892
Rt9958 T1567 T1807 510200.21628298052
Rt9959 T1567 T2653 5961373.9859650051
Rt9960 T1567 T3001 2339046.4327668459
Rt9961 T1567 T3520 257720.89989578151
Rt9962 T1567 T3837 2552487.0016126633
Gcorr3439 T1567 T3979 T1567 T3979 -1.9306298812445961e-06
Gcorr3440 T1567 T4001 T1567 T4001 -1.4301893933510318e-07
Rt9963 T1568 T1569 10817864.28844507
Rt9964 T1568 T1847 4707767.8673882261
Rt9965 T1568 T1848 9439769.7330785003
Rt9966 T1568 T2044 5197605.5949135814
Rt9967 T1568 T2761 8685493.5190273207
Rt9968 T1568 T2801 5746354.859738945
Rt9969 T1568 T2802 2917340.5233241203
Gcorr3441 T1568 T2803 T1568 T2803 -1.3186092073232914e-07
Rt9970 T1569 T1847 4212434.2712643659
Rt9971 T1569 T1849 9842817.6353197545
Rt9972 T1569 T1903 4803363.7754406156
Rt9973 T1569 T2452 10090034.822921906
Rt9974 T1569 T2802 5427914.3716800604
Rt9975 T1569 T2804 7077692.1819627378
Rt9976 T1569 T3737 5177105.8487728676
Gcorr3442 T1570 T1985 T1570 T1985 -1.5452154101911847e-07
Gcorr3443 T1570 T2409 T1570 T2409 -1.2799344124517883e-07
Rt9977 T1570 T2476 3503110.9588422393
Rt9978 T1570 T2477 2946656.0333191054
Rt9979 T1570 T2727 1832362.7141036687
Rt9980 T1570 T3180 957987.11820532067
Rt9981 T1570 T3508 2442798.9396531852
Gcorr3444 T1570 T4059 T1570 T4059 -6.717779146430126e-08
Rt9982 T1571 T1572 3903639.3415354919
Rt9983 T1571 T1573 11209172.467677809
Rt9984 T1571 T1764 14743115.48186603
Rt9985 T1571 T2573 3483295.6960699167
Gcorr3445 T1571 T3767 T1571 T3767 -1.8337271597318152e-07
Rt9986 T1571 T3769 8709906.5214930624
Rt9987 T1571 T3771 1725015.1046163135
Rt9988 T1571 T3817 19723955.917842567
Rt9989 T1572 T1764 3176832.4655514485
Rt9990 T1572 T1822 17154202.596805003
Rt9991 T1572 T1862 4381388.5317287901
Rt9992 T1572 T2300 1856477.100547753
Rt9993 T1572 T3373 1364143.1618024926
Rt9994 T1572 T3769 2655295.8885411625
Gcorr3446 T1572 T3770 T1572 T3770 -1.0707131507264001e-07
Gcorr3447 T1572 T3772 T1572 T3772 -1.9475931242684158e-07
Gcorr3448 T1572 T3817 T1572 T3817 -9.5815995708356896e-08
Rt9995 T1573 T1593 4841757.750788847
Rt9996 T1573 T1594 4786612.3798506036
Rt9997 T1573 T2573 2330156.41247764
Rt9998 T1573 T2584 2190395.5008516856
Rt9999 T1573 T3586 1050704.7330085707
Rt10000 T1573 T3771 13260835.329576742
Rt10001 T1573 T3919 29753242.432943396
Gcorr3449 T1573 T4010 T1573 T4010 -1.0113031110521761e-07
Gcorr3450 T1573 T4092 T1573 T4092 -4.345800061702625e-07
Rt10002 T1574 T1575 15118423.081251085
Rt10003 T1574 T1576 5687990.3370975284
Rt10004 T1574 T1873 4877289.3355482882
Rt10005 T1574 T1874 17038735.797101051
Rt10006 T1574 T2725 3492916.316024757
Rt10007 T1574 T3128 2073333.6316845573
Rt10008 T1574 T3150 13361561.109875532
Rt10009 T1574 T3335 3019396.7697445028
Gcorr3451 T1574 T3510 T1574 T3510 -1.3293814868525307e-07
Rt10010 T1575 T1576 4323748.0739423279
Rt10011 T1575 T1577 21761522.581611659
Rt10012 T1575 T1826 28179098.015086785
Rt10013 T1575 T2733 3436945.947660577
Rt10014 T1575 T3127 4445498.9991090484
Rt10015 T1575 T3128 3970776.1521430109
Rt10016 T1575 T3129 3094166.9731273293
Rt10017 T1576 T1577 3635845.9367969949
Rt10018 T1576 T1605 21040214.93181631
Rt10019 T1576 T1871 3904422.6147405715
Rt10020 T1576 T1873 4576296.9160682997
Rt10021 T1576 T3126 1586196.7637810332
Gcorr3452 T1576 T3127 T1576 T3127 -1.3959446043750562e-07
Rt10022 T1576 T3128 3770174.4889294934
Rt10023 T1576 T3510 5684162.3260786422
Gcorr3453 T1576 T3917 T1576 T3917 -1.2887212568959188e-07
Rt10024 T1577 T1605 4652700.3998817774
Rt10025 T1577 T1606 17989125.413283799
Rt10026 T1577 T2593 4502499.3249495057
Rt10027 T1577 T2733 4016231.220583769
Rt10028 T1577 T3110 2403338.3255327097
Gcorr3454 T1577 T3126 T1577 T3126 -2.1094955125871753e-08
Rt10029 T1577 T3127 1792152.5536279595
Gcorr3455 T1577 T4141 T1577 T4141 -8.540155819718138e-08
Rt10030 T1578 T2363 3551662.2168065878
Gcorr3456 T1578 T2442 T1578 T2442 -1.302858813335391e-07
Rt10031 T1578 T2550 2104454.0543020656
Rt10032 T1578 T2581 1962304.9425185404
Gcorr3457 T1578 T3040 T1578 T3040 -8.4743545769848842e-08
Rt10033 T1578 T3074 754843.37520408293
Rt10034 T1578 T3589 1137871.5876821678
Gcorr3458 T1578 T3787 T1578 T3787 -1.8822804328861566e-07
Rt10035 T1579 T2114 10537190.003608629
Rt10036 T1579 T2251 1282931.4651642458
Rt10037 T1579 T2359 8423213.0283752624
Rt10038 T1579 T2427 10370485.870721035
Gcorr3459 T1579 T2766 T1579 T2766 -5.2002158602040804e-07
Gcorr3460 T1579 T3234 T1579 T3234 -1.5374578599462203e-07
Rt10039 T1579 T3467 1551185.8154316437
Rt10040 T1579 T3557 2018829.8061440694
Rt10041 T1580 T1581 2657151.4615688287
Rt10042 T1580 T1979 1794304.9660549054
Rt10043 T1580 T1980 10396215.162050979
Rt10044 T1580 T1981 3556162.8039516904
Rt10045 T1580 T2818 1672262.8478089846
Gcorr3461 T1580 T3544 T1580 T3544 -4.4497850104410841e-07
Rt10046 T1580 T3584 6337177.9886956913
Rt10047 T1580 T3665 2372434.0344405477
Rt10048 T1580 T3759 10764085.22869461
Gcorr3462 T1580 T4085 T1580 T4085 -3.0073393592312266e-07
Rt10049 T1581 T1609 4166620.4738526014
Rt10050 T1581 T1610 12414156.845450258
Rt10051 T1581 T1611 4658451.0059704008
Rt10052 T1581 T1981 2847123.0217794017
Rt10053 T1581 T3584 7744783.2457940485
Rt10054 T1581 T3702 13826628.64236268
Gcorr3463 T1581 T3759 T1581 T3759 -5.1894067583853326e-07
Rt10055 T1581 T4085 1162535.7990222357
Rt10056 T1582 T1583 9039068.0531344488
Rt10057 T1582 T1598 5697052.7879241752
Rt10058 T1582 T1897 2720046.0639736452
Rt10059 T1582 T1992 16165544.819985377
Rt10060 T1582 T3121 4217550.8847051309
Rt10061 T1582 T3122 10950041.716914413
Rt10062 T1582 T3143 1689303.4157063931
Gcorr3464 T1582 T3232 T1582 T3232 -1.3096022806155051e-07
Rt10063 T1583 T1598 2424082.6974768261
Rt10064 T1583 T1599 4828094.5039788578
Rt10065 T1583 T1659 5626819.4434275804
Rt10066 T1583 T2439 9920205.2553163432
Gcorr3465 T1583 T3120 T1583 T3120 -1.1229423285790739e-07
Rt10067 T1583 T3122 837728.26850918052
Gcorr3466 T1583 T3144 T1583 T3144 -2.4154626865381245e-07
Rt10068 T1583 T3454 9034404.6900949758
Rt10069 T1583 T3896 7963840.3069280209
Rt10070 T1584 T1585 5038114.0989085082
Rt10071 T1584 T1651 13390335.558104673
Rt10072 T1584 T1686 3890359.530944088
Rt10073 T1584 T2673 8233489.3273575008
Rt10074 T1584 T3419 1793228.044398651
Gcorr3467 T1584 T3511 T1584 T3511 -3.6386532820157019e-08
Gcorr3468 T1584 T3600 T1584 T3600 -9.2047801753454704e-08
Rt10075 T1584 T4063 10821894.890174085
Rt10076 T1585 T1686 4821373.3037622161
Rt10077 T1585 T1829 5833369.7067682473
Rt10078 T1585 T2225 13583716.302346861
Rt10079 T1585 T2677 2505193.0256348103
Rt10080 T1585 T3511 3494073.3813929744
Gcorr3469 T1585 T3615 T1585 T3615 -2.0697550926256518e-08
Rt10081 T1585 T4063 12225890.708249282
Rt10082 T1585 T4152 7937579.758156646
Rt10083 T1586 T1587 3488646.2044547554
Rt10084 T1586 T2265 4155519.4096695101
Rt10085 T1586 T2329 4043634.9757283963
Rt10086 T1586 T2567 18065482.584913623
Rt10087 T1586 T2774 4806249.1829939755
Gcorr3470 T1586 T3488 T1586 T3488 -1.1230520116467153e-07
Rt10088 T1586 T4118 3588852.1792229144
Rt10089 T1587 T1588 8456502.6926786266
Rt10090 T1587 T1637 3888785.0526529783
Rt10091 T1587 T1769 3871569.3949410901
Rt10092 T1587 T2329 8046610.7785520256
Gcorr3471 T1587 T2774 T1587 T2774 -8.0995419302788574e-07
Gcorr3472 T1587 T3201 T1587 T3201 -1.090155361495542e-07
Rt10093 T1587 T3357 10436999.875685221
Rt10094 T1587 T3488 767753.64637527813
Rt10095 T1588 T1637 3361747.0928634801
Rt10096 T1588 T1777 758000.42985413456
Rt10097 T1588 T1866 31330085.515968718
Rt10098 T1588 T2241 4058752.8312502033
Gcorr3473 T1588 T3056 T1588 T3056 -1.0512812808591638e-06
Rt10099 T1588 T3357 641309.77313780494
Gcorr3474 T1588 T3697 T1588 T3697 -1.4170151902163699e-07
Rt10100 T1588 T4161 5694332.4970083209
Rt10101 T1589 T1590 5023932.7090373607
Rt10102 T1589 T2312 1665882.4144371678
Rt10103 T1589 T2380 2399229.613679572
Rt10104 T1589 T2460 11247685.970442766
Gcorr3475 T1589 T2838 T1589 T2838 -4.6921262511793319e-07
Rt10105 T1589 T3398 720851.86861105077
Gcorr3476 T1589 T3528 T1589 T3528 -1.5075306807535259e-07
Rt10106 T1589 T3760 75243029.281478122
Rt10107 T1589 T3851 15531884.484313156
Rt10108 T1590 T1591 4275428.2892461875
Rt10109 T1590 T1592 12392438.65383785
Rt10110 T1590 T1648 3346754.8908876139
Rt10111 T1590 T2460 3317335.7280977196
Gcorr3477 T1590 T2819 T1590 T2819 -1.5999281864775717e-07
Rt10112 T1590 T3466 3160156.7905691247
Rt10113 T1590 T3760 9748744.508850472
Rt10114 T1590 T3851 4548190.4338729633
Rt10115 T1591 T1592 3715272.2900376408
Rt10116 T1591 T2239 5902992.3985734163
Rt10117 T1591 T2323 2735998.0690459786
Rt10118 T1591 T2608 9626592.7932666745
Gcorr3478 T1591 T3222 T1591 T3222 -1.6628627095019085e-07
Rt10119 T1591 T3464 2201474.2448320426
Rt10120 T1591 T3466 3977309.6920969035
Gcorr3479 T1591 T3851 T1591 T3851 -9.2522901625688335e-08
Rt10121 T1591 T4110 12133629.811151708
Rt10122 T1592 T1648 4450125.0357509311
Rt10123 T1592 T1649 3559288.3817712478
Rt10124 T1592 T1650 3517409.7667278461
Rt10125 T1592 T2323 13570837.473988213
Gcorr3480 T1592 T3221 T1592 T3221 -1.5282960720109603e-07
Rt10126 T1592 T3222 3491025.1367572029
Rt10127 T1592 T3466 4503382.3081488349
Rt10128 T1592 T3780 5268990.2055654852
Rt10129 T1593 T1594 11477439.623850647
Rt10130 T1593 T1715 3800041.5213133004
Rt10131 T1593 T1803 5109889.3799898708
Rt10132 T1593 T2045 4510151.3696551109
Gcorr3481 T1593 T3545 T1593 T3545 -1.4182618573418751e-07
Rt10133 T1593 T3788 7168776.7281875117
Rt10134 T1593 T3919 7570282.2925590146
Rt10135 T1593 T4010 2664964.9078771044
Rt10136 T1594 T1715 4829520.6844804343
Rt10137 T1594 T1716 10308575.365288282
Rt10138 T1594 T1717 2732148.7850946216
Rt10139 T1594 T2584 2118573.8742202632
Gcorr3482 T1594 T3484 T1594 T3484 -1.8613273649521057e-08
Rt10140 T1594 T3586 4935594.8605904942
Rt10141 T1594 T3604 2155568.5667325561
Rt10142 T1594 T4010 6828393.2354247198
Gcorr3483 T1594 T4092 T1594 T4092 -2.9843181176342991e-07
Rt10143 T1595 T1642 3087389.8005965529
Rt10144 T1595 T1643 3613798.2788478383
Gcorr3484 T1595 T2376 T1595 T2376 -9.8974342046356055e-08
Gcorr3485 T1595 T2377 T1595 T2377 -4.2813904048619259e-08
Rt10145 T1595 T2457 1385445.3725464647
Rt10146 T1595 T3188 18098867.591465868
Rt10147 T1595 T3336 733531.71188505448
Gcorr3486 T1595 T3499 T1595 T3499 -1.5008466079246716e-07
Gcorr3487 T1595 T4100 T1595 T4100 -3.668133524241073e-07
Rt10148 T1596 T1638 2993336.9386964454
Rt10149 T1596 T1684 3851803.9775465541
Rt10150 T1596 T1808 17901949.273993164
Gcorr3488 T1596 T2287 T1596 T2287 -2.4546328383710768e-08
Rt10151 T1596 T2948 7817455.8517340692
Rt10152 T1596 T3689 877907.87976350507
Rt10153 T1596 T4014 7549016.9330947651
Rt10154 T1597 T2131 3133332.695381918
Rt10155 T1597 T2135 13382125.766651608
Rt10156 T1597 T2397 4017561.5139892446
Rt10157 T1597 T2530 3462322.7030752772
Rt10158 T1597 T2764 21190970.758809432
Rt10159 T1597 T3667 9745520.3519589268
Rt10160 T1598 T1599 20388388.671692446
Rt10161 T1598 T1992 5065747.2669597846
Rt10162 T1598 T2003 14783112.763952911
Rt10163 T1598 T2440 3133064.5715574929
Gcorr3489 T1598 T3122 T1598 T3122 -2.4868983137080747e-07
Rt10164 T1598 T3143 5230880.0955130095
Rt10165 T1598 T3144 1267939.4300789258
Rt10166 T1598 T3145 8779152.448913103
Rt10167 T1599 T1659 5967909.270644784
Rt10168 T1599 T1695 23680000.072013006
Gcorr3490 T1599 T1942 T1599 T1942 -3.994090470586229e-08
Rt10169 T1599 T2440 5131301.3359051077
Rt10170 T1599 T2539 9045008.2093158606
Rt10171 T1599 T3144 6927498.4250009749
Rt10172 T1599 T3147 1794963.0186682865
Rt10173 T1599 T3455 9696556.9570226297
Rt10174 T1599 T3896 1670698.7036349198
Rt10175 T1600 T2303 11904798.560295543
Rt10176 T1600 T2304 2882655.0781607223
Rt10177 T1600 T2305 1573016.2957461535
Rt10178 T1600 T2529 1428096.2245142434
Rt10179 T1600 T2543 6912397.5679989262
Gcorr3491 T1600 T2890 T1600 T2890 -4.7714848636316714e-07
Gcorr3492 T1600 T2935 T1600 T2935 -4.2553985805454061e-07
Rt10180 T1600 T2936 324739.98303130176
Gcorr3493 T1600 T2999 T1600 T2999 -4.3658415941625407e-07
Gcorr3494 T1600 T3000 T1600 T3000 -4.8027185141968094e-07
Rt10181 T1601 T1654 3111530.9971485427
Rt10182 T1601 T1706 3114197.8685039445
Rt10183 T1601 T1939 2933095.1522628409
Gcorr3495 T1601 T2340 T1601 T2340 -2.1216856512910223e-07
Rt10184 T1601 T2938 1233711.4916874301
Rt10185 T1601 T2995 4311679.5937328665
Gcorr3496 T1601 T3229 T1601 T3229 -2.0324271352651844e-07
Rt10186 T1601 T3581 1059354.4331942496
Rt10187 T1602 T1666 4657535.7813229244
Rt10188 T1602 T1671 70241149.800040543
Rt10189 T1602 T1675 4906760.0399076333
Rt10190 T1602 T2569 3864191.9290625947
Rt10191 T1602 T2971 1947145.8475132321
Gcorr3497 T1602 T2972 T1602 T2972 -1.1298919188018924e-07
Rt10192 T1602 T2974 1631890.5365803926
Rt10193 T1602 T2988 7520434.5406897236
Gcorr3498 T1602 T4060 T1602 T4060 -1.6388175785674633e-07
Rt10194 T1603 T2316 6183886.728899912
Rt10195 T1603 T2317 1764277.7801984905
Gcorr3499 T1603 T2318 T1603 T2318 -5.4922038508796663e-08
Rt10196 T1603 T2438 2554272.4821303706
Rt10197 T1603 T3194 22348994.329974029
Rt10198 T1603 T3195 1408033.7160009486
Gcorr3500 T1603 T3223 T1603 T3223 -8.0797304105713679e-08
Rt10199 T1603 T3225 4719784.6077044085
Gcorr3501 T1603 T3489 T1603 T3489 -1.0689826694817365e-07
Rt10200 T1604 T2155 1523105.7072536272
Rt10201 T1604 T2388 9002877.0391743481
Rt10202 T1604 T2431 8145568.4552810397
Rt10203 T1604 T2523 3907076.653862325
Rt10204 T1604 T3376 4894183.976735536
Rt10205 T1604 T3377 7799994.2401437182
Rt10206 T1604 T3383 1385211.4390866577
Gcorr3502 T1604 T4131 T1604 T4131 -5.9086011881360372e-07
Rt10207 T1605 T1606 3795049.4459471223
Rt10208 T1605 T1652 29216865.193277966
Rt10209 T1605 T1871 4244280.537839612
Rt10210 T1605 T1872 3677768.6996644437
Rt10211 T1605 T3109 1889228.045406902
Gcorr3503 T1605 T3110 T1605 T3110 -5.1540678897117987e-08
Rt10212 T1605 T3126 2140535.3264275808
Gcorr3504 T1605 T3341 T1605 T3341 -7.0369914430443952e-08
Rt10213 T1606 T1652 4735643.5749417748
Rt10214 T1606 T1653 5145920.3015999869
Rt10215 T1606 T1663 139106251.46103948
Rt10216 T1606 T2593 4398698.0746211288
Rt10217 T1606 T3108 3640634.7882831809
Gcorr3505 T1606 T3109 T1606 T3109 -1.0532067945930054e-07
Rt10218 T1606 T3110 1561651.4474930672
Rt10219 T1606 T4113 4188180.5513488906
Rt10220 T1607 T1608 3033971.8380661821
Rt10221 T1607 T1780 4800596.6367523931
Gcorr3506 T1607 T1983 T1607 T1983 -1.4592138812355061e-08
Rt10222 T1607 T2546 140226871.28212285
Gcorr3507 T1607 T3317 T1607 T3317 -2.1933986958438895e-08
Rt10223 T1607 T3856 1263282.9960586536
Rt10224 T1607 T4196 1601251.1380787594
Rt10225 T1608 T1983 4487251.8311382523
Rt10226 T1608 T2046 4267967.9998096554
Rt10227 T1608 T2455 2936668.0893619671
Rt10228 T1608 T2656 1323763.7884470392
Rt10229 T1608 T3317 5047823.0466529708
Rt10230 T1608 T3319 592883.02416064439
Gcorr3508 T1608 T3321 T1608 T3321 -4.5441367496785361e-07
Gcorr3509 T1608 T3323 T1608 T3323 -1.1581713882674256e-07
Gcorr3510 T1608 T3856 T1608 T3856 -2.6133444060924667e-08
Rt10231 T1609 T1610 11584848.459688287
Rt10232 T1609 T2481 2835917.2642578934
Rt10233 T1609 T2482 19456093.568092417
Rt10234 T1609 T2527 3684665.8814515495
Gcorr3511 T1609 T3218 T1609 T3218 -5.0576559000199826e-07
Rt10235 T1609 T3583 913467.32540306204
Gcorr3512 T1609 T3584 T1609 T3584 -1.2567679371910287e-07
Rt10236 T1609 T3702 8101780.616103027
Rt10237 T1610 T1611 4294104.1664105784
Rt10238 T1610 T1612 4104182.4780391231
Rt10239 T1610 T1613 3740282.9318405623
Rt10240 T1610 T2527 3237493.5132827866
Rt10241 T1610 T3392 40553138.081528857
Gcorr3513 T1610 T3538 T1610 T3538 -1.4346550551139678e-07
Rt10242 T1610 T3702 2082965.9217710313
Rt10243 T1610 T3981 5807958.7140063997
Rt10244 T1611 T1612 5257629.1293264572
Rt10245 T1611 T1981 6313091.4927942026
Rt10246 T1611 T1982 3082825.3815475735
Rt10247 T1611 T2021 4564288.7617745101
Rt10248 T1611 T2839 17162432.237879138
Rt10249 T1611 T3399 1705198.6085127986
Gcorr3514 T1611 T3702 T1611 T3702 -4.9831870981214451e-08
Rt10250 T1611 T3981 5994612.3873945121
Gcorr3515 T1611 T4085 T1611 T4085 -3.3753423184990729e-08
Rt10251 T1612 T1613 9594000.8116186745
Rt10252 T1612 T1614 11689588.325153764
Rt10253 T1612 T1615 2751194.2067085109
Rt10254 T1612 T2021 5097859.9341804972
Rt10255 T1612 T2839 11374934.483848434
Rt10256 T1612 T3538 1736968.4752410634
Gcorr3516 T1612 T3746 T1612 T3746 -1.6264932404005203e-07
Rt10257 T1612 T3981 59058394.712432258
Rt10258 T1613 T1614 4565484.4760903828
Rt10259 T1613 T1647 10269602.503816174
Rt10260 T1613 T1863 1418023.508776427
Rt10261 T1613 T2527 12804162.535890533
Rt10262 T1613 T3390 2011826.0801814676
Gcorr3517 T1613 T3391 T1613 T3391 -5.0039750987285334e-07
Rt10263 T1613 T3392 2336376.6725346805
Rt10264 T1613 T3538 6492068.8722551828
Rt10265 T1614 T1615 4308093.3234897954
Rt10266 T1614 T1616 12365980.447403988
Rt10267 T1614 T1647 13596737.035936067
Rt10268 T1614 T2486 3208468.5257238946
Rt10269 T1614 T3390 5643151.0516875144
Rt10270 T1614 T3395 4494718.8375059944
Rt10271 T1614 T3538 7801746.4105566563
Rt10272 T1615 T1616 4849527.5058451798
Rt10273 T1615 T1617 9648502.2733930983
Rt10274 T1615 T2021 12552896.807342155
Rt10275 T1615 T2079 1866617.4328646371
Rt10276 T1615 T3395 10394733.055525834
Gcorr3518 T1615 T3538 T1615 T3538 -1.656671035822793e-07
Rt10277 T1615 T3745 2902445.5680144369
Rt10278 T1615 T3746 1500915.702615456
Rt10279 T1616 T1617 3537985.267732779
Rt10280 T1616 T1618 4680758.9087955812
Rt10281 T1616 T2199 381947.87454180513
Rt10282 T1616 T2486 2727312.7453604322
Gcorr3519 T1616 T3389 T1616 T3389 -1.8804670695119419e-07
Rt10283 T1616 T3395 3300342.9278664389
Gcorr3520 T1616 T3721 T1616 T3721 -3.0670172877267841e-06
Gcorr3521 T1616 T3745 T1616 T3745 -1.6848986426459782e-07
Rt10284 T1616 T4084 277945.6887014992
Rt10285 T1617 T1618 5222691.2697601784
Rt10286 T1617 T1619 4948131.4864533851
Rt10287 T1617 T1806 4904946.2547538271
Rt10288 T1617 T2079 3428795.6368039534
Rt10289 T1617 T2844 10685133.568353483
Rt10290 T1617 T3745 1658338.5912819759
Gcorr3522 T1617 T4084 T1617 T4084 -1.7297212140244008e-07
Rt10291 T1618 T1619 2091555.8410935486
Rt10292 T1618 T1620 9788339.6504305396
Rt10293 T1618 T1621 2205077.8501500376
Rt10294 T1618 T2199 9574653.5268865842
Rt10295 T1618 T2844 2396455.8586309981
Rt10296 T1618 T3721 3056964.9300616928
Gcorr3523 T1618 T3722 T1618 T3722 -3.0882012363553031e-07
Rt10297 T1618 T3775 2173850.2200430566
Gcorr3524 T1618 T4084 T1618 T4084 -5.8152515045855683e-08
Rt10298 T1619 T1620 2795361.9908092585
Rt10299 T1619 T1628 4336582.5958565855
Rt10300 T1619 T1806 5164447.7351533612
Rt10301 T1619 T2649 1188157.3887779748
Gcorr3525 T1619 T2844 T1619 T2844 -1.5790420386414543e-07
Gcorr3526 T1619 T3775 T1619 T3775 -4.3562260093617542e-07
Rt10302 T1620 T1621 2643022.8111303081
Rt10303 T1620 T1622 4636698.398666787
Rt10304 T1620 T1628 5110546.4315101625
Rt10305 T1620 T2173 4987743.1163378712
Rt10306 T1620 T2845 11126923.61389564
Gcorr3527 T1620 T3722 T1620 T3722 -2.7832502883563368e-07
Rt10307 T1620 T3775 1276622.7151275193
Rt10308 T1621 T1622 8534674.475038182
Rt10309 T1621 T1623 3921865.5730454465
Rt10310 T1621 T1714 9476257.9316517692
Rt10311 T1621 T2199 4000361.9630944324
Rt10312 T1621 T3393 35452712.288073003
Gcorr3528 T1621 T3721 T1621 T3721 -1.1550389654628397e-07
Rt10313 T1621 T3722 1015311.0234861249
Gcorr3529 T1621 T3775 T1621 T3775 -4.2967412398525854e-07
Rt10314 T1622 T1623 4323701.6164146746
Rt10315 T1622 T1624 11282909.752741931
Rt10316 T1622 T1625 3566684.3285899125
Rt10317 T1622 T2173 4978154.3343169484
Rt10318 T1622 T2845 6021918.6928917821
Rt10319 T1622 T3722 40395157.213294052
Gcorr3530 T1622 T3773 T1622 T3773 -1.2727114147122554e-07
Rt10320 T1622 T3975 2447473.7485700073
Rt10321 T1623 T1624 2528481.1313191359
Rt10322 T1623 T1627 2396727.9131362005
Rt10323 T1623 T1714 1611660.1035899925
Rt10324 T1623 T2670 7705594.034946884
Gcorr3531 T1623 T3393 T1623 T3393 -4.4283794243923477e-07
Rt10325 T1623 T3722 101183186.90663664
Rt10326 T1623 T3723 676878.73765722336
Gcorr3532 T1623 T3975 T1623 T3975 -6.9748170767291259e-08
Gcorr3533 T1623 T4041 T1623 T4041 -4.9034200716712046e-07
Rt10327 T1624 T1625 1494584.9001242109
Rt10328 T1624 T1626 9368159.4940977171
Rt10329 T1624 T1627 10141655.501762526
Rt10330 T1624 T2219 4450044.2691553086
Rt10331 T1624 T3603 1866470.1767175044
Gcorr3534 T1624 T3723 T1624 T3723 -2.7696593643400226e-07
Gcorr3535 T1624 T3773 T1624 T3773 -4.9227839013642333e-07
Rt10332 T1624 T3975 1935602.452114135
Rt10333 T1624 T4041 4770735.8765770914
Rt10334 T1625 T1626 4303989.9432215737
Rt10335 T1625 T1631 5055574.3742380701
Rt10336 T1625 T1694 9737795.9643295296
Rt10337 T1625 T2173 4829120.4708960624
Gcorr3536 T1625 T3603 T1625 T3603 -2.2889121360221092e-07
Rt10338 T1625 T3765 5813854.5276104845
Rt10339 T1625 T3773 1082993.0232581999
Gcorr3537 T1625 T3975 T1625 T3975 -4.5518356046078801e-07
Rt10340 T1626 T1631 4981454.6963200755
Rt10341 T1626 T1709 4897672.0226578349
Rt10342 T1626 T1788 5087667.5087793041
Rt10343 T1626 T2219 4394364.4862923846
Rt10344 T1626 T2876 12746958.8043791
Rt10345 T1626 T3546 4304585.005505411
Rt10346 T1626 T3603 9950629.3022673391
Rt10347 T1626 T3765 7292034.3844796596
Gcorr3538 T1626 T4167 T1626 T4167 -7.9193126077584334e-08
Gcorr3539 T1627 T2015 T1627 T2015 -8.8761992110919608e-08
Rt10348 T1627 T2219 2963912.2642350015
Rt10349 T1627 T2605 2134544.1434944686
Rt10350 T1627 T2670 814757.45804010157
Rt10351 T1627 T3386 9281035.794647852
Rt10352 T1627 T3602 6761304.7312544528
Gcorr3540 T1627 T3723 T1627 T3723 -5.1613333936672667e-07
Gcorr3541 T1627 T3783 T1627 T3783 -6.1293321479974594e-07
Rt10353 T1627 T4041 659385.76080698625
Rt10354 T1628 T2089 5948033.7070783256
Rt10355 T1628 T2167 8232545.8511849446
Rt10356 T1628 T2173 4391763.7344676079
Rt10357 T1628 T2649 2572910.4346207958
Rt10358 T1629 T1630 2511659.2981378818
Rt10359 T1629 T1690 93158718.078266636
Rt10360 T1629 T1861 5779580.6181332283
Rt10361 T1629 T1877 2654994.3315536971
Gcorr3542 T1629 T3021 T1629 T3021 -1.3123699052204516e-07
Rt10362 T1629 T3023 46692837.014512189
Rt10363 T1629 T3098 3647634.7097313995
Gcorr3543 T1629 T3616 T1629 T3616 -1.4442781955995938e-07
Rt10364 T1629 T4082 914196.62518275878
Rt10365 T1630 T1690 3274801.0424065311
Gcorr3544 T1630 T1882 T1630 T1882 -4.9235413585703953e-10
Gcorr3545 T1630 T2013 T1630 T2013 -6.5204276296965438e-08
Rt10366 T1630 T2586 2398658.6660092464
Rt10367 T1630 T2962 1072485.2538281993
Rt10368 T1630 T3021 2017744.908395641
Rt10369 T1630 T3023 3011574.8861269034
Gcorr3546 T1630 T4082 T1630 T4082 -3.7857910669386745e-07
Rt10370 T1631 T1694 3706562.6951025287
Rt10371 T1631 T1709 10553940.650889181
Rt10372 T1631 T1831 1967056.8163690888
Rt10373 T1631 T2400 7677437.3814751469
Rt10374 T1631 T2876 3356534.9145346642
Rt10375 T1631 T3765 9150684.90204308
Rt10376 T1632 T1633 9469133.6117949318
Gcorr3547 T1632 T1634 T1632 T1634 -4.3014790196815071e-08
Rt10377 T1632 T1759 2870124.2931312746
Gcorr3548 T1632 T2412 T1632 T2412 -1.7619979875035934e-07
Gcorr3549 T1632 T3014 T1632 T3014 -3.7702278260083999e-08
Rt10378 T1632 T3069 653974.4911791482
Rt10379 T1632 T3408 1577928.7146199215
Rt10380 T1632 T4076 13231928.705268642
Rt10381 T1633 T1759 7241283.5166337695
Gcorr3550 T1633 T1760 T1633 T1760 -4.6189577727802802e-08
Rt10382 T1633 T1901 7808899.5140718836
Rt10383 T1633 T1902 4053768.1161029837
Gcorr3551 T1633 T2641 T1633 T2641 -9.179815501046204e-08
Rt10384 T1633 T3063 3253337.0519300322
Rt10385 T1633 T3408 2398514.4323879629
Rt10386 T1633 T3457 48279458.572371282
Rt10387 T1633 T4058 993804.95816314104
Rt10388 T1633 T4076 4398721.0882400153
Gcorr3552 T1634 T2099 T1634 T2099 -3.4607689433642348e-07
Gcorr3553 T1634 T2319 T1634 T2319 -8.2298949260962581e-08
Rt10389 T1634 T2412 4957182.7141569331
Rt10390 T1634 T2521 5549744.4334439328
Rt10391 T1634 T2986 708222.94597332133
Gcorr3554 T1634 T3014 T1634 T3014 -5.6107353222778085e-07
Rt10392 T1634 T3069 809284.42600866023
Rt10393 T1634 T3525 1050372.9939115811
Rt10394 T1635 T1636 53361806.736259498
Rt10395 T1635 T1955 3730374.6555786585
Rt10396 T1635 T1956 9059758.3496705331
Gcorr3555 T1635 T2403 T1635 T2403 -3.5034195622150743e-08
Rt10397 T1635 T3249 1299716.8492737468
Gcorr3556 T1635 T3250 T1635 T3250 -9.8616640640115934e-08
Rt10398 T1635 T3252 1107683.9055144452
Gcorr3557 T1635 T3254 T1635 T3254 -1.9738539232938359e-09
Gcorr3558 T1636 T1698 T1636 T1698 -1.8573345775742258e-09
Rt10399 T1636 T1699 3014133.4067796385
Rt10400 T1636 T1955 4521466.1777314469
Gcorr3559 T1636 T2057 T1636 T2057 -1.7057425517459411e-07
Rt10401 T1636 T3247 523909.02928175149
Gcorr3560 T1636 T3248 T1636 T3248 -1.592651536692978e-06
Rt10402 T1636 T3249 1405426.0648196551
Rt10403 T1636 T3973 1135401.1065846458
Rt10404 T1637 T1769 11595163.521459669
Rt10405 T1637 T1770 2884130.0657484569
Rt10406 T1637 T1777 12140056.708079768
Rt10407 T1637 T2480 867007.8573014295
Gcorr3561 T1637 T3017 T1637 T3017 -7.6964817588696108e-07
Rt10408 T1637 T3056 7837091.0568885803
Rt10409 T1637 T3201 791256.94939294201
Gcorr3562 T1637 T3357 T1637 T3357 -5.6067251276996111e-08
Rt10410 T1638 T1808 3589010.0227261269
Rt10411 T1638 T1883 6480131.9077122994
Rt10412 T1638 T2000 10641950.258416353
Gcorr3563 T1638 T2493 T1638 T2493 -4.6636134495602906e-08
Rt10413 T1638 T3286 753767.40044552786
Gcorr3564 T1638 T3689 T1638 T3689 -3.3295632323873728e-07
Rt10414 T1638 T3690 2848636.8260542927
Rt10415 T1638 T4014 1902311.319563221
Rt10416 T1638 T4106 22267415.892144479
Rt10417 T1639 T1712 4350524.7292512041
Rt10418 T1639 T1880 4679258.5844292296
Rt10419 T1639 T1881 3569371.5057292469
Rt10420 T1639 T2041 9951577.9751198571
Rt10421 T1639 T2743 18627449.676091
Gcorr3565 T1639 T3235 T1639 T3235 -4.1347091813942745e-07
Gcorr3566 T1639 T3643 T1639 T3643 -2.5963816424291139e-08
Gcorr3567 T1639 T3758 T1639 T3758 -2.3085924938140641e-07
Rt10422 T1639 T3980 850946.33717173513
Rt10423 T1640 T1641 6046502.2024601772
Rt10424 T1640 T1713 6242517.9953280585
Gcorr3568 T1640 T1954 T1640 T1954 -2.7438614338051572e-08
Rt10425 T1640 T2540 3815578.7188581284
Rt10426 T1640 T3046 967917.12240983883
Gcorr3569 T1640 T3047 T1640 T3047 -1.8582768171564418e-07
Rt10427 T1640 T3048 1284817.3320378293
Rt10428 T1640 T3166 4446373.3233860359
Rt10429 T1641 T1779 1201001.9954372956
Rt10430 T1641 T1852 143401170.01020026
Rt10431 T1641 T1954 4690947.4106659675
Rt10432 T1641 T2624 2293952.1134047583
Gcorr3570 T1641 T2992 T1641 T2992 -2.0228966005939488e-07
Rt10433 T1641 T3045 739183.40459238563
Rt10434 T1641 T3046 2181681.0167148397
Rt10435 T1641 T3047 1747586.1574251472
Gcorr3571 T1641 T3207 T1641 T3207 -7.0000951499116203e-07
Rt10436 T1642 T1643 4069378.3444281332
Rt10437 T1642 T1644 5317005.6601783382
Rt10438 T1642 T2420 3961291.2437490365
Rt10439 T1642 T2421 4831825.9104740946
Rt10440 T1642 T3134 3182939.4769190056
Gcorr3572 T1642 T3336 T1642 T3336 -2.0245106945184152e-07
Rt10441 T1642 T3337 4883024.4881330198
Gcorr3573 T1642 T3833 T1642 T3833 -7.1019508151688538e-08
Rt10442 T1642 T4100 1641744.0911150589
Rt10443 T1643 T1644 3993229.3447036878
Rt10444 T1643 T1645 5261308.8483806709
Rt10445 T1643 T2377 2926156.8445414696
Gcorr3574 T1643 T2478 T1643 T2478 -6.6661041629266422e-08
Rt10446 T1643 T3188 7869647.1554462509
Gcorr3575 T1643 T3336 T1643 T3336 -1.1806379165970138e-07
Rt10447 T1643 T3337 986797.70504757529
Rt10448 T1643 T3930 3596050.8449580818
Gcorr3576 T1643 T3990 T1643 T3990 -1.1900539994521662e-07
Rt10449 T1644 T1645 33077049.098071281
Rt10450 T1644 T1646 5118146.2523081917
Rt10451 T1644 T1962 2363986.219903036
Rt10452 T1644 T2421 2347644.4059392856
Gcorr3577 T1644 T2977 T1644 T2977 -8.6837249286427475e-08
Gcorr3578 T1644 T3032 T1644 T3032 -4.6711106400635672e-07
Gcorr3579 T1644 T3337 T1644 T3337 -9.718590911447806e-08
Rt10453 T1644 T3833 610190.85484956263
Rt10454 T1644 T3990 2090837.96389774
Rt10455 T1645 T1646 5573450.1190299792
Gcorr3580 T1645 T1669 T1645 T1669 -3.5625750502770373e-08
Rt10456 T1645 T1892 9202591.0014199112
Rt10457 T1645 T2478 2678649.0767490389
Rt10458 T1645 T2927 1585318.5652868394
Gcorr3581 T1645 T2985 T1645 T2985 -1.6191341981426036e-07
Rt10459 T1645 T3930 2071357.9963354885
Rt10460 T1645 T3990 1223113.4847310809
Gcorr3582 T1646 T1669 T1646 T1669 -3.2253864841136852e-08
Gcorr3583 T1646 T1962 T1646 T1962 -2.8273264758373842e-08
Rt10461 T1646 T2423 9181063.197683366
Rt10462 T1646 T2526 2009957.1710108288
Gcorr3584 T1646 T2925 T1646 T2925 -5.0908846375502378e-08
Rt10463 T1646 T2927 1295823.0994704391
Rt10464 T1646 T2977 700009.89587309631
Rt10465 T1646 T3990 24065877.042897314
Rt10466 T1647 T1863 1360773.104494157
Gcorr3585 T1647 T2200 T1647 T2200 -1.2059243232791502e-07
Rt10467 T1647 T2486 928245.19257857313
Rt10468 T1647 T2487 7487738.7881533233
Rt10469 T1647 T3388 1276334.3471019967
Gcorr3586 T1647 T3389 T1647 T3389 -4.9481365359746082e-07
Rt10470 T1647 T3390 1201869.5881586242
Gcorr3587 T1647 T3391 T1647 T3391 -3.8385627546112139e-07
Rt10471 T1648 T1649 5143183.8109103804
Rt10472 T1648 T1958 11653115.23526811
Rt10473 T1648 T2460 9736209.0522259884
Rt10474 T1648 T2582 3120014.3237387645
Rt10475 T1648 T2819 3089563.9146858179
Gcorr3588 T1648 T3466 T1648 T3466 -1.4777457541118323e-07
Rt10476 T1648 T3543 27927611.290210154
Rt10477 T1648 T3780 4111327.4343268638
Rt10478 T1649 T1650 10937169.064881615
Rt10479 T1649 T1827 5954286.9566636384
Rt10480 T1649 T1958 4198879.6635979535
Rt10481 T1649 T2139 8891342.4162959494
Rt10482 T1649 T3221 4091931.0852458645
Gcorr3589 T1649 T3543 T1649 T3543 -7.2734510779042213e-08
Rt10483 T1649 T3780 9628146.0469066966
Rt10484 T1649 T3936 4050997.5672093551
Rt10485 T1650 T1827 3766654.2971547167
Rt10486 T1650 T1942 16928937.932701714
Rt10487 T1650 T2323 14080960.479836479
Rt10488 T1650 T2620 3683062.1600691611
Rt10489 T1650 T3148 7543916.969536785
Rt10490 T1650 T3221 4480309.7693659039
Rt10491 T1650 T3222 4405928.2026072154
Gcorr3590 T1651 T1896 T1651 T1896 -7.9932173067638118e-08
Gcorr3591 T1651 T2247 T1651 T2247 -1.0832263233236665e-08
Rt10492 T1651 T2418 12012703.064325677
Rt10493 T1651 T2447 2448731.0391979306
Rt10494 T1651 T2673 1986982.8301767081
Gcorr3592 T1651 T3416 T1651 T3416 -4.1353790243103386e-08
Rt10495 T1651 T3418 1147664.7829841687
Rt10496 T1651 T3419 7525593.7846101075
Rt10497 T1652 T1653 4276847.3444728134
Rt10498 T1652 T1872 5822558.1341859912
Rt10499 T1652 T2066 3373576.2591011417
Rt10500 T1652 T2067 9049276.1111629922
Rt10501 T1652 T3107 2009031.4607751577
Rt10502 T1652 T3108 16319108.343981599
Rt10503 T1652 T3109 2028777.3093915521
Gcorr3593 T1652 T3452 T1652 T3452 -1.478631308849836e-07
Rt10504 T1653 T1663 4845270.8686806066
Rt10505 T1653 T1664 6681161.8024882423
Rt10506 T1653 T1665 6127398.1602337481
Rt10507 T1653 T2067 5617367.0252779955
Rt10508 T1653 T3106 1563135.1687889141
Gcorr3594 T1653 T3107 T1653 T3107 -1.9672177611018095e-07
Rt10509 T1653 T3108 1455642.8822064602
Rt10510 T1653 T3116 1731199.3875959006
Gcorr3595 T1653 T3942 T1653 T3942 -1.912821184138939e-07
Gcorr3596 T1653 T4113 T1653 T4113 -1.0721123493514595e-07
Rt10511 T1654 T1706 113910017.13625485
Gcorr3597 T1654 T1707 T1654 T1707 -7.1685271782504773e-08
Gcorr3598 T1654 T1948 T1654 T1948 -4.4336455172897686e-09
Rt10512 T1654 T2222 24442287.479106635
Rt10513 T1654 T2694 1972770.8381508593
Rt10514 T1654 T3229 1389995.3167173592
Gcorr3599 T1654 T3581 T1654 T3581 -1.704277040732777e-08
Rt10515 T1654 T3841 1614464.9132479765
Rt10516 T1655 T2025 4443229.2413305994
Rt10517 T1655 T2026 19421739.982943669
Rt10518 T1655 T2367 4119297.9783020159
Rt10519 T1655 T2587 3349512.9741295958
Gcorr3600 T1655 T3257 T1655 T3257 -1.5649835122212145e-07
Rt10520 T1655 T3259 2166552.9956056178
Rt10521 T1655 T3352 3377605.2072031321
Gcorr3601 T1655 T3354 T1655 T3354 -1.985457779284488e-08
Rt10522 T1656 T1657 10136823.375360208
Rt10523 T1656 T1783 4657222.9770998387
Rt10524 T1656 T1860 12034412.888898548
Rt10525 T1656 T2169 4648892.8689504769
Rt10526 T1656 T3498 10533758.860687539
Gcorr3602 T1656 T3641 T1656 T3641 -1.4519084451231852e-07
Rt10527 T1656 T3813 2701471.7193454728
Rt10528 T1656 T4127 6751331.7637130823
Rt10529 T1657 T1790 4458825.194041728
Rt10530 T1657 T1868 3505854.7826196291
Rt10531 T1657 T2005 9976025.3375097383
Rt10532 T1657 T2169 4388081.5790022388
Rt10533 T1657 T3813 9762371.3129125964
Rt10534 T1658 T1676 3382355.8971086922
Rt10535 T1658 T1975 22036758.447256088
Rt10536 T1658 T2252 13910286.257086162
Rt10537 T1658 T2585 1268883.2259955204
Rt10538 T1658 T3281 3170393.9448101628
Gcorr3603 T1658 T3289 T1658 T3289 -8.3001467675931885e-08
Rt10539 T1658 T3290 570261.78179847822
Gcorr3604 T1658 T3291 T1658 T3291 -5.4779892120545766e-07
Gcorr3605 T1658 T4006 T1658 T4006 -5.7645464425302983e-07
Rt10540 T1659 T1695 13644774.896247502
Rt10541 T1659 T1904 2319005.9212562446
Rt10542 T1659 T2334 5813068.3738577999
Rt10543 T1659 T2439 15013050.416946065
Gcorr3606 T1659 T2932 T1659 T2932 -1.2899199059212768e-07
Rt10544 T1659 T3454 782106.80534317438
Rt10545 T1659 T3455 2594395.7505325177
Rt10546 T1659 T3896 13422922.577403966
Rt10547 T1660 T1661 2021947.0488211687
Rt10548 T1660 T2076 1805791.2146124386
Rt10549 T1660 T2077 3062190.2156640468
Rt10550 T1660 T2078 8250727.0142014408
Gcorr3607 T1660 T2788 T1660 T2788 -1.213600055421236e-07
Gcorr3608 T1660 T3330 T1660 T3330 -1.0499176910996985e-07
Gcorr3609 T1660 T3569 T1660 T3569 -4.8346343309528806e-07
Rt10551 T1660 T3713 3368763.2072498766
Gcorr3610 T1660 T3714 T1660 T3714 -2.3360352715531213e-10
Rt10552 T1660 T3941 732858.89365699945
Gcorr3611 T1660 T4134 T1660 T4134 -3.5872238466697152e-07
Rt10553 T1661 T1662 3912575.6233291477
Rt10554 T1661 T2046 5484566.1467543282
Rt10555 T1661 T2076 10789478.3083924
Rt10556 T1661 T2429 3488756.8733726367
Gcorr3612 T1661 T3320 T1661 T3320 -1.0641632210379648e-07
Rt10557 T1661 T3330 3933073.8387022931
Rt10558 T1661 T3569 1172417.4124557534
Rt10559 T1661 T3839 10984821.106323931
Gcorr3613 T1661 T3941 T1661 T3941 -3.9980988309053197e-07
Rt10560 T1662 T2046 12996474.348156475
Rt10561 T1662 T2047 2943729.4737935811
Rt10562 T1662 T2403 3584023.3952014209
Rt10563 T1662 T2601 3688385.580850027
Rt10564 T1662 T3253 3845028.2971969577
Rt10565 T1662 T3330 20018441.992615309
Gcorr3614 T1662 T3436 T1662 T3436 -2.1591961126347636e-07
Rt10566 T1662 T3839 1196598.5636902123
Rt10567 T1663 T1664 6158056.8064914551
Rt10568 T1663 T2264 2804000.0167378671
Gcorr3615 T1663 T2568 T1663 T2568 -9.8064305371537812e-08
Rt10569 T1663 T2593 3845017.867595484
Rt10570 T1663 T3116 5803023.7428318867
Rt10571 T1663 T3461 2156209.5506193168
Rt10572 T1663 T3462 10782880.606726974
Rt10573 T1663 T4113 1119283.9928418759
Gcorr3616 T1664 T1665 T1664 T1665 -1.992925626381201e-08
Rt10574 T1664 T1989 5743569.8733075671
Rt10575 T1664 T2264 3441572.7620874667
Gcorr3617 T1664 T2463 T1664 T2463 -2.3773499316257112e-08
Rt10576 T1664 T3116 1930025.5059629309
Gcorr3618 T1664 T3462 T1664 T3462 -1.9021930133117032e-07
Rt10577 T1664 T3942 2405006.3372381488
Rt10578 T1664 T4150 878301.57706635725
Rt10579 T1665 T1989 7967863.8900799891
Gcorr3619 T1665 T2048 T1665 T2048 -3.0354938008743626e-08
Gcorr3620 T1665 T2067 T1665 T2067 -1.0758244691739139e-07
Rt10580 T1665 T2385 2456665.6288174107
Rt10581 T1665 T2399 7009162.656356548
Rt10582 T1665 T3104 1382640.4145330829
Rt10583 T1665 T3106 2744711.61915062
Gcorr3621 T1665 T3844 T1665 T3844 -1.0739973014438084e-09
Rt10584 T1665 T3942 1292467.513256605
Rt10585 T1666 T1667 4571184.9951801347
Rt10586 T1666 T1671 3262442.6717784596
Rt10587 T1666 T1810 3902400.0731935939
Gcorr3622 T1666 T2363 T1666 T2363 -8.0951392329170821e-08
Rt10588 T1666 T2972 2036911.4631587598
Rt10589 T1666 T2974 15489978.445365377
Rt10590 T1666 T2975 1224721.5125763561
Gcorr3623 T1666 T3790 T1666 T3790 -9.015703202730976e-08
Rt10591 T1667 T1810 5206888.6809292063
Rt10592 T1667 T1854 1528268.0941937007
Rt10593 T1667 T1875 4524487.6901754504
Rt10594 T1667 T1876 8176134.0153276492
Gcorr3624 T1667 T2972 T1667 T2972 -8.0557983464971977e-08
Rt10595 T1667 T3161 2827009.1204572995
Gcorr3625 T1667 T3203 T1667 T3203 -7.3102904147551505e-07
Gcorr3626 T1667 T3521 T1667 T3521 -6.5776424515605772e-08
Rt10596 T1667 T3790 687733.80586426065
Rt10597 T1668 T1711 1424769.2624417539
Gcorr3627 T1668 T1855 T1668 T1855 -1.0136143586431416e-08
Gcorr3628 T1668 T1963 T1668 T1963 -8.1551095766446922e-08
Rt10598 T1668 T2474 6316561.4318033466
Rt10599 T1668 T3265 971589.73797990405
Gcorr3629 T1668 T3282 T1668 T3282 -4.6780749309039024e-07
Rt10600 T1668 T3325 1390588.2128987839
Rt10601 T1668 T4003 1826496.7343048842
Rt10602 T1669 T1892 3815566.7331365072
Rt10603 T1669 T1997 3719926.0564585398
Rt10604 T1669 T2417 139545924.56677258
Rt10605 T1669 T2526 2501505.9127924871
Rt10606 T1669 T2898 2339452.8960470259
Rt10607 T1669 T2927 472106.89745618502
Rt10608 T1669 T2933 114492222.12662353
Rt10609 T1670 T1977 5569092.2306133211
Rt10610 T1670 T1978 4317872.9198698374
Rt10611 T1670 T2090 1436292.0314066189
Rt10612 T1670 T2204 1414398.1746287316
Gcorr3630 T1670 T2883 T1670 T2883 -5.2301534086059613e-07
Gcorr3631 T1670 T3630 T1670 T3630 -3.7204781069203804e-07
Rt10613 T1671 T2363 6067904.1933791908
Rt10614 T1671 T2442 6437968.4589641886
Rt10615 T1671 T2569 2946862.2718409239
Gcorr3632 T1671 T2652 T1671 T2652 -5.6756413286851425e-08
Rt10616 T1671 T2974 1692784.2946573594
Gcorr3633 T1671 T2975 T1671 T2975 -1.1049104400220732e-07
Rt10617 T1671 T3039 1232852.7904247844
Rt10618 T1671 T3894 4207385.4570482755
Gcorr3634 T1672 T1887 T1672 T1887 -7.0186543713817219e-08
Rt10619 T1672 T2226 669147.30850496003
Rt10620 T1672 T2451 85331319.621797085
Rt10621 T1672 T2531 7077126.0928927902
Rt10622 T1672 T2586 3409585.8260480831
Rt10623 T1672 T2961 1720872.9953661456
Gcorr3635 T1672 T3021 T1672 T3021 -2.0413134854822432e-07
Rt10624 T1672 T3022 361391.48169094103
Gcorr3636 T1672 T3514 T1672 T3514 -1.340979264644916e-06
Rt10625 T1673 T1701 4480823.1460881718
Rt10626 T1673 T1702 4459155.858807547
Rt10627 T1673 T1842 4050494.0770582887
Rt10628 T1673 T2125 4861235.0467615072
Gcorr3637 T1673 T4114 T1673 T4114 -1.0498293563309806e-07
Rt10629 T1674 T2142 10440188.535292193
Rt10630 T1674 T2238 18897400.92895072
Rt10631 T1674 T2272 5647243.5074931057
Rt10632 T1674 T2631 6507514.1851269752
Rt10633 T1674 T2730 4235071.2860596115
Rt10634 T1675 T2410 16849060.176539239
Rt10635 T1675 T2560 4707889.5558903348
Rt10636 T1675 T2569 18943790.537093509
Rt10637 T1675 T2591 2980520.7915273579
Rt10638 T1675 T2729 12357527.224589817
Rt10639 T1675 T2988 1603382.8188836123
Rt10640 T1675 T3933 2502491.980013913
Gcorr3638 T1675 T3934 T1675 T3934 -1.3579133177913279e-07
Rt10641 T1675 T4060 5129280.9414801272
Rt10642 T1676 T1846 5175336.8455546852
Rt10643 T1676 T1975 5244941.7190365996
Gcorr3639 T1676 T1976 T1676 T1976 -1.5442882974506539e-09
Rt10644 T1676 T2243 2740584.7231656164
Gcorr3640 T1676 T3290 T1676 T3290 -1.8519548199768933e-08
Rt10645 T1676 T3291 1789722.5685173231
Rt10646 T1676 T3292 1529538.4332458253
Gcorr3641 T1676 T3293 T1676 T3293 -1.5289866219306929e-07
Gcorr3642 T1677 T1678 T1677 T1678 -8.9896658150315623e-08
Gcorr3643 T1677 T2073 T1677 T2073 -6.1433101589248754e-08
Rt10647 T1677 T2093 3597128.8941098521
Rt10648 T1677 T2625 6742967.519529623
Rt10649 T1677 T3160 757677.9265580558
Rt10650 T1677 T3509 1708016.4332940166
Rt10651 T1677 T3840 1622357.0362211224
Rt10652 T1678 T1679 5541000.2523071086
Rt10653 T1678 T2093 10924974.24446376
Rt10654 T1678 T2192 8822469.4305658918
Gcorr3644 T1678 T2449 T1678 T2449 -1.5816163203239623e-07
Gcorr3645 T1678 T3009 T1678 T3009 -1.7724880002368406e-07
Rt10655 T1678 T3084 604747.06610427774
Rt10656 T1678 T3160 754945.63541091233
Rt10657 T1678 T3809 1975600.1827278063
Gcorr3646 T1679 T2000 T1679 T2000 -2.0989174390452245e-07
Rt10658 T1679 T2301 11604397.598764017
Rt10659 T1679 T2449 6437465.077865391
Gcorr3647 T1679 T2450 T1679 T2450 -1.3440517248930087e-07
Rt10660 T1679 T2493 2412166.3948509684
Gcorr3648 T1679 T2979 T1679 T2979 -1.635084080177679e-07
Rt10661 T1679 T3009 763488.75781139883
Rt10662 T1679 T3035 549566.81477537984
Rt10663 T1679 T3084 2726763.2573914998
Rt10664 T1680 T1681 25432145.70100449
Rt10665 T1680 T2248 22942240.844788544
Rt10666 T1680 T2324 2370422.8673952306
Rt10667 T1680 T2634 2982107.4961950094
Rt10668 T1680 T3055 5474618.4415672114
Gcorr3649 T1680 T3200 T1680 T3200 -2.8732738948763804e-08
Rt10669 T1680 T3356 366163.53715762723
Gcorr3650 T1680 T4133 T1680 T4133 -2.3094138048585771e-06
Rt10670 T1681 T1682 10976560.796942078
Rt10671 T1681 T1798 5499535.1172715379
Gcorr3651 T1681 T1799 T1681 T1799 -2.6562363622122906e-08
Rt10672 T1681 T2634 2086088.5285832593
Rt10673 T1681 T3016 3611517.3439669418
Rt10674 T1681 T3055 2406003.2300001062
Rt10675 T1681 T3059 5521773.9604073176
Rt10676 T1682 T1798 14099623.162706716
Rt10677 T1682 T1800 3684752.6679850938
Gcorr3652 T1682 T1893 T1682 T1893 -2.0303038515466938e-08
Rt10678 T1682 T2590 2987443.2131054178
Rt10679 T1682 T3059 1046793.4106351375
Gcorr3653 T1682 T3060 T1682 T3060 -1.5651733574673572e-07
Rt10680 T1682 T3089 3162970.464040047
Rt10681 T1683 T1773 4548071.3013189016
Rt10682 T1683 T1815 4579387.113594234
Rt10683 T1683 T2091 5199091.7284361115
Rt10684 T1683 T2097 11879863.190634349
Gcorr3654 T1683 T3815 T1683 T3815 -8.3703869574900671e-08
Rt10685 T1684 T2286 4449615.9451703448
Rt10686 T1684 T2287 5038684.8810383081
Rt10687 T1684 T2583 6396772.8701747414
Rt10688 T1684 T2651 1902493.758761294
Gcorr3655 T1684 T2916 T1684 T2916 -1.891979771017889e-07
Gcorr3656 T1684 T2948 T1684 T2948 -6.8657221896305209e-09
Rt10689 T1684 T3054 2944888.496134595
Rt10690 T1684 T3689 5585353.9188793199
Gcorr3657 T1684 T3792 T1684 T3792 -2.097006298626371e-07
Rt10691 T1684 T4026 1165347.9544352146
Rt10692 T1685 T1802 3963090.6473483429
Rt10693 T1685 T1850 3302654.0693529267
Rt10694 T1685 T1857 4424896.0475032395
Rt10695 T1685 T2518 13898214.330247251
Gcorr3658 T1685 T3303 T1685 T3303 -1.6502414457950305e-07
Rt10696 T1685 T3305 2327934.3554555532
Rt10697 T1685 T3306 1592906.4960036133
Gcorr3659 T1685 T3307 T1685 T3307 -4.1690299261579093e-10
Rt10698 T1686 T2225 177373961.87059262
Rt10699 T1686 T2553 2594391.9719042382
Rt10700 T1686 T2554 10574739.755073991
Rt10701 T1686 T2673 2667266.1173846526
Gcorr3660 T1686 T3419 T1686 T3419 -1.3462978644717559e-07
Rt10702 T1686 T3421 2079870.1311085271
Rt10703 T1686 T3511 6903751.3423824906
Rt10704 T1686 T4152 55152417.30800429
Rt10705 T1687 T1966 9056752.680761084
Rt10706 T1687 T2147 5136352.0265003666
Rt10707 T1687 T2202 1776856.6426825528
Rt10708 T1687 T2401 6648723.697800111
Rt10709 T1687 T2734 14285443.688116278
Gcorr3661 T1687 T2965 T1687 T2965 -4.3835406394872923e-07
Rt10710 T1687 T3698 1581348.3831027132
Gcorr3662 T1687 T3964 T1687 T3964 -3.543686971153882e-08
Rt10711 T1688 T1689 12117063.018116573
Rt10712 T1688 T1888 15780665.609494973
Rt10713 T1688 T1945 1687028.2924340947
Rt10714 T1688 T2408 4593667.772105068
Gcorr3663 T1688 T3402 T1688 T3402 -2.0509271999101506e-07
Rt10715 T1688 T3403 1324844.9566957068
Rt10716 T1688 T3921 1133963.6293138149
Gcorr3664 T1688 T4068 T1688 T4068 -1.7274648102013951e-07
Gcorr3665 T1688 T4136 T1688 T4136 -2.3157150638172494e-07
Gcorr3666 T1689 T1996 T1689 T1996 -6.8716450826997266e-08
Rt10717 T1689 T2291 832514.23748244124
Rt10718 T1689 T2292 7403679.8337224238
Rt10719 T1689 T2408 3420464.6767042065
Rt10720 T1689 T3427 645622.2773343398
Gcorr3667 T1689 T3678 T1689 T3678 -7.5150056821206547e-07
Rt10721 T1689 T3679 16727018.20369919
Rt10722 T1689 T3921 2671932.5189689794
Rt10723 T1690 T1877 115907209.74590707
Rt10724 T1690 T1882 3439410.5395497405
Rt10725 T1690 T2224 5396809.3166026976
Rt10726 T1690 T2345 1880824.644867297
Gcorr3668 T1690 T2962 T1690 T2962 -1.8567539521358209e-07
Rt10727 T1690 T3023 862333.66691137315
Rt10728 T1690 T3024 2936754.1585288011
Gcorr3669 T1690 T3036 T1690 T3036 -3.2337013679059949e-08
Rt10729 T1691 T2010 5575694.5480900677
Rt10730 T1691 T2011 4094822.9061878482
Rt10731 T1691 T2043 4106746.8974687206
Rt10732 T1691 T2217 9047199.8874933459
Rt10733 T1691 T3592 12468644.006530916
Rt10734 T1691 T3818 8547098.7430677786
Rt10735 T1692 T1693 10068762.681246273
Rt10736 T1692 T1700 3618437.3669774025
Rt10737 T1692 T2197 10582675.858779779
Rt10738 T1692 T2214 3755638.3161877282
Rt10739 T1693 T1700 2656792.652850023
Rt10740 T1693 T1865 10038330.563396387
Rt10741 T1693 T2034 4531380.1940612029
Rt10742 T1693 T2347 8394582.5333638247
Rt10743 T1694 T2167 15917447.110538961
Rt10744 T1694 T2173 1832362.4989826395
Rt10745 T1694 T2201 4873801.0284456518
Rt10746 T1694 T2400 4156392.8551245122
Rt10747 T1695 T1904 8351362.9224370457
Gcorr3670 T1695 T2220 T1695 T2220 -3.7295226340857642e-08
Rt10748 T1695 T2539 1087496.6721335652
Rt10749 T1695 T2619 2309493.439350537
Gcorr3671 T1695 T3198 T1695 T3198 -5.1993564426812967e-07
Rt10750 T1695 T3455 515223.37980358035
Rt10751 T1695 T3456 5176434.8825173834
Rt10752 T1696 T2111 4627960.1164024575
Rt10753 T1696 T2112 4590425.1401093435
Rt10754 T1696 T2251 2833489.9882312776
Rt10755 T1696 T2283 9405521.987263931
Gcorr3672 T1696 T2766 T1696 T2766 -1.927292845578248e-07
Rt10756 T1696 T3655 1593468.4080259344
Gcorr3673 T1696 T4172 T1696 T4172 -1.3563019160703424e-07
Rt10757 T1697 T1791 3242336.0401767446
Rt10758 T1697 T1974 8153082.249244486
Rt10759 T1697 T2083 4605838.8791141259
Rt10760 T1697 T2205 4108516.6781215048
Rt10761 T1697 T2758 21306586.290468276
Rt10762 T1698 T1699 6329191.5336182276
Rt10763 T1698 T2052 4163418.2134121517
Rt10764 T1698 T2053 17976830.57908655
Rt10765 T1698 T2055 3673730.2147137779
Rt10766 T1698 T3243 1459311.0641402095
Gcorr3674 T1698 T3245 T1698 T3245 -1.1521483822353635e-07
Rt10767 T1698 T3247 1547561.3488600098
Rt10768 T1698 T3248 11584287.710869221
Gcorr3675 T1699 T2050 T1699 T2050 -1.7275850785014009e-08
Gcorr3676 T1699 T2055 T1699 T2055 -1.3989116492288254e-08
Rt10769 T1699 T2056 4225613.5293513723
Rt10770 T1699 T2057 8409666.5547162667
Rt10771 T1699 T3245 1806220.9508207706
Rt10772 T1699 T3247 2838512.3585703461
Rt10773 T1699 T3251 61189928.370198876
Gcorr3677 T1699 T3973 T1699 T3973 -1.7273196766209553e-07
Rt10774 T1699 T4000 617151.21682485228
Rt10775 T1700 T1865 1972915.5091102766
Rt10776 T1700 T2214 11586129.366284264
Rt10777 T1700 T2413 4315254.8824641556
Rt10778 T1700 T2517 3792822.6117919777
Rt10779 T1701 T1702 10616290.457945997
Rt10780 T1701 T1703 4625073.1296715196
Rt10781 T1701 T1786 4666335.9404629814
Rt10782 T1701 T2391 7927542.5460367389
Rt10783 T1702 T1786 1702509.3751717685
Rt10784 T1702 T2002 5619672.2757095695
Rt10785 T1702 T2038 9221679.7945294548
Rt10786 T1702 T2125 9111764.8570157811
Rt10787 T1703 T2127 2813572.1746159163
Rt10788 T1703 T2209 1471522.7661192261
Rt10789 T1703 T2213 2717250.9815774029
Rt10790 T1703 T2391 4908306.3718435448
Rt10791 T1704 T1778 9048435.3085740227
Rt10792 T1704 T2005 4750492.4029170312
Rt10793 T1704 T2105 11929893.517969921
Rt10794 T1704 T2383 3888999.815436183
Gcorr3678 T1704 T2696 T1704 T2696 -7.9758044312818038e-09
Rt10795 T1705 T1969 1567165.5225256006
Rt10796 T1705 T2124 11316338.156544331
Rt10797 T1705 T2222 7254107.5976992538
Rt10798 T1705 T2664 2363494.2353185876
Gcorr3679 T1705 T3230 T1705 T3230 -2.1324484852369594e-07
Gcorr3680 T1705 T3324 T1705 T3324 -4.6556625694858344e-07
Rt10799 T1705 T3503 597560.42635209626
Gcorr3681 T1705 T3683 T1705 T3683 -4.261271513862024e-07
Gcorr3682 T1705 T3937 T1705 T3937 -6.0593403560198446e-08
Rt10800 T1706 T1707 6876262.7157493513
Rt10801 T1706 T1708 350880.51206356613
Rt10802 T1706 T2340 2497316.5734844808
Gcorr3683 T1706 T2937 T1706 T2937 -1.592796634462025e-06
Rt10803 T1706 T2938 384925.89847067941
Rt10804 T1706 T2991 6535212.9034658885
Rt10805 T1706 T3229 1936652.4136283265
Gcorr3684 T1707 T1708 T1707 T1708 -9.1235083004308684e-09
Rt10806 T1707 T1905 6853457.6087742886
Gcorr3685 T1707 T1969 T1707 T1969 -6.9842856977204712e-08
Gcorr3686 T1707 T1970 T1707 T1970 -1.3964764880008995e-09
Rt10807 T1707 T2578 3893923.5227375333
Rt10808 T1707 T2694 2097595.1353679183
Rt10809 T1707 T2991 1567881.3720384291
Rt10810 T1707 T3050 1084443.6246900181
Rt10811 T1707 T3229 3332135.0866166209
Gcorr3687 T1707 T4090 T1707 T4090 -2.3520111949220139e-07
Gcorr3688 T1708 T1905 T1708 T1905 -3.5037177228204604e-08
Gcorr3689 T1708 T2340 T1708 T2340 -3.7913329456153882e-07
Rt10812 T1708 T2396 47637570.130811863
Rt10813 T1708 T2704 713011.88867410028
Rt10814 T1708 T2937 448747.90340339072
Gcorr3690 T1708 T2938 T1708 T2938 -1.4904857922099755e-06
Rt10815 T1708 T2991 576398.30838481768
Gcorr3691 T1708 T2992 T1708 T2992 -4.2315419875435061e-07
Rt10816 T1709 T1788 10567071.643067788
Rt10817 T1709 T1831 1991973.842082897
Rt10818 T1709 T1891 10628816.420871506
Rt10819 T1709 T2225 4988509.7815612331
Rt10820 T1709 T2876 2646074.7489416208
Rt10821 T1709 T3789 3231218.2997603253
Rt10822 T1709 T4167 5940809.660492965
Gcorr3692 T1710 T1825 T1710 T1825 -1.1082940236987342e-07
Gcorr3693 T1710 T2075 T1710 T2075 -2.1864445215652963e-07
Rt10823 T1710 T2623 2307707.4294460877
Rt10824 T1710 T2676 8037519.0384364678
Rt10825 T1710 T2816 515593.38701925479
Gcorr3694 T1710 T2941 T1710 T2941 -6.9405057859848365e-07
Rt10826 T1710 T3224 2784788.7828936372
Rt10827 T1710 T3922 1615633.0528424236
Gcorr3695 T1711 T1908 T1711 T1908 -2.3687300715675265e-08
Rt10828 T1711 T1963 2745351.150770125
Rt10829 T1711 T2358 726538.65493020823
Gcorr3696 T1711 T2381 T1711 T2381 -1.3765463385454411e-07
Rt10830 T1711 T2432 4795007.0164834056
Gcorr3697 T1711 T3265 T1711 T3265 -1.2877908814013061e-07
Rt10831 T1711 T3266 1948419.7464171636
Rt10832 T1711 T3282 249521.75388174789
Gcorr3698 T1711 T3325 T1711 T3325 -5.2053784226166561e-07
Gcorr3699 T1711 T3886 T1711 T3886 -1.2232119902124463e-06
Rt10833 T1711 T4128 6998305.1043067705
Rt10834 T1712 T1878 5002313.2307474976
Rt10835 T1712 T1880 9349254.5191353578
Rt10836 T1712 T2022 3058240.2665140321
Rt10837 T1712 T2244 4263510.0016597072
Rt10838 T1712 T2743 2011600.5921471803
Rt10839 T1712 T3642 12684827.183388086
Rt10840 T1712 T3758 10022635.286735378
Rt10841 T1713 T2007 6745077.7593461769
Gcorr3700 T1713 T2033 T1713 T2033 -6.9301033823366179e-08
Rt10842 T1713 T2540 4434889.7200781936
Rt10843 T1713 T2550 2782730.0729096676
Gcorr3701 T1713 T3048 T1713 T3048 -1.6944509483876529e-07
Rt10844 T1713 T3166 830957.53013411537
Rt10845 T1713 T3485 828577.6383950829
Rt10846 T1713 T3486 822962.70627768326
Gcorr3702 T1713 T3787 T1713 T3787 -4.5241382958308052e-07
Gcorr3703 T1713 T4130 T1713 T4130 -8.5891324705577342e-08
Rt10847 T1714 T2199 7185175.9780327426
Rt10848 T1714 T2200 2687135.8223866918
Rt10849 T1714 T2670 939087.05773415323
Gcorr3704 T1714 T2690 T1714 T2690 -7.9767370604346607e-10
Rt10850 T1714 T3387 22124088.775843225
Rt10851 T1714 T3393 620066.50967372826
Gcorr3705 T1714 T3723 T1714 T3723 -6.0301980060368877e-07
Gcorr3706 T1714 T3783 T1714 T3783 -4.7011114359018231e-07
Rt10852 T1715 T1716 4612227.1785746152
Rt10853 T1715 T1803 10077993.232086975
Rt10854 T1715 T2064 14557886.436217554
Rt10855 T1715 T2354 1627219.9556219459
Rt10856 T1715 T2861 3888962.0670129284
Rt10857 T1715 T3545 1357994.753919956
Rt10858 T1715 T3604 20815867.859851953
Gcorr3707 T1715 T4010 T1715 T4010 -1.3487624338268801e-07
Rt10859 T1716 T1717 4226128.0800854387
Rt10860 T1716 T1718 10103116.698504491
Rt10861 T1716 T1719 2932657.8723868043
Rt10862 T1716 T2064 4811217.8940895991
Rt10863 T1716 T2861 11033585.032859009
Rt10864 T1716 T3604 11595848.878649514
Gcorr3708 T1716 T3671 T1716 T3671 -2.2589097265230597e-07
Rt10865 T1716 T3949 1825965.2665764517
Rt10866 T1717 T1718 4818443.2068033535
Rt10867 T1717 T2250 58007350.204328559
Rt10868 T1717 T2584 6845784.40985684
Rt10869 T1717 T2607 2658139.5595540497
Gcorr3709 T1717 T3483 T1717 T3483 -6.2799836716817587e-08
Rt10870 T1717 T3484 1440284.6461134099
Gcorr3710 T1717 T3604 T1717 T3604 -1.461099315778775e-07
Rt10871 T1717 T3949 12826988.679864794
Rt10872 T1718 T1719 4365089.6577118998
Rt10873 T1718 T1720 11209301.355221733
Rt10874 T1718 T1746 3999716.0934333312
Rt10875 T1718 T2607 7352629.6205539899
Rt10876 T1718 T3483 2405669.6011541868
Rt10877 T1718 T3949 122005187.35520142
Rt10878 T1718 T4025 11172470.153161371
Rt10879 T1719 T1720 5395344.0984703545
Rt10880 T1719 T1721 9758618.9620407335
Rt10881 T1719 T1753 1702952.0562849727
Rt10882 T1719 T2064 9266071.8858264945
Rt10883 T1719 T2872 3921661.3868553294
Rt10884 T1719 T3671 1298362.9621260713
Gcorr3711 T1719 T3949 T1719 T3949 -2.016892146596185e-07
Rt10885 T1719 T4025 8806695.9566154871
Rt10886 T1720 T1721 2954628.5274271723
Rt10887 T1720 T1722 10035422.325287346
Rt10888 T1720 T1746 4059202.1195368012
Rt10889 T1720 T2216 9199447.2333595101
Gcorr3712 T1720 T2872 T1720 T2872 -1.6818952606692103e-07
Rt10890 T1720 T3674 2291257.1930337357
Rt10891 T1720 T4025 4578213.4291140893
Rt10892 T1721 T1722 4380984.0676471032
Rt10893 T1721 T1723 4767875.0681276908
Rt10894 T1721 T1753 2536184.6976167951
Rt10895 T1721 T2210 4803657.9995582784
Rt10896 T1721 T2872 1365511.3154099777
Rt10897 T1721 T3673 11690312.024904052
Gcorr3713 T1721 T3674 T1721 T3674 -2.1189188262843415e-07
Rt10898 T1722 T1723 10414958.823830234
Rt10899 T1722 T1724 1716428.9709233672
Rt10900 T1722 T2172 10708520.091284897
Rt10901 T1722 T2216 4438682.8984587211
Gcorr3714 T1722 T2859 T1722 T2859 -4.4276633864958543e-07
Rt10902 T1722 T3673 2148594.1926310519
Rt10903 T1722 T3674 14109648.192033267
Rt10904 T1722 T3992 2711243.7506559612
Rt10905 T1723 T1724 1765965.6427796583
Rt10906 T1723 T1725 10081370.981384462
Rt10907 T1723 T2159 3573409.9804340415
Rt10908 T1723 T2210 4736432.0486878101
Gcorr3715 T1723 T2859 T1723 T2859 -4.1637432323139026e-07
Rt10909 T1723 T3673 3545126.8772041136
Rt10910 T1724 T1725 4473774.9809820829
Rt10911 T1724 T1726 4612120.1724630045
Rt10912 T1724 T1727 1745152.354788115
Rt10913 T1724 T2172 1516722.0933504305
Rt10914 T1724 T2859 482998.25872360705
Gcorr3716 T1724 T3474 T1724 T3474 -4.2674238623027416e-07
Gcorr3717 T1724 T3673 T1724 T3673 -4.4118457132898944e-07
Gcorr3718 T1724 T3849 T1724 T3849 -1.3182362836744051e-07
Gcorr3719 T1724 T3992 T1724 T3992 -4.1604069585414648e-07
Rt10915 T1725 T1726 10367476.430452466
Rt10916 T1725 T1750 3892537.212651893
Rt10917 T1725 T1789 5179780.9303814294
Rt10918 T1725 T2159 4795547.4150314936
Rt10919 T1726 T1727 9960879.3251343444
Rt10920 T1726 T1728 3702823.9544670549
Rt10921 T1726 T1750 4842484.1890493603
Rt10922 T1726 T2232 4688450.3355280273
Gcorr3720 T1726 T3741 T1726 T3741 -1.5043159151280196e-07
Rt10923 T1726 T3849 2526960.1705852197
Rt10924 T1727 T1728 5057859.8195608119
Rt10925 T1727 T1729 10259737.117821904
Rt10926 T1727 T1747 3741798.7380562616
Rt10927 T1727 T2172 10378151.063996146
Gcorr3721 T1727 T2859 T1727 T2859 -3.391269810387228e-07
Rt10928 T1727 T3406 4043239.2917065979
Rt10929 T1727 T3474 3559069.5773587287
Rt10930 T1727 T3849 3588741.5354214623
Rt10931 T1728 T1729 3871918.6071192753
Rt10932 T1728 T1730 4350742.2765786443
Rt10933 T1728 T1731 1863123.8070633325
Rt10934 T1728 T2232 9512960.5775301605
Gcorr3722 T1728 T2825 T1728 T2825 -4.1957902290262679e-07
Gcorr3723 T1728 T3404 T1728 T3404 -5.7189070534628601e-09
Rt10935 T1728 T3406 5834420.8722435692
Rt10936 T1728 T3741 1195669.6347278182
Gcorr3724 T1728 T3849 T1728 T3849 -1.4230955667278738e-07
Rt10937 T1728 T4119 35886204.530472413
Rt10938 T1729 T1730 10875279.673445456
Rt10939 T1729 T1743 3884991.3362294491
Rt10940 T1729 T1747 4002244.3570600762
Rt10941 T1729 T2503 10359291.382664889
Rt10942 T1729 T3404 6234397.7760960041
Rt10943 T1729 T3405 6350036.4690833706
Rt10944 T1729 T3406 6071392.1251882315
Rt10945 T1730 T1731 10070096.047723481
Rt10946 T1730 T1732 2101523.5782332141
Rt10947 T1730 T1743 5483644.4212740744
Rt10948 T1730 T2277 9750573.5600573868
Rt10949 T1730 T3404 5773497.020437385
Gcorr3725 T1730 T3493 T1730 T3493 -4.3442408066308611e-07
Rt10950 T1730 T4119 2494640.2510377537
Rt10951 T1730 T4155 2860478.4535656292
Rt10952 T1731 T1732 4390516.5212969966
Rt10953 T1731 T1733 5209006.6020889394
Rt10954 T1731 T2232 1758864.2617916234
Rt10955 T1731 T2426 1304789.5728467188
Rt10956 T1731 T2825 574200.12861532508
Rt10957 T1731 T3685 45196131.220510326
Gcorr3726 T1731 T3741 T1731 T3741 -5.0169905336868851e-07
Rt10958 T1731 T4119 17126753.820628203
Rt10959 T1732 T1733 10075095.642296819
Rt10960 T1732 T1734 880604.6817385999
Rt10961 T1732 T1744 3294721.0209614546
Rt10962 T1732 T2277 3747336.7803769028
Rt10963 T1732 T3493 554126.71833196632
Rt10964 T1732 T3685 14113266.569109401
Gcorr3727 T1732 T3910 T1732 T3910 -8.2404847768748546e-07
Gcorr3728 T1732 T4119 T1732 T4119 -1.4749859339076946e-07
Gcorr3729 T1732 T4155 T1732 T4155 -4.3477007032697823e-07
Rt10965 T1733 T1734 3760496.2887448003
Rt10966 T1733 T1735 4873254.9051084593
Rt10967 T1733 T1745 11713073.849149611
Rt10968 T1733 T2426 2954016.7836886281
Gcorr3730 T1733 T2794 T1733 T2794 -1.0607516752405615e-07
Rt10969 T1733 T3685 2788579.2414339543
Rt10970 T1734 T1735 10631466.692173598
Rt10971 T1734 T1736 4119152.0648546838
Rt10972 T1734 T1744 10467406.605895031
Rt10973 T1734 T2293 10436572.616572909
Rt10974 T1734 T2794 4578108.2107210476
Gcorr3731 T1734 T3493 T1734 T3493 -8.0213221251336716e-07
Rt10975 T1734 T3685 150295964.73820996
Rt10976 T1734 T3910 962109.55142744409
Rt10977 T1735 T1736 4686427.1531793745
Rt10978 T1735 T1737 5139473.6814518189
Rt10979 T1735 T1745 4323864.9741289085
Rt10980 T1735 T2168 9898506.6861530561
Rt10981 T1735 T2794 4201069.0632038396
Gcorr3732 T1735 T4195 T1735 T4195 -5.5412634125985745e-08
Rt10982 T1736 T1737 2563533.9837174742
Rt10983 T1736 T1738 3807195.2927791988
Rt10984 T1736 T1739 3741722.1236919779
Rt10985 T1736 T2293 4167145.2292077998
Gcorr3733 T1736 T2794 T1736 T2794 -2.8312791348585246e-09
Gcorr3734 T1736 T3346 T1736 T3346 -8.747280918111465e-08
Rt10986 T1736 T3530 1021537.9410354933
Rt10987 T1736 T3910 137364714.95288143
Gcorr3735 T1736 T4019 T1736 T4019 -4.1838277887949907e-07
Gcorr3736 T1736 T4195 T1736 T4195 -1.5519996696505168e-08
Rt10988 T1737 T1738 10551572.471370153
Rt10989 T1737 T1742 4600242.8287549429
Rt10990 T1737 T1752 973649.31653007213
Rt10991 T1737 T2168 1093877.5455408508
Gcorr3737 T1737 T3530 T1737 T3530 -3.5705113018602305e-07
Rt10992 T1737 T4019 2255102.7073416566
Rt10993 T1737 T4195 3865329.5716358451
Rt10994 T1738 T1739 4301715.2272045566
Rt10995 T1738 T1740 1319336.2378822344
Rt10996 T1738 T1742 1603957.1899217647
Rt10997 T1738 T2143 10593213.372724326
Rt10998 T1738 T2793 1259971.2083190104
Rt10999 T1738 T3529 6175299.8482748186
Gcorr3738 T1738 T3530 T1738 T3530 -1.3317645979150636e-07
Gcorr3739 T1738 T3782 T1738 T3782 -6.3730678960519824e-07
Rt11000 T1738 T4019 1071123.698450028
Rt11001 T1739 T1740 10483024.587106893
Rt11002 T1739 T1741 2998487.0515807527
Rt11003 T1739 T2293 9833245.2707297318
Rt11004 T1739 T2471 3728164.4159983564
Gcorr3740 T1739 T3273 T1739 T3273 -1.4568769773227784e-07
Rt11005 T1739 T3346 3986693.9650421687
Rt11006 T1739 T3529 2163696.4111383487
Gcorr3741 T1739 T3530 T1739 T3530 -9.8843396247316787e-08
Rt11007 T1740 T1741 4200928.2527023526
Rt11008 T1740 T1748 4337827.86348751
Rt11009 T1740 T1754 4738049.7339544874
Rt11010 T1740 T2143 3542332.4246952916
Gcorr3742 T1740 T2793 T1740 T2793 -6.6474439127594126e-07
Gcorr3743 T1740 T3344 T1740 T3344 -1.6470676504452218e-07
Rt11011 T1740 T3529 10455232.756845681
Rt11012 T1740 T3782 919215.6820187897
Rt11013 T1740 T4089 6553279.4763582405
Rt11014 T1741 T1748 11086742.853176041
Rt11015 T1741 T1749 3812333.9286062075
Rt11016 T1741 T1767 21295229.059552744
Rt11017 T1741 T2471 7232367.164970262
Rt11018 T1741 T3273 1904713.0227504605
Gcorr3744 T1741 T3529 T1741 T3529 -1.8029412549018542e-07
Rt11019 T1741 T4089 4344640.1358555229
Rt11020 T1742 T1752 5066129.9030011073
Rt11021 T1742 T1774 10633503.944665691
Rt11022 T1742 T1775 5148311.4116607495
Rt11023 T1742 T2143 4883594.0674599139
Gcorr3745 T1742 T2793 T1742 T2793 -8.9877754524119146e-08
Gcorr3746 T1742 T4019 T1742 T4019 -6.6736815906710869e-07
Rt11024 T1743 T2277 3289104.3999033095
Rt11025 T1743 T2503 2623100.54269792
Rt11026 T1743 T2507 3495382.7313253679
Rt11027 T1743 T3349 429753556.74318856
Rt11028 T1743 T3351 2881322.0556936548
Rt11029 T1743 T3404 5273538.8029766241
Gcorr3747 T1743 T3405 T1743 T3405 -1.5499653460540645e-07
Rt11030 T1743 T4155 9735286.2625879068
Rt11031 T1744 T2277 3287625.2394471182
Rt11032 T1744 T2293 3946018.901678849
Rt11033 T1744 T2294 12178290.115439672
Rt11034 T1744 T2532 9063484.4115280248
Rt11035 T1744 T3347 2089048.64550512
Gcorr3748 T1744 T3493 T1744 T3493 -1.1790570540829321e-07
Rt11036 T1744 T3910 8794845.2014087792
Rt11037 T1745 T1912 2902837.5133888368
Rt11038 T1745 T2168 4129068.2269462105
Rt11039 T1745 T2426 2137230.8525979877
Rt11040 T1745 T2579 2596050.0978023051
Rt11041 T1746 T2216 3513364.3679510001
Rt11042 T1746 T2606 11039830.498766981
Rt11043 T1746 T2607 3219683.6327376622
Rt11044 T1746 T2705 7103567.6706099305
Rt11045 T1746 T3478 1461037.4496087774
Gcorr3749 T1746 T3483 T1746 T3483 -7.7834702551986873e-08
Gcorr3750 T1746 T3674 T1746 T3674 -9.5626053836021379e-08
Rt11046 T1746 T4025 66879281.755329236
Rt11047 T1747 T2172 11054881.187813438
Rt11048 T1747 T2464 3454546.9101868994
Rt11049 T1747 T2465 4753017.2416939158
Rt11050 T1747 T2503 8909248.6420012135
Rt11051 T1747 T3405 2805409.7138557946
Gcorr3751 T1747 T3406 T1747 T3406 -1.6780191282968032e-07
Rt11052 T1747 T3474 3202883.8499170858
Gcorr3752 T1747 T3475 T1747 T3475 -9.1215269128188745e-09
Rt11053 T1748 T1749 2713715.6428994834
Rt11054 T1748 T1751 3652695.9952236973
Rt11055 T1748 T1754 9544682.0296222568
Rt11056 T1748 T2314 10313660.16924081
Gcorr3753 T1748 T3270 T1748 T3270 -1.5888786352129223e-07
Rt11057 T1748 T3344 1632813.0997983739
Rt11058 T1748 T4089 5453066.8365896139
Rt11059 T1749 T1751 12795316.611086156
Rt11060 T1749 T1767 3343397.565589448
Rt11061 T1749 T1768 3517364.3472825671
Rt11062 T1749 T2575 10605152.959845861
Rt11063 T1749 T3270 1059295.0889857998
Gcorr3754 T1749 T3272 T1749 T3272 -1.0305311707996539e-07
Rt11064 T1749 T3273 11097915.457873635
Gcorr3755 T1749 T4089 T1749 T4089 -1.4373095299276162e-07
Rt11065 T1750 T1789 10081178.957652483
Rt11066 T1750 T2036 5054746.803275371
Rt11067 T1750 T2037 19771067.074964885
Rt11068 T1750 T2232 4478561.8186841151
Rt11069 T1750 T2723 4243308.2114287885
Rt11070 T1751 T2314 3638503.8575795377
Rt11071 T1751 T2315 16945778.411328223
Rt11072 T1751 T2575 3899461.2360381605
Rt11073 T1751 T2647 3130655.3993708566
Rt11074 T1751 T3268 1645601.2487572082
Gcorr3756 T1751 T3269 T1751 T3269 -5.882221209770669e-08
Rt11075 T1751 T3270 2854915.8395229331
Gcorr3757 T1751 T3344 T1751 T3344 -1.2917970571756874e-07
Rt11076 T1752 T1774 4446267.8818328828
Rt11077 T1752 T1959 9993493.9595697299
Rt11078 T1752 T2168 9075833.0513910782
Rt11079 T1752 T2260 2402417.3607275793
Rt11080 T1753 T2064 4773510.3828902058
Rt11081 T1753 T2210 3228259.2387223202
Rt11082 T1753 T2437 5692316.7643984733
Rt11083 T1753 T2499 1509428.0744261418
Gcorr3758 T1753 T2872 T1753 T2872 -4.3303083922927655e-07
Gcorr3759 T1753 T3671 T1753 T3671 -2.3706608651109164e-07
Rt11084 T1754 T2143 5025950.5011625905
Rt11085 T1754 T2279 12529625.376862111
Rt11086 T1754 T2314 898185.44828549074
Rt11087 T1754 T2382 3527852.9139498202
Rt11088 T1754 T2645 8571153.1163364928
Rt11089 T1754 T3344 7702007.600113106
Gcorr3760 T1754 T3345 T1754 T3345 -1.2562577152674968e-06
Gcorr3761 T1754 T3663 T1754 T3663 -7.127383244575398e-08
Rt11090 T1754 T3782 13499115.391689051
Rt11091 T1754 T3827 574908.321676402
Rt11092 T1755 T1756 2377354.0371617959
Rt11093 T1755 T1818 260281.4515156158
Rt11094 T1755 T1993 3926247.9677261035
Rt11095 T1755 T1994 3670447.4119048174
Rt11096 T1755 T3362 5534106.3161309054
Gcorr3762 T1755 T3364 T1755 T3364 -1.9264543656377982e-07
Gcorr3763 T1755 T3664 T1755 T3664 -8.6536608393879449e-08
Rt11097 T1755 T3666 150602.81211141346
Rt11098 T1755 T3918 38878696.759120099
Gcorr3764 T1755 T4030 T1755 T4030 -5.8534398927699403e-06
Rt11099 T1756 T1818 4487614.0454115635
Rt11100 T1756 T1819 9661146.8613497894
Rt11101 T1756 T1821 819515.7597352661
Rt11102 T1756 T2472 746025.10501162871
Rt11103 T1756 T3364 299898.83094094245
Gcorr3765 T1756 T3365 T1756 T3365 -2.0497233161610514e-06
Gcorr3766 T1756 T3367 T1756 T3367 -5.5659342486509663e-07
Rt11104 T1756 T3368 2918208.8619350353
Gcorr3767 T1756 T3666 T1756 T3666 -2.8225423214237631e-07
Rt11105 T1756 T4030 12664790.015265476
Rt11106 T1757 T1858 3125568.4948709966
Rt11107 T1757 T2481 2541433.634132707
Rt11108 T1757 T2516 1722764.3287167924
Rt11109 T1757 T3155 2471863.5902474588
Gcorr3768 T1757 T3218 T1757 T3218 -1.4433327072421404e-07
Rt11110 T1757 T3233 3279666.7493310049
Rt11111 T1757 T3578 1379810.5908037019
Gcorr3769 T1757 T4104 T1757 T4104 -4.912845963723473e-07
Gcorr3770 T1758 T2192 T1758 T2192 -1.0502493794890438e-08
Rt11112 T1758 T2305 5964365.433486864
Gcorr3771 T1758 T2306 T1758 T2306 -2.0828076150659841e-07
Rt11113 T1758 T2529 4865454.6862500831
Rt11114 T1758 T2653 13113436.562373523
Gcorr3772 T1758 T2999 T1758 T2999 -1.1377343503607346e-08
Rt11115 T1758 T3001 786736.49328503257
Rt11116 T1758 T3162 668131.65635708149
Rt11117 T1758 T3837 2432286.8185558864
Rt11118 T1759 T1760 3172140.3991297623
Gcorr3773 T1759 T1879 T1759 T1879 -4.2228083808740298e-08
Rt11119 T1759 T2412 1065620.2457499551
Gcorr3774 T1759 T2665 T1759 T2665 -1.4637302743167534e-07
Gcorr3775 T1759 T3063 T1759 T3063 -4.5770618213319111e-08
Gcorr3776 T1759 T3069 T1759 T3069 -2.8129984919654721e-07
Rt11120 T1759 T3512 522918.28584165167
Gcorr3777 T1759 T4012 T1759 T4012 -5.6477330424238665e-07
Rt11121 T1759 T4076 686556.93820812157
Rt11122 T1760 T1879 5748137.2702566357
Rt11123 T1760 T1901 6183869.1014169659
Rt11124 T1760 T2074 2619603.2385161803
Rt11125 T1760 T2423 25147268.945733126
Rt11126 T1760 T2978 1173747.6154065127
Gcorr3778 T1760 T3031 T1760 T3031 -3.4762239604929534e-08
Rt11127 T1760 T3063 862223.81680416805
Gcorr3779 T1760 T3512 T1760 T3512 -1.7142386060390827e-07
Gcorr3780 T1761 T1807 T1761 T1807 -1.4659552979922936e-07
Gcorr3781 T1761 T1991 T1761 T1991 -2.7172373631998554e-07
Rt11128 T1761 T2261 2807961.9479129445
Rt11129 T1761 T2563 2563123.6854916238
Gcorr3782 T1761 T2796 T1761 T2796 -5.5984408356164982e-07
Rt11130 T1761 T3384 1206631.8064747155
Rt11131 T1761 T3520 2574822.0777036445
Rt11132 T1761 T3979 502619.75641577441
Rt11133 T1761 T4066 1276166.9149602845
Rt11134 T1762 T1884 11367498.187268505
Rt11135 T1762 T1974 2099803.835426793
Rt11136 T1762 T1998 10856496.431068499
Rt11137 T1762 T2380 1604022.26283005
Rt11138 T1763 T1813 2709279.9114916055
Rt11139 T1763 T1817 64516180.560740866
Rt11140 T1763 T1908 2468915.3099294514
Rt11141 T1763 T2559 20844233.603419978
Gcorr3783 T1763 T3276 T1763 T3276 -1.602519503513174e-07
Rt11142 T1763 T3277 4314525.7997022383
Rt11143 T1763 T3278 624183.01515160373
Gcorr3784 T1763 T3279 T1763 T3279 -1.4754216443718557e-07
Rt11144 T1764 T1822 944411.66358606028
Rt11145 T1764 T2051 13767166.395916035
Rt11146 T1764 T2505 1948992.3121251441
Rt11147 T1764 T2573 2182118.5039047282
Rt11148 T1764 T3012 5373255.8783584321
Gcorr3785 T1764 T3373 T1764 T3373 -4.3558908727120187e-07
Gcorr3786 T1764 T3482 T1764 T3482 -3.8846432910566435e-07
Rt11149 T1764 T3817 511789.51766379637
Gcorr3787 T1764 T4124 T1764 T4124 -5.0080149719220751e-07
Rt11150 T1765 T1916 19411220.665270403
Rt11151 T1765 T1952 4573293.1507474072
Rt11152 T1765 T1953 8941894.7443822119
Rt11153 T1765 T2321 3612270.5545597286
Rt11154 T1765 T2884 2128348.8948011599
Rt11155 T1765 T3644 11948013.941736279
Gcorr3788 T1765 T3645 T1765 T3645 -1.1181694428939328e-07
Gcorr3789 T1766 T1939 T1766 T1939 -2.2074641622759821e-07
Rt11156 T1766 T2340 4941266.4486542782
Rt11157 T1766 T2633 1277278.8950046061
Gcorr3790 T1766 T2662 T1766 T2662 -1.5076195272792216e-08
Rt11158 T1766 T2904 671153.45849709737
Rt11159 T1766 T2939 1240324.4512526204
Rt11160 T1766 T3662 1641494.204814085
Rt11161 T1766 T4015 1835937.3136911832
Rt11162 T1767 T1768 11270449.105990006
Rt11163 T1767 T2294 332683867.00000417
Rt11164 T1767 T2353 3559228.2768446212
Rt11165 T1767 T2471 3045802.8927529552
Rt11166 T1767 T2697 11778134.121575456
Rt11167 T1767 T3272 1201811.052567401
Rt11168 T1767 T3273 8731321.5220986865
Rt11169 T1767 T3274 3892738.4552930002
Gcorr3791 T1767 T3786 T1767 T3786 -2.2190143771061752e-07
Gcorr3792 T1768 T2014 T1768 T2014 -1.4921253603760258e-07
Rt11170 T1768 T2353 11924200.302938888
Rt11171 T1768 T2575 3340471.921406392
Rt11172 T1768 T2687 2357635.9338950519
Gcorr3793 T1768 T3270 T1768 T3270 -1.2603760882951333e-07
Rt11173 T1768 T3271 1817898.7934201884
Rt11174 T1768 T3272 2004343.6065207897
Rt11175 T1768 T4083 2491238.9727344438
Rt11176 T1769 T1770 4199349.561118695
Rt11177 T1769 T2164 8292563.4749400821
Rt11178 T1769 T2266 3774207.2672407767
Rt11179 T1769 T2329 3924525.0876330058
Rt11180 T1769 T2616 14727165.531219473
Rt11181 T1769 T3201 2835113.8062530369
Gcorr3794 T1769 T3326 T1769 T3326 -1.7433111731882678e-07
Gcorr3795 T1769 T3488 T1769 T3488 -4.1341206566514719e-08
Gcorr3796 T1769 T3657 T1769 T3657 -7.9035419274178587e-08
Rt11182 T1769 T3902 1876229.1467931294
Rt11183 T1770 T2266 6721940.7262496017
Rt11184 T1770 T2342 3407394.6309012244
Rt11185 T1770 T2480 6586519.8096181275
Rt11186 T1770 T3017 2904456.2937078443
Gcorr3797 T1770 T3201 T1770 T3201 -3.7763316845671521e-08
Rt11187 T1770 T3326 4623145.0571397441
Rt11188 T1771 T2299 10187854.015543971
Rt11189 T1771 T2395 11286837.862368993
Rt11190 T1771 T2496 4300514.7487912597
Rt11191 T1771 T2674 3279098.0906393034
Gcorr3798 T1771 T2745 T1771 T2745 -1.4897015040704849e-07
Rt11192 T1771 T3043 3522450.9324100795
Rt11193 T1771 T3075 2897118.2475048811
Gcorr3799 T1771 T3076 T1771 T3076 -4.3730941954030024e-08
Rt11194 T1772 T1948 5691142.3792603072
Rt11195 T1772 T1949 14945065.236700084
Rt11196 T1772 T1966 4278478.4933723127
Rt11197 T1772 T2712 2245515.980129275
Gcorr3800 T1772 T3062 T1772 T3062 -1.5589854314426254e-07
Rt11198 T1772 T3227 1821728.9295800403
Rt11199 T1772 T3228 6019664.257323374
Rt11200 T1772 T3447 3549768.4981463482
Gcorr3801 T1772 T3566 T1772 T3566 -8.2320108965952144e-08
Rt11201 T1773 T1815 3827676.0675819395
Rt11202 T1773 T1824 2856648.122638314
Gcorr3802 T1773 T2034 T1773 T2034 -6.9395620527148256e-09
Rt11203 T1773 T2347 1304373.847097205
Rt11204 T1773 T2790 37868782.60735324
Gcorr3803 T1773 T3857 T1773 T3857 -1.0944502083409934e-07
Rt11205 T1774 T1775 5194950.9826895595
Rt11206 T1774 T1776 13345054.141070206
Rt11207 T1774 T1959 4477668.2048118236
Rt11208 T1774 T2459 2391589.1945425514
Rt11209 T1775 T1776 4661667.9746217439
Rt11210 T1775 T2070 10648377.13282679
Rt11211 T1775 T2143 4543602.4056616556
Rt11212 T1775 T2382 3337168.7252287702
Gcorr3804 T1775 T3663 T1775 T3663 -1.4256868268418808e-07
Rt11213 T1776 T2070 2686542.4968615067
Rt11214 T1776 T2344 1596204.1547164479
Rt11215 T1776 T2459 3454543.9465795429
Rt11216 T1776 T2726 863762.8561662056
Rt11217 T1777 T1866 4473214.6761252675
Rt11218 T1777 T1867 4235342.8421747703
Rt11219 T1777 T2480 8938169.2679743115
Rt11220 T1777 T2547 3228619.0904319552
Rt11221 T1777 T3056 600758.73977668735
Gcorr3805 T1777 T3065 T1777 T3065 -9.9829565969904696e-08
Rt11222 T1777 T3066 10221053.84402076
Gcorr3806 T1777 T3357 T1777 T3357 -1.0271661482331409e-06
Rt11223 T1777 T4161 15443948.481821766
Gcorr3807 T1778 T2106 T1778 T2106 -1.7203681686504054e-08
Rt11224 T1778 T2386 8598051.6074101459
Rt11225 T1778 T2597 2362349.7400144427
Rt11226 T1778 T2696 2559261.179683717
Rt11227 T1779 T1852 1809885.4215940398
Rt11228 T1779 T1869 5273145.8063268894
Rt11229 T1779 T2027 3723588.1062974362
Rt11230 T1779 T2082 10359974.893095728
Rt11231 T1779 T2666 2450550.2704572333
Gcorr3808 T1779 T3045 T1779 T3045 -6.9771862410162057e-07
Rt11232 T1779 T3047 4032547.6717232019
Gcorr3809 T1779 T3086 T1779 T3086 -1.5860591789779293e-07
Rt11233 T1779 T3207 423699.92344230192
Gcorr3810 T1779 T3692 T1779 T3692 -5.804843629307825e-07
Rt11234 T1780 T2350 4260054.8753165621
Rt11235 T1780 T2485 9156588.6649892051
Rt11236 T1780 T2546 2485270.2426818344
Rt11237 T1780 T2549 7649790.445906328
Rt11238 T1780 T2946 2820576.5821263487
Rt11239 T1780 T3590 782364.62407501077
Rt11240 T1780 T3856 10555259.334549377
Gcorr3811 T1780 T3906 T1780 T3906 -5.9451795305158223e-08
Gcorr3812 T1780 T4196 T1780 T4196 -8.305270914551036e-08
Rt11241 T1781 T1782 3672768.0379857919
Rt11242 T1781 T2472 2882835.9124696292
Rt11243 T1781 T2473 12109732.924636884
Rt11244 T1781 T3363 2180701.6148550618
Rt11245 T1781 T3365 23705093.831094682
Rt11246 T1781 T3366 12413648.810055571
Rt11247 T1781 T3621 2103980.8384935567
Gcorr3813 T1782 T2445 T1782 T2445 -2.8605909588596342e-08
Rt11248 T1782 T2462 2070813.1278265752
Rt11249 T1782 T2473 11395430.958344383
Rt11250 T1782 T2678 1915077.8574469129
Rt11251 T1782 T3366 865566.98027261405
Gcorr3814 T1782 T3621 T1782 T3621 -4.7885524778617696e-08
Rt11252 T1782 T3855 1026214.359205622
Gcorr3815 T1782 T3970 T1782 T3970 -3.7088173467556948e-07
Gcorr3816 T1782 T4166 T1782 T4166 -4.7987709002782526e-08
Rt11253 T1783 T1860 4178193.3770381561
Rt11254 T1783 T1889 10929163.249674439
Rt11255 T1783 T2284 728481.09314709587
Rt11256 T1783 T2502 3553972.6576829706
Rt11257 T1783 T3491 5326188.9393551676
Gcorr3817 T1783 T3497 T1783 T3497 -5.7317630137289567e-08
Rt11258 T1783 T3498 659918.9327367451
Gcorr3818 T1783 T3555 T1783 T3555 -1.067698237580607e-06
Gcorr3819 T1783 T4127 T1783 T4127 -1.0103891172808243e-07
Rt11259 T1784 T2076 15103144.710669104
Rt11260 T1784 T2077 19150268.808006179
Rt11261 T1784 T2195 10251725.640366349
Rt11262 T1784 T2454 923872.54166729271
Gcorr3820 T1784 T3343 T1784 T3343 -6.4788566964752469e-07
Rt11263 T1784 T3739 1369180.1501403684
Rt11264 T1784 T3742 1866285.7381778511
Rt11265 T1785 T1794 4105412.4767520474
Gcorr3821 T1785 T1943 T1785 T1943 -1.4987821118333753e-08
Rt11266 T1785 T2265 12963233.377234176
Rt11267 T1785 T2567 3491407.0167230014
Rt11268 T1785 T2597 3757240.2806404666
Rt11269 T1786 T2038 1732152.5692967868
Rt11270 T1786 T2262 1412009.2993516503
Rt11271 T1786 T2309 2065223.6762189525
Rt11272 T1786 T2391 1458840.0161666831
Rt11273 T1787 T2084 4920726.6966290511
Rt11274 T1787 T2095 4538959.9754294865
Rt11275 T1787 T2179 4378581.0192564903
Rt11276 T1787 T2221 4701306.7212683959
Rt11277 T1788 T2219 3860889.5168346581
Rt11278 T1788 T2225 5437655.281066495
Rt11279 T1788 T2332 19046642.147520762
Rt11280 T1788 T2553 3122145.0904131257
Rt11281 T1788 T3459 12900052.038835015
Rt11282 T1788 T3494 20210929.72881208
Rt11283 T1788 T3546 5262342.6668778351
Rt11284 T1788 T4167 6310696.3237802451
Rt11285 T1789 T2085 7677622.8826114843
Rt11286 T1789 T2159 5580968.9551071115
Rt11287 T1789 T2691 8754558.4354821797
Rt11288 T1789 T2723 2239689.9016425102
Rt11289 T1790 T1868 15101279.795644119
Rt11290 T1790 T2204 1475399.1925713143
Rt11291 T1790 T2479 7785798.9563894253
Rt11292 T1790 T2535 3330205.1332561583
Rt11293 T1791 T2063 4723102.5832415624
Rt11294 T1791 T2186 11529560.077648971
Rt11295 T1791 T2205 16273235.489970645
Rt11296 T1791 T2212 3932801.057457603
Rt11297 T1792 T2096 4390043.7218712559
Rt11298 T1792 T2118 9468467.5051423609
Rt11299 T1792 T2120 623492.94414565468
Rt11300 T1792 T2237 9510975.3521678969
Rt11301 T1793 T2019 7531408.8000714229
Rt11302 T1793 T2126 4465675.5345426556
Rt11303 T1793 T2128 11799633.671285857
Rt11304 T1793 T2596 4840207.6454496477
Rt11305 T1793 T2626 11950008.865265708
Gcorr3822 T1793 T2770 T1793 T2770 -7.721728285868321e-08
Rt11306 T1793 T3215 15148869.258357391
Rt11307 T1793 T4095 7017866.4803523095
Rt11308 T1794 T2136 10826851.824569354
Rt11309 T1794 T2156 3974474.7682162756
Rt11310 T1794 T2163 4129805.8398767663
Rt11311 T1794 T2265 9880175.3891265988
Gcorr3823 T1795 T2301 T1795 T2301 -1.2582877099081919e-08
Rt11312 T1795 T2328 5203288.2743220972
Rt11313 T1795 T2493 1418058.5025630067
Rt11314 T1795 T2603 10774716.484354937
Gcorr3824 T1795 T2908 T1795 T2908 -1.1337876868568147e-07
Rt11315 T1795 T2909 3142569.275529963
Rt11316 T1795 T2952 996924.46228784905
Rt11317 T1795 T2953 1932018.3102193719
Gcorr3825 T1795 T2979 T1795 T2979 -5.5334560020122283e-07
Rt11318 T1796 T1797 10986312.612406956
Rt11319 T1796 T2140 10441099.279196132
Rt11320 T1796 T2165 5964325.539970451
Rt11321 T1796 T2348 4382819.0558103966
Rt11322 T1796 T2822 8941975.9132852778
Rt11323 T1797 T1833 4676946.8228708515
Rt11324 T1797 T1834 3958104.0888532121
Rt11325 T1797 T2004 16833215.773587175
Rt11326 T1797 T2348 2126446.8136911392
Rt11327 T1797 T2822 1705928.2877351712
Gcorr3826 T1797 T2823 T1797 T2823 -1.6045497488160571e-07
Rt11328 T1797 T2848 7166148.4773519151
Rt11329 T1797 T3564 3777091.8505453677
Gcorr3827 T1797 T3763 T1797 T3763 -3.4352282995604819e-07
Rt11330 T1798 T1799 4625249.9724875139
Rt11331 T1798 T1800 5769132.5868689101
Rt11332 T1798 T2024 8264788.2156692864
Gcorr3828 T1798 T2398 T1798 T2398 -8.0129866872107366e-08
Rt11333 T1798 T3016 2156915.5891630333
Rt11334 T1798 T3059 4272043.5736048687
Rt11335 T1798 T3111 1691081.9436778896
Rt11336 T1798 T3939 4082303.404256735
Rt11337 T1799 T2215 4673983.7799093742
Rt11338 T1799 T2263 3448080.1311469204
Rt11339 T1799 T2398 3600766.7852617051
Rt11340 T1799 T2634 3653640.8268175879
Gcorr3829 T1799 T2915 T1799 T2915 -2.1572797538492398e-07
Rt11341 T1799 T3011 1257637.4524841646
Rt11342 T1799 T3015 2774094.1061397158
Rt11343 T1799 T3016 1698868.9534155577
Gcorr3830 T1799 T3939 T1799 T3939 -1.3948023810594632e-07
Gcorr3831 T1799 T4194 T1799 T4194 -1.0730235636770847e-07
Rt11344 T1800 T1893 3721973.8451327905
Gcorr3832 T1800 T1894 T1800 T1894 -1.6882578291515022e-08
Rt11345 T1800 T2024 6862019.1022007512
Rt11346 T1800 T2514 2455054.2736299736
Rt11347 T1800 T3059 6040203.2646600939
Gcorr3833 T1800 T3089 T1800 T3089 -1.9473514655837429e-07
Rt11348 T1800 T3111 1978108.7032302888
Gcorr3834 T1800 T3776 T1800 T3776 -2.0933255058971241e-07
Rt11349 T1800 T3822 708106.71789500199
Rt11350 T1801 T2045 2076162.1194158206
Rt11351 T1801 T2179 5017033.1768141156
Rt11352 T1801 T2221 1692832.6160453476
Rt11353 T1801 T2296 4653132.7807040401
Gcorr3835 T1801 T2846 T1801 T2846 -4.2628653676570436e-07
Rt11354 T1801 T3766 3460629.8107889458
Rt11355 T1802 T1857 18780033.489242818
Rt11356 T1802 T2035 5412819.8894543797
Rt11357 T1802 T2362 14247396.718379818
Rt11358 T1802 T2668 2067048.2706667276
Gcorr3836 T1802 T3306 T1802 T3306 -9.7637667634940794e-08
Rt11359 T1802 T3307 2084147.1467112587
Rt11360 T1802 T3311 2801294.9171331823
Rt11361 T1802 T3312 29546904.886633486
Rt11362 T1803 T2045 5198828.150952084
Rt11363 T1803 T2296 4775032.2881740471
Rt11364 T1803 T2354 1788055.744233476
Rt11365 T1803 T2355 3427928.2256807182
Rt11366 T1803 T3545 4896228.2284331415
Rt11367 T1803 T3788 9935918.2745627463
Rt11368 T1804 T1805 27766307.821183626
Rt11369 T1804 T1903 13559902.214372866
Rt11370 T1804 T2452 8461783.3304892574
Rt11371 T1804 T2453 12540400.756194206
Rt11372 T1804 T2676 13595349.046120333
Rt11373 T1804 T2806 1982209.6325385135
Gcorr3837 T1804 T2807 T1804 T2807 -4.046954029652812e-08
Rt11374 T1804 T2808 1857123.4250614333
Rt11375 T1804 T3977 4916211.0946527421
Gcorr3838 T1805 T1968 T1805 T1968 -7.5024558038743297e-08
Rt11376 T1805 T2552 3313185.4828916355
Rt11377 T1805 T2623 6092516.9403208653
Rt11378 T1805 T2676 3898959.6238702023
Gcorr3839 T1805 T2807 T1805 T2807 -5.8903660360492277e-07
Rt11379 T1805 T2808 1098406.9392181062
Rt11380 T1805 T2809 1263540.8446520951
Rt11381 T1805 T2810 2191302.0120182531
Gcorr3840 T1805 T2811 T1805 T2811 -1.6200433745390709e-08
Rt11382 T1806 T2079 3316715.108221211
Rt11383 T1806 T2080 14343353.009470489
Rt11384 T1806 T2548 3136837.0137197399
Rt11385 T1806 T2649 12142048.254853569
Gcorr3841 T1807 T2261 T1807 T2261 -3.9581717548822008e-07
Gcorr3842 T1807 T2449 T1807 T2449 -1.5685932442770513e-07
Rt11386 T1807 T2450 5547511.4897554768
Rt11387 T1807 T2653 1899250.1545257235
Rt11388 T1807 T3208 593323.35275880608
Rt11389 T1807 T3430 7403836.0089261271
Gcorr3843 T1807 T3520 T1807 T3520 -1.9875396219956056e-06
Rt11390 T1807 T3837 5896932.4771463573
Rt11391 T1807 T3979 200429.29606335508
Rt11392 T1808 T1883 20722684.49352755
Rt11393 T1808 T2287 10705389.479889087
Rt11394 T1808 T2288 1348688.4646233197
Rt11395 T1808 T2541 3706776.0760649443
Rt11396 T1808 T3170 14265589.244551631
Rt11397 T1808 T3689 5300102.6612632414
Rt11398 T1808 T3690 418376.595593401
Gcorr3844 T1808 T3753 T1808 T3753 -5.8263736887442924e-07
Rt11399 T1809 T2071 1588933.1717051896
Gcorr3845 T1809 T2242 T1809 T2242 -3.912079409012462e-08
Rt11400 T1809 T2370 21591678.862262502
Rt11401 T1809 T2565 40501969.439478837
Rt11402 T1809 T2714 3780443.3495585234
Rt11403 T1809 T3013 1962492.9464098907
Rt11404 T1809 T3034 3463649.9028286785
Rt11405 T1809 T3176 759442.55548112595
Gcorr3846 T1809 T3847 T1809 T3847 -6.1641652631427639e-07
Rt11406 T1810 T1854 18756340.407802779
Rt11407 T1810 T1870 4915457.4908718728
Gcorr3847 T1810 T2363 T1810 T2363 -1.3413470652016494e-07
Rt11408 T1810 T2484 1878010.8981072824
Rt11409 T1810 T2975 1644079.9172562624
Rt11410 T1810 T3051 11298906.540926693
Rt11411 T1810 T3203 2013153.1776252312
Gcorr3848 T1810 T3790 T1810 T3790 -3.7605207615084583e-08
Rt11412 T1811 T1812 7890601.6619188441
Rt11413 T1811 T2077 4796445.235717345
Rt11414 T1811 T2508 2576554.6429613512
Rt11415 T1812 T1913 16582115.51083746
Rt11416 T1812 T2336 3524557.7053157953
Rt11417 T1812 T2337 1854618.4037878455
Rt11418 T1812 T2508 14194992.050835185
Rt11419 T1812 T2631 1502009.4189963278
Rt11420 T1813 T1817 6482549.0468081096
Rt11421 T1813 T2252 71468565.079783186
Rt11422 T1813 T2404 8154379.0611818479
Rt11423 T1813 T2585 1720163.7684614046
Gcorr3849 T1813 T3278 T1813 T3278 -1.402128884207417e-07
Rt11424 T1813 T3279 753242.81905972632
Rt11425 T1813 T3567 2401766.7956881323
Gcorr3850 T1813 T4006 T1813 T4006 -1.2246780189710956e-07
Rt11426 T1814 T2012 5008437.1719311075
Rt11427 T1814 T2206 4208897.1150973765
Gcorr3851 T1814 T2344 T1814 T2344 -2.5847205854189729e-09
Gcorr3852 T1814 T2459 T1814 T2459 -2.7316080966193443e-08
Rt11428 T1814 T2726 2112649.2065276951
Gcorr3853 T1814 T3889 T1814 T3889 -1.4555397850108667e-07
Rt11429 T1814 T4182 8751425.7792142369
Rt11430 T1815 T2034 1627534.0727683937
Rt11431 T1815 T2091 11537371.652058464
Rt11432 T1815 T2274 3233003.9976903759
Rt11433 T1815 T2495 4304597.3109107967
Gcorr3854 T1816 T1858 T1816 T1858 -2.301946391115491e-07
Rt11434 T1816 T2516 3666129.6486140764
Rt11435 T1816 T2595 1740995.9748595229
Rt11436 T1816 T2947 1157195.4969009971
Rt11437 T1816 T3473 1118864.5473615588
Rt11438 T1816 T4104 2648691.221133058
Gcorr3855 T1817 T2404 T1817 T2404 -7.4897486619471168e-08
Rt11439 T1817 T2424 5418259.190281109
Rt11440 T1817 T2559 948789.01683873904
Gcorr3856 T1817 T2617 T1817 T2617 -2.6689137226255552e-08
Rt11441 T1817 T3278 1105847.7891916495
Rt11442 T1817 T3355 1157265.9060372792
Rt11443 T1817 T3567 1005633.6023850449
Gcorr3857 T1817 T3784 T1817 T3784 -6.6236247242896208e-07
Rt11444 T1818 T1819 5238735.0134462984
Rt11445 T1818 T1820 17579178.039912861
Rt11446 T1818 T1993 2092302.6146993639
Rt11447 T1818 T2351 2580264.6893820888
Gcorr3858 T1818 T2798 T1818 T2798 -2.7733480079873391e-07
Gcorr3859 T1818 T3368 T1818 T3368 -1.157235754534088e-07
Gcorr3860 T1818 T3666 T1818 T3666 -5.8585403889104879e-06
Gcorr3861 T1818 T3814 T1818 T3814 -7.9450708695587454e-08
Rt11448 T1818 T4030 151026.17686705568
Rt11449 T1818 T4192 3212112.7417419269
Rt11450 T1819 T1820 5377204.7243290842
Rt11451 T1819 T1821 1127526.450943778
Rt11452 T1819 T1832 4386690.0427587777
Rt11453 T1819 T2612 6140246.6386415102
Gcorr3862 T1819 T3367 T1819 T3367 -6.1787480390053559e-07
Rt11454 T1819 T3368 961327.52580398566
Rt11455 T1819 T3369 4766586.1079003662
Rt11456 T1819 T4029 15752549.679358916
Gcorr3863 T1819 T4192 T1819 T4192 -7.851489063978218e-08
Rt11457 T1820 T1832 14928551.978480661
Rt11458 T1820 T2331 4059173.1270065475
Rt11459 T1820 T2351 3917145.2465285691
Rt11460 T1820 T2448 4568529.7551583797
Gcorr3864 T1820 T2799 T1820 T2799 -1.0639395826842715e-07
Rt11461 T1820 T3816 5219916.1843458097
Rt11462 T1820 T4029 3403276.1582668447
Rt11463 T1820 T4192 8009241.9795368547
Rt11464 T1821 T2292 41357088.942723356
Rt11465 T1821 T2322 4104583.3872642359
Rt11466 T1821 T2472 1825591.3181206095
Rt11467 T1821 T2612 660658.6730147691
Gcorr3865 T1821 T3364 T1821 T3364 -6.0565069503264863e-07
Gcorr3866 T1821 T3365 T1821 T3365 -2.5650227621576073e-07
Rt11468 T1821 T3367 278113.83032931929
Gcorr3867 T1821 T3368 T1821 T3368 -6.0961891259416148e-07
Gcorr3868 T1821 T3369 T1821 T3369 -1.0951126771630234e-06
Gcorr3869 T1821 T3825 T1821 T3825 -1.593000700886471e-07
Rt11469 T1822 T1862 2694202.9476670101
Rt11470 T1822 T2023 3881147.2224714216
Rt11471 T1822 T2051 3116082.3753120168
Rt11472 T1822 T2659 5109230.522811655
Gcorr3870 T1822 T3012 T1822 T3012 -4.9607677940570141e-07
Rt11473 T1822 T3372 112306925.1449917
Rt11474 T1822 T3373 972320.39662884839
Gcorr3871 T1822 T3772 T1822 T3772 -3.0491372226403573e-07
Gcorr3872 T1822 T3817 T1822 T3817 -5.3912274433938765e-07
Rt11475 T1822 T4124 751206.87284924579
Rt11476 T1823 T2058 10506597.306420192
Rt11477 T1823 T2254 3512260.3249092414
Rt11478 T1823 T2501 3458405.3108866224
Rt11479 T1823 T2643 3012764.3144504409
Rt11480 T1823 T2886 8180703.9944368685
Gcorr3873 T1823 T3638 T1823 T3638 -1.1867047025045986e-07
Rt11481 T1823 T3756 1735235.5219714248
Rt11482 T1823 T3877 29097804.39325485
Rt11483 T1824 T2092 2968747.9969631569
Rt11484 T1824 T2347 41638260.039355025
Rt11485 T1824 T2509 6248839.8725290913
Rt11486 T1824 T2534 1811527.6571161563
Rt11487 T1824 T2790 27070788.499927852
Rt11488 T1824 T3453 227167239.68256667
Gcorr3874 T1824 T3568 T1824 T3568 -5.9317584017838033e-08
Rt11489 T1824 T3857 1462831.2327630555
Gcorr3875 T1825 T2075 T1825 T2075 -2.7206255779134569e-07
Gcorr3876 T1825 T2411 T1825 T2411 -2.2550965595576617e-07
Rt11490 T1825 T2521 6173233.7322697975
Rt11491 T1825 T2698 820713.11006372713
Rt11492 T1825 T2816 544210.82217851165
Gcorr3877 T1825 T2817 T1825 T2817 -5.3337085704239379e-07
Rt11493 T1825 T2820 587126.26409593143
Rt11494 T1825 T2941 94920883.329729825
Rt11495 T1826 T2467 3715285.7066418957
Rt11496 T1826 T2468 5348233.9705733117
Gcorr3878 T1826 T2469 T1826 T2469 -5.1155829413909757e-08
Rt11497 T1826 T2733 3394280.6684813043
Rt11498 T1826 T3129 2223335.6473482493
Gcorr3879 T1826 T3151 T1826 T3151 -9.557618103929807e-08
Rt11499 T1826 T3437 4402656.2597359326
Rt11500 T1826 T3882 2115999.3820029283
Rt11501 T1827 T1942 3275990.3183636544
Rt11502 T1827 T2003 6520382.3435204318
Rt11503 T1827 T2139 3684880.665463544
Rt11504 T1827 T2440 8373570.8477745922
Rt11505 T1827 T3146 2640183.4056742289
Gcorr3880 T1827 T3148 T1827 T3148 -1.5465216319760282e-07
Rt11506 T1827 T3221 2627288.0865105265
Rt11507 T1827 T3532 8850629.4722520877
Gcorr3881 T1827 T3936 T1827 T3936 -8.1482854758083823e-08
Gcorr3882 T1828 T2015 T1828 T2015 -2.1912316555581287e-08
Rt11508 T1828 T2208 4871438.548244589
Rt11509 T1828 T2605 7894207.8963262709
Rt11510 T1828 T2682 706020.30326867022
Gcorr3883 T1828 T3004 T1828 T3004 -7.0696165845615043e-07
Rt11511 T1828 T3385 2225875.8731574784
Rt11512 T1828 T4135 604226.69078867242
Rt11513 T1829 T2010 4344830.3588282159
Rt11514 T1829 T2379 43933748.388988107
Rt11515 T1829 T2522 2943163.8672677637
Rt11516 T1829 T2677 2683374.5423772619
Gcorr3884 T1829 T2854 T1829 T2854 -1.0783767880210684e-07
Rt11517 T1829 T3615 444166.05910147674
Gcorr3885 T1829 T4063 T1829 T4063 -1.8743510756173346e-06
Rt11518 T1830 T2487 3216950.3079826054
Rt11519 T1830 T2558 3033764.477905347
Rt11520 T1830 T2994 1586195.8647264575
Rt11521 T1830 T3967 1221296.1165471424
Rt11522 T1830 T4007 14980942.066094205
Rt11523 T1831 T1891 4807582.2668080404
Rt11524 T1831 T1923 5502494.8071593633
Rt11525 T1831 T2400 5643509.800206813
Rt11526 T1831 T2574 3407015.009346663
Gcorr3886 T1831 T2876 T1831 T2876 -4.2725411091700517e-07
Gcorr3887 T1831 T3789 T1831 T3789 -1.7150364057208292e-07
Rt11527 T1832 T2291 202016502.13897952
Rt11528 T1832 T2448 3891205.974408464
Rt11529 T1832 T2612 3180311.3763042167
Rt11530 T1832 T2618 2896310.6778182271
Rt11531 T1832 T3369 30113213.537930418
Rt11532 T1832 T3677 3087822.5739660519
Rt11533 T1832 T3678 38231352.699105874
Rt11534 T1832 T4029 6934025.063121601
Rt11535 T1833 T1834 4495134.8122732481
Rt11536 T1833 T1835 11399303.585385069
Rt11537 T1833 T2190 5154500.8620445766
Rt11538 T1833 T2639 3462320.0059364396
Rt11539 T1833 T2823 21776865.956783969
Rt11540 T1833 T2848 6017720.5332357902
Rt11541 T1833 T2849 5734568.052794287
Rt11542 T1833 T2887 16088429.788393602
Rt11543 T1834 T1835 2723543.1872127824
Rt11544 T1834 T1836 11155564.676031174
Rt11545 T1834 T1837 4973943.6902676038
Rt11546 T1834 T2004 27649407.394688997
Rt11547 T1834 T2848 6482140.7034996701
Gcorr3888 T1834 T2887 T1834 T2887 -1.4843084274471052e-07
Rt11548 T1834 T2980 2034811.4858504152
Rt11549 T1834 T3564 11559744.810666349
Rt11550 T1835 T1836 1708238.2285840008
Rt11551 T1835 T1838 5793421.5330417836
Rt11552 T1835 T2325 6193712.5028433148
Rt11553 T1835 T2639 3080821.5588352764
Rt11554 T1835 T2887 883456.96688105178
Gcorr3889 T1835 T2980 T1835 T2980 -4.2049632773652903e-07
Gcorr3890 T1835 T2981 T1835 T2981 -1.6079881483066401e-07
Gcorr3891 T1835 T3791 T1835 T3791 -9.4431784617201468e-08
Rt11555 T1835 T4027 6651688.4389881017
Rt11556 T1836 T1837 4824910.1896887124
Rt11557 T1836 T1838 15238404.013372909
Rt11558 T1836 T1839 17039834.443038072
Rt11559 T1836 T2702 3764887.0869349372
Gcorr3892 T1836 T2887 T1836 T2887 -4.2135039628277751e-07
Rt11560 T1836 T2980 2741981.251121317
Rt11561 T1836 T2981 1707266.5510262598
Rt11562 T1836 T3080 6433850.9901605844
Rt11563 T1837 T1839 4853135.3662608974
Rt11564 T1837 T1840 3218939.9468072969
Rt11565 T1837 T1947 17439445.69321518
Rt11566 T1837 T2004 3088316.6169039188
Rt11567 T1837 T2980 6518004.7779970001
Rt11568 T1837 T3080 5647442.4723376986
Rt11569 T1837 T3431 1335942.4171864309
Gcorr3893 T1837 T3549 T1837 T3549 -1.9420402740044147e-07
Gcorr3894 T1837 T3564 T1837 T3564 -1.4076531460181967e-07
Gcorr3895 T1838 T2289 T1838 T2289 -6.3914324079177738e-08
Rt11570 T1838 T2325 3001408.8508180454
Rt11571 T1838 T2392 7833275.4867453091
Rt11572 T1838 T2494 33164974.898053173
Rt11573 T1838 T2702 3136806.9470862178
Rt11574 T1838 T2981 6153622.056126833
Rt11575 T1838 T3082 1238473.8134277554
Rt11576 T1838 T4027 2580602.348050755
Gcorr3896 T1838 T4077 T1838 T4077 -1.6588517490821001e-07
Rt11577 T1839 T1840 11119456.392662361
Rt11578 T1839 T1844 5976750.3739620028
Rt11579 T1839 T1988 7463007.6745509943
Rt11580 T1839 T2702 2358771.717800892
Rt11581 T1839 T3080 1818537.2650643338
Gcorr3897 T1839 T3081 T1839 T3081 -1.4324929702077346e-07
Rt11582 T1839 T3549 11391209.205684464
Rt11583 T1839 T4120 2682130.3687584093
Rt11584 T1840 T1844 12349472.500144143
Rt11585 T1840 T1947 4445820.4104747595
Rt11586 T1840 T1960 12378896.838371493
Rt11587 T1840 T2072 3771613.3456600141
Gcorr3898 T1840 T3431 T1840 T3431 -1.7321241405670163e-07
Rt11588 T1840 T3549 1287632.8484123433
Rt11589 T1840 T4064 4409676.1524289269
Rt11590 T1841 T1843 4558389.0105281314
Rt11591 T1841 T2456 5509273.6681323964
Rt11592 T1841 T2506 4358326.8953864528
Rt11593 T1841 T2621 33651511.153900027
Rt11594 T1841 T2960 1276864.0703242968
Gcorr3899 T1841 T2993 T1841 T2993 -2.4238693512080241e-08
Rt11595 T1841 T3037 1616726.617046786
Gcorr3900 T1841 T3138 T1841 T3138 -4.8659290950679861e-08
Rt11596 T1842 T2125 10155682.161906164
Rt11597 T1842 T2233 12184342.336524144
Rt11598 T1842 T2248 5030932.6342636906
Rt11599 T1842 T2324 3619648.1551134968
Gcorr3901 T1842 T3468 T1842 T3468 -5.5881794855207521e-09
Rt11600 T1842 T3652 3919457.5805858979
Rt11601 T1842 T4114 2999946.8671000525
Rt11602 T1843 T2072 2186533.3461249373
Rt11603 T1843 T2498 3973257.3029415752
Rt11604 T1843 T2506 14277090.564205319
Rt11605 T1843 T2905 34928391.937412441
Gcorr3902 T1843 T2931 T1843 T2931 -3.4458983635664431e-07
Rt11606 T1843 T2960 3875992.0733202072
Rt11607 T1843 T3138 2524008.7818216993
Rt11608 T1843 T3905 1097630.9003418335
Rt11609 T1844 T1988 892961.23207309027
Rt11610 T1844 T2072 1808808.1333477509
Rt11611 T1844 T2498 1537029.7081858381
Gcorr3903 T1844 T3172 T1844 T3172 -6.6793702412717558e-07
Rt11612 T1844 T3549 22301386.439761072
Rt11613 T1844 T3550 520214.18973492127
Gcorr3904 T1844 T3905 T1844 T3905 -4.1987683924074227e-07
Rt11614 T1844 T4120 12121634.176498411
Gcorr3905 T1845 T2456 T1845 T2456 -4.6904423901276527e-08
Rt11615 T1845 T2684 4661411.4962387029
Rt11616 T1845 T2685 1508164.6408420841
Rt11617 T1845 T3159 1234894.7394428989
Rt11618 T1845 T3709 2971563.4270183006
Rt11619 T1845 T3710 632566.64806584758
Rt11620 T1846 T2092 11535979.629462847
Rt11621 T1846 T2243 52278434.307737857
Rt11622 T1846 T2509 2791326.7169423979
Rt11623 T1846 T2710 2630321.8942909865
Rt11624 T1846 T3291 3658489.0206655632
Rt11625 T1846 T3293 16329625.046188185
Rt11626 T1846 T3353 3819965.3691422208
Rt11627 T1846 T3453 7865465.899357697
Rt11628 T1847 T1848 5138494.3036664966
Rt11629 T1847 T1849 3777501.2593507566
Rt11630 T1847 T2295 3958485.6010668036
Rt11631 T1847 T2395 8286102.0509626418
Rt11632 T1847 T2761 27488398.517867476
Rt11633 T1847 T2802 12387120.609108496
Rt11634 T1847 T3445 1933053.0002102843
Gcorr3906 T1847 T3737 T1847 T3737 -1.2490093232531939e-07
Gcorr3907 T1847 T3880 T1847 T3880 -3.8046572046219536e-08
Rt11635 T1848 T2044 4870339.460716757
Rt11636 T1848 T2184 5172226.3644201448
Rt11637 T1848 T2229 4326680.8108085636
Rt11638 T1848 T2295 4938838.3995505543
Rt11639 T1848 T2761 2976710.2519498761
Rt11640 T1848 T3880 10305381.485768793
Rt11641 T1849 T1903 4259011.983602195
Rt11642 T1849 T2357 19473188.757924449
Rt11643 T1849 T2395 5071260.5735372612
Rt11644 T1849 T2674 3171990.3609102196
Gcorr3908 T1849 T3445 T1849 T3445 -1.2237528644826901e-07
Rt11645 T1849 T3737 2799423.0530339628
Rt11646 T1849 T3738 11388310.655781778
Rt11647 T1849 T3955 5139233.8132396778
Rt11648 T1850 T2338 41798507.270039201
Rt11649 T1850 T2518 1976755.9367440108
Rt11650 T1850 T2525 780929.9234504085
Gcorr3909 T1850 T3302 T1850 T3302 -1.085041650981749e-06
Rt11651 T1850 T3303 475394.48744784598
Rt11652 T1850 T3304 2175601.306324326
Rt11653 T1850 T3305 14977003.011656264
Rt11654 T1851 T2419 2617618.8555254801
Rt11655 T1851 T2447 2657704.6568817012
Rt11656 T1851 T2642 2452804.1478077187
Gcorr3910 T1851 T3413 T1851 T3413 -3.0653432496184134e-08
Rt11657 T1851 T3414 1874735.4672668243
Gcorr3911 T1851 T3417 T1851 T3417 -3.8404612487366195e-08
Rt11658 T1851 T3846 89099815.236127615
Rt11659 T1852 T2027 10992257.873542979
Rt11660 T1852 T2387 3970970.8807111727
Rt11661 T1852 T2577 2529074.5370243238
Rt11662 T1852 T2624 41602737.424369663
Rt11663 T1852 T3045 1732853.284194638
Rt11664 T1852 T3164 27610417.13485131
Gcorr3912 T1852 T3207 T1852 T3207 -5.1535463310585852e-07
Rt11665 T1852 T3692 1281665.5036787395
Rt11666 T1853 T2008 368253.53991155978
Rt11667 T1853 T2009 14440107.455853164
Rt11668 T1853 T2406 3898057.0742039154
Rt11669 T1853 T2663 5129261.8740656525
Gcorr3913 T1853 T3099 T1853 T3099 -4.2236748146592764e-07
Rt11670 T1853 T3205 6791889.8627503794
Gcorr3914 T1853 T3428 T1853 T3428 -3.7307542514335607e-06
Rt11671 T1853 T3718 3818868.4287238624
Rt11672 T1853 T4073 227833.71236185264
Rt11673 T1854 T1870 4867369.2053160453
Rt11674 T1854 T1875 24496276.888603237
Rt11675 T1854 T2415 3223898.54119934
Rt11676 T1854 T2512 2404512.1651373943
Gcorr3915 T1854 T3141 T1854 T3141 -1.4592576299757081e-07
Rt11677 T1854 T3203 890146.63551272231
Rt11678 T1854 T3505 5355286.7512938734
Rt11679 T1854 T3521 3627282.8907696465
Gcorr3916 T1854 T3790 T1854 T3790 -7.1942917905797635e-07
Gcorr3917 T1855 T2315 T1855 T2315 -2.7779631073973435e-08
Rt11680 T1855 T2474 5775965.1446219515
Gcorr3918 T1855 T2475 T1855 T2475 -8.8599308507932535e-08
Rt11681 T1855 T2647 1907296.614261325
Gcorr3919 T1855 T2717 T1855 T2717 -5.7397436425962454e-08
Gcorr3920 T1855 T3263 T1855 T3263 -4.8074050882616184e-07
Rt11682 T1855 T3267 1090773.5980395249
Rt11683 T1855 T3681 2015460.8903398369
Rt11684 T1855 T4003 1304577.7322803072
Gcorr3921 T1856 T1887 T1856 T1887 -1.8532129174726921e-07
Rt11685 T1856 T2226 5527252.5546974121
Gcorr3922 T1856 T2273 T1856 T2273 -8.9203729194974099e-08
Rt11686 T1856 T2492 1650500.25574561
Rt11687 T1856 T2815 3966166.0475423816
Gcorr3923 T1856 T2837 T1856 T2837 -5.0808046153243688e-07
Rt11688 T1856 T3038 5343543.9286427395
Gcorr3924 T1856 T3514 T1856 T3514 -1.5789328153660269e-07
Rt11689 T1856 T3960 282023.00931969972
Rt11690 T1856 T4146 2498180.9413268385
Rt11691 T1857 T2035 3606858.8298819633
Rt11692 T1857 T2485 4017373.3603688008
Rt11693 T1857 T2518 3405048.2871050299
Rt11694 T1857 T2549 21814546.389133673
Gcorr3925 T1857 T3305 T1857 T3305 -7.0180722607090995e-08
Rt11695 T1857 T3307 1303835.0084473246
Gcorr3926 T1857 T3313 T1857 T3313 -1.1220131484122052e-07
Rt11696 T1857 T3322 2325946.4210867882
Rt11697 T1858 T2467 3421574.9596027383
Rt11698 T1858 T2468 46962262.611606784
Rt11699 T1858 T2516 3380496.8343988149
Rt11700 T1858 T2595 1670166.6341619021
Rt11701 T1858 T3154 4960211.9422998074
Gcorr3927 T1858 T3155 T1858 T3155 -1.5178866923667144e-07
Rt11702 T1858 T3233 588790.84237634088
Rt11703 T1858 T3438 5025937.6268220702
Gcorr3928 T1858 T4104 T1858 T4104 -3.8808242018106759e-07
Rt11704 T1859 T2445 2390249.235075498
Rt11705 T1859 T2473 1358997.554020168
Rt11706 T1859 T2910 453813.73823078669
Rt11707 T1859 T3424 1352281.5865649565
Gcorr3929 T1859 T3621 T1859 T3621 -7.8144049962864061e-08
Gcorr3930 T1859 T3855 T1859 T3855 -3.2512429911910762e-07
Rt11708 T1860 T1889 8376546.1620037341
Rt11709 T1860 T2169 4275970.385127224
Rt11710 T1860 T2335 4488673.8974027196
Rt11711 T1860 T2660 3060640.1480216463
Gcorr3931 T1860 T2746 T1860 T2746 -2.187807371516625e-07
Rt11712 T1860 T3491 8570478.7619352881
Rt11713 T1860 T3901 5187054.9479694637
Rt11714 T1860 T4127 2850836.2360852677
Rt11715 T1861 T1877 17526376.326511227
Rt11716 T1861 T1944 6461547.2604836421
Rt11717 T1861 T2536 2725200.386691629
Rt11718 T1861 T2708 2031724.8342896753
Rt11719 T1861 T3098 8180393.3111552643
Rt11720 T1861 T3522 5282760.3742493344
Rt11721 T1861 T3616 2093495.4959214819
Gcorr3932 T1861 T3928 T1861 T3928 -1.1158332549611691e-07
Rt11722 T1862 T2023 3627575.0982548837
Rt11723 T1862 T2300 22991650.104137339
Gcorr3933 T1862 T2428 T1862 T2428 -1.2378439743517469e-08
Rt11724 T1862 T2706 4724136.7185392212
Rt11725 T1862 T2713 2791355.2377002244
Gcorr3934 T1862 T3373 T1862 T3373 -4.4573494973243946e-07
Gcorr3935 T1862 T3374 T1862 T3374 -1.2100111487448002e-07
Rt11726 T1862 T3772 680077.19926972373
Rt11727 T1863 T2482 210324314.93209341
Rt11728 T1863 T2487 1949365.4577904295
Rt11729 T1863 T2527 2764782.6687993496
Rt11730 T1863 T2558 902936.62032961973
Gcorr3936 T1863 T3388 T1863 T3388 -7.0616806933525544e-07
Gcorr3937 T1863 T3390 T1863 T3390 -5.2449119279733778e-07
Rt11731 T1863 T3391 344386.72270021489
Gcorr3938 T1863 T3392 T1863 T3392 -1.1813154915709284e-07
Rt11732 T1863 T3394 2372990.8666272103
Gcorr3939 T1863 T3396 T1863 T3396 -5.1432301816712082e-07
Gcorr3940 T1863 T3967 T1863 T3967 -4.6013905133556898e-07
Rt11733 T1864 T2269 8220515.0053390292
Rt11734 T1864 T2297 3489999.9950332749
Rt11735 T1864 T2342 8752351.6198083423
Gcorr3941 T1864 T2899 T1864 T2899 -9.3372290973665144e-08
Rt11736 T1864 T2912 1720501.9569335354
Rt11737 T1864 T2913 2201337.0793512906
Rt11738 T1864 T3005 1195808.1626357422
Gcorr3942 T1864 T4096 T1864 T4096 -7.2755541052266386e-07
Rt11739 T1865 T2034 3711640.6170032937
Rt11740 T1865 T2373 2331513.5673608216
Rt11741 T1865 T2517 2946788.7827546359
Gcorr3943 T1865 T2738 T1865 T2738 -1.1020785320179721e-07
Rt11742 T1866 T1867 9257977.6778028719
Rt11743 T1866 T2048 15075210.479232723
Rt11744 T1866 T2241 10920020.732575841
Rt11745 T1866 T2724 2347026.1609897492
Rt11746 T1866 T3066 1896580.0395774238
Rt11747 T1866 T4161 6210948.9592174999
Rt11748 T1867 T2048 4959503.2353357486
Rt11749 T1867 T2399 4717085.7654235987
Rt11750 T1867 T2461 5174941.4960167771
Rt11751 T1867 T2547 8770112.3005825393
Rt11752 T1867 T3065 1278854.5337561276
Rt11753 T1867 T3066 7641920.2609660449
Rt11754 T1867 T3102 4549161.7548632454
Gcorr3944 T1867 T3962 T1867 T3962 -1.2384110135693844e-07
Rt11755 T1868 T2005 6065077.316650073
Rt11756 T1868 T2386 4076504.1586182257
Rt11757 T1868 T2535 3057247.2084375671
Rt11758 T1868 T2696 5456957.2500942387
Rt11759 T1869 T2630 1397775.594472945
Rt11760 T1869 T2648 1640265.7264340317
Rt11761 T1869 T2666 4034557.2753591742
Gcorr3945 T1869 T3047 T1869 T3047 -7.082248890409619e-07
Gcorr3946 T1869 T3049 T1869 T3049 -9.353485598602981e-08
Rt11762 T1869 T3086 588545.71853485785
Gcorr3947 T1869 T3087 T1869 T3087 -1.4446317734388113e-07
Gcorr3948 T1869 T4147 T1869 T4147 -1.5387250497081428e-07
Rt11763 T1870 T2416 3776416.7660447774
Rt11764 T1870 T2484 14681590.566869861
Rt11765 T1870 T2512 30285343.906946633
Rt11766 T1870 T2732 2844318.4438469103
Rt11767 T1870 T3051 2345138.7520479318
Rt11768 T1870 T3141 4353241.3419880429
Gcorr3949 T1870 T3203 T1870 T3203 -5.4496783776607348e-08
Rt11769 T1870 T4143 12579279.290474322
Rt11770 T1871 T1872 13958711.869570987
Rt11771 T1871 T1873 11057149.301165102
Rt11772 T1871 T1951 4868472.4832614046
Rt11773 T1871 T2545 2113664.4936223105
Gcorr3950 T1871 T3126 T1871 T3126 -1.3977048210635816e-07
Rt11774 T1871 T3341 2377253.5153094777
Gcorr3951 T1871 T3864 T1871 T3864 -2.0257928501862229e-07
Rt11775 T1871 T3917 1847853.6701455656
Rt11776 T1872 T1951 4398812.772080658
Rt11777 T1872 T2066 20769819.447793089
Rt11778 T1872 T2669 2495893.3795507648
Gcorr3952 T1872 T3109 T1872 T3109 -1.2644405253790611e-08
Rt11779 T1872 T3341 2961414.9644435248
Rt11780 T1872 T3452 2489391.2184112631
Gcorr3953 T1872 T3513 T1872 T3513 -1.0126255759204147e-07
Rt11781 T1873 T1874 4683430.1670850748
Rt11782 T1873 T2088 3242517.8999844543
Rt11783 T1873 T2545 8064082.1906268289
Rt11784 T1873 T2771 6955890.6001675064
Gcorr3954 T1873 T3335 T1873 T3335 -1.6504871022151134e-07
Rt11785 T1873 T3510 1884368.7558857601
Rt11786 T1873 T3562 9152165.3331200872
Rt11787 T1873 T3917 10613145.080741391
Rt11788 T1874 T2019 7745079.3687154138
Rt11789 T1874 T2088 17411398.201800548
Rt11790 T1874 T2688 2545022.8878345382
Rt11791 T1874 T2725 2464384.1082668588
Rt11792 T1874 T3335 2828524.8647734844
Rt11793 T1874 T3562 13607528.752233975
Rt11794 T1874 T3859 7537989.7220409876
Gcorr3955 T1874 T4086 T1874 T4086 -1.2226434662840996e-07
Rt11795 T1875 T1876 4029461.6492816075
Rt11796 T1875 T2356 3662837.936175914
Rt11797 T1875 T2415 4079825.001513279
Rt11798 T1875 T2430 3280975.8282021116
Gcorr3956 T1875 T3019 T1875 T3019 -1.0876958505998577e-07
Gcorr3957 T1875 T3161 T1875 T3161 -1.8892921325436149e-07
Rt11799 T1875 T3521 2326533.8407273199
Rt11800 T1875 T3836 18484483.957618918
Rt11801 T1875 T3887 2549041.0840509762
Rt11802 T1876 T2430 5912107.5503247166
Rt11803 T1876 T2504 3678611.0260192105
Rt11804 T1876 T2614 1917094.2704302405
Rt11805 T1876 T3161 1778614.3923201307
Gcorr3958 T1876 T3620 T1876 T3620 -8.4285075969559927e-08
Gcorr3959 T1876 T3887 T1876 T3887 -1.5570921812265686e-07
Rt11806 T1876 T4091 3866567.7489574351
Rt11807 T1877 T1944 1600230.7330666711
Rt11808 T1877 T2345 3741954.2658017934
Rt11809 T1877 T2672 4493689.639568232
Rt11810 T1877 T3023 8672877.2902246974
Rt11811 T1877 T3131 1120371.3665509289
Rt11812 T1877 T3616 2443249.8411092241
Gcorr3960 T1877 T3617 T1877 T3617 -5.3164213127298873e-07
Gcorr3961 T1877 T4082 T1877 T4082 -7.6842012491809416e-08
Rt11813 T1878 T2244 8848248.4501486439
Rt11814 T1878 T2501 6099775.204325811
Rt11815 T1878 T2643 2543525.994327717
Gcorr3962 T1878 T2886 T1878 T2886 -1.2236488605385079e-07
Gcorr3963 T1878 T3236 T1878 T3236 -1.5832503621841833e-07
Rt11816 T1878 T3642 3986145.8547653547
Rt11817 T1878 T3758 13195096.320563609
Rt11818 T1878 T3929 2177701.8536004969
Rt11819 T1879 T2423 2734964.3310177936
Rt11820 T1879 T2526 36414558.599300809
Rt11821 T1879 T2665 6028333.4891785691
Rt11822 T1879 T2925 1143543.8716653469
Rt11823 T1879 T2978 3843439.0076246671
Rt11824 T1879 T3512 1334296.1125298694
Rt11825 T1880 T1881 4738241.5416256879
Rt11826 T1880 T2022 6202852.8030420514
Rt11827 T1880 T2039 10056214.320046823
Rt11828 T1880 T2700 2730480.9755609552
Rt11829 T1880 T2743 13232028.878662033
Rt11830 T1880 T3643 5426126.3300787024
Rt11831 T1881 T2039 2498360.8109884569
Rt11832 T1881 T2041 4703719.3453167416
Rt11833 T1881 T2042 4058489.3751936392
Rt11834 T1881 T2110 29881814.385338496
Rt11835 T1881 T3643 3529261.3807278522
Rt11836 T1881 T3649 1810387.9815605001
Gcorr3964 T1881 T3980 T1881 T3980 -1.1746703648293201e-07
Rt11837 T1881 T4103 51882775.885943227
Gcorr3965 T1882 T2013 T1882 T2013 -3.1504912638506308e-08
Rt11838 T1882 T2073 2832747.5695061265
Gcorr3966 T1882 T2224 T1882 T2224 -1.1972561726743462e-07
Rt11839 T1882 T2625 2480461.8000572999
Rt11840 T1882 T2962 927870.46740002197
Rt11841 T1882 T3024 1614127.893575571
Rt11842 T1882 T3509 23695547.211690303
Rt11843 T1883 T2000 3633901.1102459473
Rt11844 T1883 T2541 7769077.0928446669
Gcorr3967 T1883 T2600 T1883 T2600 -7.1588901975525455e-08
Rt11845 T1883 T2657 1931717.9677571882
Rt11846 T1883 T2840 1503012.1071873591
Rt11847 T1883 T3690 3685441.2827974032
Gcorr3968 T1883 T3951 T1883 T3951 -5.4121500311725149e-07
Rt11848 T1883 T4106 502521.9148227229
Rt11849 T1884 T1885 5869685.7005932936
Rt11850 T1884 T2380 4257187.1160925142
Rt11851 T1884 T2460 7934494.3532447601
Rt11852 T1884 T2582 2701278.2231763806
Rt11853 T1885 T2235 9640647.3895170204
Rt11854 T1885 T2308 14860255.065693388
Rt11855 T1885 T2582 6841396.8168952586
Rt11856 T1885 T2689 1296115.7811341663
Rt11857 T1886 T2202 5396353.1940850485
Rt11858 T1886 T2401 11265746.215054749
Rt11859 T1886 T2712 2119672.0894207177
Rt11860 T1886 T3226 3420020.0766343623
Rt11861 T1886 T3609 11062837.803213131
Gcorr3969 T1886 T3626 T1886 T3626 -1.4102994498628929e-07
Rt11862 T1886 T4023 3905062.847929067
Rt11863 T1887 T2226 2091055.5804853598
Rt11864 T1887 T2492 6913277.3503418332
Rt11865 T1887 T2531 2156487.5259450143
Rt11866 T1887 T3022 9285618.6948362123
Rt11867 T1887 T3184 675141.04176559462
Gcorr3970 T1887 T3514 T1887 T3514 -2.7995505027394641e-07
Gcorr3971 T1887 T3829 T1887 T3829 -8.0656673859515497e-08
Rt11868 T1887 T4146 1108276.5783371904
Rt11869 T1888 T1945 2136163.456783501
Rt11870 T1888 T2419 4139540.2740655569
Rt11871 T1888 T2642 2568786.5318734674
Gcorr3972 T1888 T3002 T1888 T3002 -1.08409085510066e-08
Rt11872 T1888 T3403 2091122.0679503409
Rt11873 T1888 T3846 1980595.6368895452
Rt11874 T1888 T4126 15630041.048478451
Gcorr3973 T1888 T4136 T1888 T4136 -8.9394012398174734e-08
Rt11875 T1889 T2335 4697968.6717712712
Rt11876 T1889 T2502 2766915.8089266852
Rt11877 T1889 T2683 2344240.7669334109
Rt11878 T1889 T3125 9401640.8914192747
Gcorr3974 T1889 T3175 T1889 T3175 -9.4474997027277538e-08
Rt11879 T1889 T3491 1663922.4732682821
Rt11880 T1890 T1913 11491738.650331926
Rt11881 T1890 T2564 1667483.5759928899
Rt11882 T1890 T2629 1080085.8733202757
Gcorr3975 T1890 T3443 T1890 T3443 -1.4499575708335199e-07
Rt11883 T1890 T3605 3591292.6809373824
Rt11884 T1890 T3708 789510.41730700014
Gcorr3976 T1890 T3874 T1890 T3874 -2.1570586616777955e-08
Gcorr3977 T1890 T3875 T1890 T3875 -4.8345206608533506e-07
Gcorr3978 T1890 T4071 T1890 T4071 -4.0674425046354721e-07
Rt11885 T1891 T1923 4378925.2321794648
Rt11886 T1891 T2225 5157073.2001689812
Gcorr3979 T1891 T2522 T1891 T2522 -8.6241560532133511e-09
Rt11887 T1891 T2677 2600355.3576987963
Rt11888 T1891 T2853 6654485.3340957351
Rt11889 T1891 T3789 7803505.1011749497
Rt11890 T1892 T1972 13395400.703718195
Gcorr3980 T1892 T1997 T1892 T1997 -3.3716668991586799e-08
Rt11891 T1892 T2478 9744003.7195314933
Rt11892 T1892 T2615 2338081.2754935073
Rt11893 T1892 T2927 155233869.53493363
Rt11894 T1892 T2933 1408278.1952262274
Rt11895 T1892 T2985 918242.14712227613
Rt11896 T1892 T4184 14820245.665585645
Rt11897 T1893 T1894 7174226.7313938849
Rt11898 T1893 T1987 1928508.7818181268
Rt11899 T1893 T2016 75574733.048266858
Gcorr3981 T1893 T2590 T1893 T2590 -1.1404279885800054e-09
Rt11900 T1893 T3089 1314740.3564074512
Rt11901 T1893 T3091 1919223.3333172253
Gcorr3982 T1893 T3591 T1893 T3591 -5.8135410378434267e-07
Gcorr3983 T1893 T3822 T1893 T3822 -7.7747470453190472e-08
Rt11902 T1893 T4129 808896.31693187368
Rt11903 T1894 T1987 1947587.7855128727
Rt11904 T1894 T2514 1154833.8641674861
Gcorr3984 T1894 T2576 T1894 T2576 -8.3163883960996693e-09
Gcorr3985 T1894 T2693 T1894 T2693 -2.7725104635470281e-08
Rt11905 T1894 T2944 596328.11054287571
Gcorr3986 T1894 T3591 T1894 T3591 -3.783485777132033e-07
Gcorr3987 T1894 T3776 T1894 T3776 -5.5375956441978694e-07
Rt11906 T1894 T3822 1333242.0842601496
Rt11907 T1894 T4129 2646049.9395862063
Rt11908 T1895 T2433 3159860.8073620978
Rt11909 T1895 T2509 4181951.8636262813
Rt11910 T1895 T2710 2574151.8744333703
Gcorr3988 T1895 T3297 T1895 T3297 -9.0042664308909455e-09
Rt11911 T1895 T3353 11343735.348673131
Rt11912 T1895 T3852 2782381.2752715391
Gcorr3989 T1895 T4180 T1895 T4180 -3.1553173545532123e-08
Rt11913 T1896 T2247 2577949.2868338954
Rt11914 T1896 T2418 1060804.6336083161
Gcorr3990 T1896 T3418 T1896 T3418 -2.0612590087640425e-07
Gcorr3991 T1896 T3434 T1896 T3434 -4.5284552595244482e-07
Rt11915 T1896 T3463 2067980.6428456588
Rt11916 T1896 T3952 822838.93174544396
Rt11917 T1896 T4198 1057448.5865160567
Rt11918 T1897 T1992 5841340.7336773789
Rt11919 T1897 T2020 2888014.3625749797
Rt11920 T1897 T2397 4267238.287201969
Rt11921 T1897 T2530 3012123.3735329947
Gcorr3992 T1897 T3143 T1897 T3143 -2.3167822673571285e-07
Rt11922 T1897 T3232 1185432.8780820614
Gcorr3993 T1897 T3623 T1897 T3623 -2.2730076676027425e-07
Rt11923 T1897 T3667 34023141.45997566
Rt11924 T1897 T4069 6217511.9943730533
Rt11925 T1898 T2059 3425055.5219471087
Rt11926 T1898 T2406 2565372.3448132533
Rt11927 T1898 T2566 2071210.5208322287
Rt11928 T1898 T2663 24932996.291457236
Gcorr3994 T1898 T2926 T1898 T2926 -1.694234987099376e-07
Rt11929 T1898 T3442 1324225.8012419252
Rt11930 T1898 T3687 57636901.192532569
Rt11931 T1898 T3820 3230218.1931410278
Gcorr3995 T1898 T3890 T1898 T3890 -1.7935546201090395e-07
Gcorr3996 T1898 T3927 T1898 T3927 -1.0911912865842748e-07
Rt11932 T1899 T2326 49048676.971731685
Rt11933 T1899 T2392 1393801.0404279456
Rt11934 T1899 T2563 1318536.8144941891
Rt11935 T1899 T2679 12363881.825213954
Rt11936 T1899 T2943 2149292.7268017796
Rt11937 T1899 T3041 1375711.4852559746
Rt11938 T1899 T3083 644052.71427639865
Gcorr3997 T1899 T3384 T1899 T3384 -5.8150896206306347e-07
Gcorr3998 T1899 T3824 T1899 T3824 -5.1604331843671073e-07
Rt11939 T1900 T1972 4281873.2221546369
Rt11940 T1900 T2555 2002078.5979496783
Rt11941 T1900 T2615 3234577.7024596273
Gcorr3999 T1900 T2997 T1900 T2997 -6.4462230190826106e-08
Rt11942 T1900 T3052 8292520.6126988409
Gcorr4000 T1900 T3178 T1900 T3178 -1.5751478546330982e-07
Rt11943 T1900 T4179 12362071.428092236
Rt11944 T1900 T4183 1655594.9210217739
Rt11945 T1900 T4184 11582191.01127631
Rt11946 T1901 T1902 8163244.2849838864
Rt11947 T1901 T2074 20115967.206715453
Rt11948 T1901 T2257 21395740.371499602
Rt11949 T1901 T2489 1585095.1338259517
Rt11950 T1901 T2622 5013519.3117335495
Rt11951 T1901 T3031 3354049.7021794948
Rt11952 T1901 T3063 8369177.8966615666
Rt11953 T1901 T3064 909424.34761591617
Gcorr4001 T1901 T3168 T1901 T3168 -2.1678154746069983e-07
Gcorr4002 T1901 T4058 T1901 T4058 -2.6235022187161767e-08
Rt11954 T1902 T2257 7158937.3608353566
Rt11955 T1902 T2285 7514378.6269466719
Rt11956 T1902 T2641 5452124.0143468082
Rt11957 T1902 T2715 2368181.7022262355
Rt11958 T1902 T3064 13002325.711303636
Rt11959 T1902 T3457 1477190.8849647758
Gcorr4003 T1902 T3536 T1902 T3536 -7.6808938626370419e-08
Gcorr4004 T1902 T4058 T1902 T4058 -9.4584062563410723e-08
Rt11960 T1902 T4168 3894315.8828255059
Rt11961 T1903 T2357 1408889.1071993483
Rt11962 T1903 T2452 1153066.722942336
Rt11963 T1903 T2453 1574172.2607158627
Gcorr4005 T1903 T2804 T1903 T2804 -2.0453875309154963e-07
Gcorr4006 T1903 T2806 T1903 T2806 -2.6708423306329357e-07
Rt11964 T1903 T2835 480266.92970661324
Rt11965 T1903 T3737 9179283.4848022722
Gcorr4007 T1903 T3738 T1903 T3738 -2.3454869939221846e-07
Gcorr4008 T1903 T3931 T1903 T3931 -3.4660188768638437e-07
Gcorr4009 T1903 T3977 T1903 T3977 -3.5085712253938475e-07
Rt11966 T1904 T2334 560670.91673111147
Rt11967 T1904 T2619 1704792.0625080531
Rt11968 T1904 T2635 3565898.1687429454
Rt11969 T1904 T2932 223713.31365662243
Gcorr4010 T1904 T3455 T1904 T3455 -5.304372856576151e-08
Gcorr4011 T1904 T3946 T1904 T3946 -2.2741716166340466e-06
Rt11970 T1905 T2577 11916060.737315446
Rt11971 T1905 T2578 1951536.6606532079
Rt11972 T1905 T2624 7395236.4320850968
Rt11973 T1905 T2704 1822386.4547245987
Rt11974 T1905 T2991 9845159.8492207695
Rt11975 T1905 T3044 870532.57587664435
Gcorr4012 T1905 T4090 T1905 T4090 -2.0410484346201513e-07
Rt11976 T1906 T2402 6384747.572226977
Rt11977 T1906 T2525 864958.89672950364
Gcorr4013 T1906 T2537 T1906 T2537 -7.0124125818295293e-08
Rt11978 T1906 T2940 1740163.6733519593
Gcorr4014 T1906 T3302 T1906 T3302 -6.796445317770066e-07
Rt11979 T1906 T3862 450076.64528266928
Rt11980 T1906 T4186 1220448.515458992
Rt11981 T1907 T1971 2170664.3195043514
Rt11982 T1907 T2272 15262944.714750661
Rt11983 T1907 T2730 1434808.7744786881
Gcorr4015 T1907 T2888 T1907 T2888 -4.3791839413505505e-07
Gcorr4016 T1907 T3212 T1907 T3212 -3.612321217662551e-07
Rt11984 T1907 T3531 1813879.324020718
Rt11985 T1907 T3719 1893318.2349925085
Rt11986 T1907 T3834 1914499.5397651356
Gcorr4017 T1907 T3885 T1907 T3885 -2.9686742485840109e-07
Rt11987 T1908 T2358 20303778.415293787
Rt11988 T1908 T2381 2604294.1404198012
Rt11989 T1908 T2559 1323753.3077432693
Gcorr4018 T1908 T3266 T1908 T3266 -5.1212833605318556e-08
Rt11990 T1908 T3276 481970.56886747957
Gcorr4019 T1908 T3278 T1908 T3278 -5.1312998913233699e-07
Gcorr4020 T1908 T3784 T1908 T3784 -7.0410592715070412e-08
Rt11991 T1908 T4128 1586127.9530021716
Rt11992 T1909 T1999 6764677.3979142457
Rt11993 T1909 T2028 8763053.2986347806
Rt11994 T1909 T2606 13586821.056877142
Rt11995 T1909 T3479 4297582.5191386249
Rt11996 T1909 T3613 2210047.9386318349
Rt11997 T1909 T3807 635945.78267411713
Rt11998 T1909 T4053 86741729.657757983
Rt11999 T1910 T1911 3817550.0888436944
Rt12000 T1910 T1912 8459651.5093571413
Gcorr4021 T1910 T2751 T1910 T2751 -1.1659922837940606e-07
Gcorr4022 T1910 T2950 T1910 T2950 -1.237958471412895e-07
Rt12001 T1910 T3971 2829090.6772363596
Rt12002 T1911 T1912 6298599.4789285045
Rt12003 T1911 T2036 12099748.455359515
Rt12004 T1911 T2037 4605080.5169965448
Rt12005 T1911 T2579 2756508.1828515623
Rt12006 T1912 T2168 4602007.4902629983
Rt12007 T1912 T2260 791102.57287450368
Rt12008 T1912 T2579 4545196.4625843605
Rt12009 T1913 T2238 5088826.6889488799
Rt12010 T1913 T2337 5656148.847967335
Rt12011 T1913 T2564 2189811.7575551849
Rt12012 T1913 T2631 11310101.63225776
Gcorr4023 T1913 T2741 T1913 T2741 -1.1224784725439917e-07
Rt12013 T1913 T3874 1374460.800962192
Gcorr4024 T1913 T4071 T1913 T4071 -3.1121438413497043e-07
Gcorr4025 T1914 T1915 T1914 T1915 -4.4739672838411287e-08
Rt12014 T1914 T2030 2498958.1970590455
Rt12015 T1914 T2507 3563385.4381926148
Rt12016 T1914 T3401 14833184.859564973
Rt12017 T1914 T3866 662976.75016715599
Rt12018 T1914 T4033 584578.50040795433
Gcorr4026 T1915 T2353 T1915 T2353 -6.2359071105775412e-09
Rt12019 T1915 T2507 2595759.0697687124
Rt12020 T1915 T2532 3450882.1184762535
Rt12021 T1915 T2697 2381829.4243061049
Gcorr4027 T1915 T3348 T1915 T3348 -3.2764220176566392e-08
Rt12022 T1915 T3350 2765977.1033670437
Rt12023 T1915 T3866 8113319.9559318163
Rt12024 T1915 T4043 1438774.5861832828
Rt12025 T1916 T1917 3985988.4537209165
Rt12026 T1916 T1918 3636414.6814351222
Rt12027 T1916 T2321 3482536.5679833577
Rt12028 T1916 T2884 255826917.16883129
Rt12029 T1916 T3196 59283488.630983464
Rt12030 T1916 T3631 1959454.829800688
Gcorr4028 T1916 T3646 T1916 T3646 -1.3128688976532349e-07
Rt12031 T1916 T3838 7931710.308955715
Rt12032 T1917 T1918 10416452.121142853
Rt12033 T1917 T1957 17059639.093147535
Rt12034 T1917 T2722 1667861.5288710422
Gcorr4029 T1917 T3196 T1917 T3196 -1.0276759083627359e-08
Rt12035 T1917 T3342 26640155.6604366
Rt12036 T1917 T3646 2508720.7896903278
Rt12037 T1917 T4132 16609581.765600093
Rt12038 T1918 T1957 3684840.1254937798
Rt12039 T1918 T2321 4887544.6050812528
Rt12040 T1918 T2389 2822883.6460452005
Gcorr4030 T1918 T3631 T1918 T3631 -1.2223725437654559e-07
Rt12041 T1918 T3646 3512089.4267515293
Gcorr4031 T1919 T1920 T1919 T1920 -1.0101173794348859e-08
Rt12042 T1919 T1921 6278006.1165927174
Gcorr4032 T1919 T2524 T1919 T2524 -6.4983138061123252e-08
Rt12043 T1919 T2728 890898.69912527571
Rt12044 T1919 T2951 17454349.268946245
Rt12045 T1919 T3382 617888.67432721402
Gcorr4033 T1919 T3963 T1919 T3963 -4.3553028719467233e-07
Rt12046 T1919 T3984 767792.36276103673
Gcorr4034 T1919 T4093 T1919 T4093 -1.27974695453488e-07
Rt12047 T1920 T2388 4847941.0296252258
Gcorr4035 T1920 T2428 T1920 T2428 -6.8576990286868959e-08
Rt12048 T1920 T2523 2526090.6543793688
Rt12049 T1920 T2524 2726834.0570942881
Rt12050 T1920 T2728 1266053.060076396
Rt12051 T1920 T3375 1104495.0154138994
Gcorr4036 T1920 T3377 T1920 T3377 -1.9884851182542043e-07
Rt12052 T1920 T3378 1759389.5568602537
Gcorr4037 T1920 T3382 T1920 T3382 -3.2729778777202391e-08
Gcorr4038 T1920 T3963 T1920 T3963 -4.8370056208391804e-08
Rt12053 T1921 T1922 6641024.6056434419
Gcorr4039 T1921 T2239 T1921 T2239 -9.9204849463819984e-09
Rt12054 T1921 T2524 5788111.0118689127
Rt12055 T1921 T2608 2314090.2894412512
Rt12056 T1921 T3381 1884748.1716459079
Gcorr4040 T1921 T3382 T1921 T3382 -3.1181020747546737e-08
Rt12057 T1921 T3465 13215589.660153771
Rt12058 T1921 T4093 1168549.6903000113
Rt12059 T1922 T2220 7151381.6873637717
Rt12060 T1922 T2323 10472983.684026176
Rt12061 T1922 T2539 8791321.3282946087
Gcorr4041 T1922 T2608 T1922 T2608 -3.8502146485920451e-08
Rt12062 T1922 T2620 3107840.5147782359
Rt12063 T1922 T3198 6145221.6684442936
Rt12064 T1922 T3465 3411277.0014129616
Rt12065 T1922 T4045 3714833.3716184748
Rt12066 T1922 T4046 1050232.3350357539
Gcorr4042 T1922 T4093 T1922 T4093 -1.8807608678357368e-07
Rt12067 T1923 T2522 3832611.0058254469
Rt12068 T1923 T2574 8341299.5132490899
Rt12069 T1923 T2711 2047620.21595903
Rt12070 T1924 T2699 1429487.8754870524
Rt12071 T1924 T2731 1952954.2000150229
Rt12072 T1924 T3439 250310.78802327858
Gcorr4043 T1924 T3867 T1924 T3867 -5.4795092807521902e-07
Rt12073 T1924 T3912 1328322.5742873508
Gcorr4044 T1924 T3944 T1924 T3944 -5.3656677866360654e-07
Rt12074 T1925 T1926 2649030.630081879
Rt12075 T1925 T1927 4188723.2906830786
Rt12076 T1925 T1929 2361705.389390084
Rt12077 T1925 T2375 6244808.2661599172
Rt12078 T1925 T2731 2714733.6099453876
Gcorr4045 T1925 T2987 T1925 T2987 -5.2531497387093481e-07
Rt12079 T1925 T3156 446227.90150210063
Gcorr4046 T1925 T3158 T1925 T3158 -3.0897566301873308e-08
Rt12080 T1925 T3912 4279119.3347888635
Gcorr4047 T1925 T3915 T1925 T3915 -3.4492552730508658e-07
Rt12081 T1925 T4044 3980782.0338363335
Gcorr4048 T1926 T1927 T1926 T1927 -3.3483941282425833e-08
Rt12082 T1926 T1928 2355949.4440510925
Gcorr4049 T1926 T1936 T1926 T1936 -1.6906648388380044e-07
Rt12083 T1926 T2490 5115176.4393944805
Rt12084 T1926 T2987 964656.62931270862
Gcorr4050 T1926 T3156 T1926 T3156 -4.548456156742782e-07
Rt12085 T1926 T3158 829416.1193203649
Rt12086 T1926 T3397 1215469.8909850698
Rt12087 T1926 T3515 3862047.1359410435
Gcorr4051 T1926 T4049 T1926 T4049 -4.2875623197842223e-07
Rt12088 T1927 T1928 2765966.8891770286
Rt12089 T1927 T1929 8150497.8514808845
Gcorr4052 T1927 T1930 T1927 T1930 -7.6498655748092162e-08
Gcorr4053 T1927 T1934 T1927 T1934 -2.0957902021870189e-08
Rt12090 T1927 T2598 1904520.9802072861
Rt12091 T1927 T2897 2181260.0858963327
Rt12092 T1927 T2911 1525485.5493359393
Rt12093 T1927 T2987 964520.24317979475
Gcorr4054 T1927 T3156 T1927 T3156 -1.7467596821689349e-07
Gcorr4055 T1927 T4049 T1927 T4049 -3.5727317520028597e-07
Rt12094 T1928 T1930 2299096.1505222567
Rt12095 T1928 T1931 3730402.6642173533
Rt12096 T1928 T2253 832366.28889018099
Gcorr4056 T1928 T2490 T1928 T2490 -1.1768053595105741e-07
Gcorr4057 T1928 T2897 T1928 T2897 -4.9466839504550867e-07
Gcorr4058 T1928 T2987 T1928 T2987 -4.2413851092980599e-07
Gcorr4059 T1928 T2990 T1928 T2990 -5.8984174979976982e-08
Rt12097 T1928 T3397 1201753.5718515345
Rt12098 T1928 T3726 108985522.89033878
Rt12099 T1928 T4049 388816.56814748305
Gcorr4060 T1928 T4112 T1928 T4112 -6.991392545824857e-07
Rt12100 T1929 T1934 7272438.9004156152
Rt12101 T1929 T1964 4717389.6180219389
Rt12102 T1929 T1965 5005094.9060416119
Rt12103 T1929 T2375 3901180.398642872
Rt12104 T1929 T2911 5913551.9941997994
Rt12105 T1929 T3085 3312800.0871020635
Gcorr4061 T1929 T3156 T1929 T3156 -4.1926242665420904e-07
Rt12106 T1929 T3703 9525109.6192683112
Rt12107 T1929 T3915 902115.73476946983
Gcorr4062 T1929 T4013 T1929 T4013 -1.2931204697047947e-07
Rt12108 T1930 T1931 6904739.2492784662
Rt12109 T1930 T1932 72716707.615706295
Rt12110 T1930 T2231 9198820.0546737518
Rt12111 T1930 T2360 20708003.883215703
Rt12112 T1930 T2598 2327964.2294308213
Rt12113 T1930 T2880 2649253.0619289004
Rt12114 T1930 T2897 2100972.5336685372
Rt12115 T1930 T2990 1718740.9050039924
Rt12116 T1930 T4042 4518767.3712930605
Gcorr4063 T1930 T4049 T1930 T4049 -4.5209433859968004e-07
Rt12117 T1931 T1932 5307330.1434010137
Rt12118 T1931 T1937 4105521.0515520405
Gcorr4064 T1931 T2253 T1931 T2253 -2.1124616032809311e-08
Rt12119 T1931 T2661 553519.80117381935
Rt12120 T1931 T2990 2280107.6471473337
Gcorr4065 T1931 T3140 T1931 T3140 -1.7518396349837581e-06
Rt12121 T1931 T3725 412613.78428637778
Rt12122 T1931 T3726 2261155.4330612943
Gcorr4066 T1931 T4042 T1931 T4042 -1.7791701424006673e-07
Rt12123 T1932 T1937 6609229.653132651
Rt12124 T1932 T2215 5048151.727138198
Rt12125 T1932 T2223 12061429.576949961
Rt12126 T1932 T2231 5247945.4277083864
Rt12127 T1932 T2914 1616167.0973125489
Gcorr4067 T1932 T3010 T1932 T3010 -6.236193151670205e-08
Rt12128 T1932 T3725 3789813.3052074299
Rt12129 T1932 T4042 2588979.1571374885
Rt12130 T1933 T2286 3771834.2131719245
Rt12131 T1933 T2375 14191025.40005176
Rt12132 T1933 T2528 3636859.801451358
Rt12133 T1933 T2699 2830688.3968032175
Rt12134 T1933 T2731 5742806.4188046455
Rt12135 T1933 T3020 3391005.9318361948
Rt12136 T1933 T3027 2729998.9489764213
Rt12137 T1933 T3169 14519800.994694991
Rt12138 T1933 T4004 1555141.1592475132
Rt12139 T1934 T1964 4772321.8686370188
Rt12140 T1934 T2360 12737934.880593792
Rt12141 T1934 T2441 1791147.4839454954
Rt12142 T1934 T2598 2728979.4531655516
Rt12143 T1934 T2881 1949693.9311935839
Rt12144 T1934 T2911 10207513.849629734
Rt12145 T1934 T3085 3176941.8758301199
Gcorr4068 T1934 T3803 T1934 T3803 -7.6980745429774202e-08
Gcorr4069 T1934 T3935 T1934 T3935 -1.1641554782504364e-07
Rt12146 T1935 T1937 10250005.531617936
Gcorr4070 T1935 T2253 T1935 T2253 -9.7449151454806115e-08
Rt12147 T1935 T2661 1823178.1371502166
Gcorr4071 T1935 T3140 T1935 T3140 -2.4313420236377738e-08
Rt12148 T1935 T3727 270957.88604410068
Rt12149 T1935 T3728 878193.08817124867
Rt12150 T1936 T2490 2436841.4751941022
Gcorr4072 T1936 T2533 T1936 T2533 -4.1818722383925349e-08
Rt12151 T1936 T3515 328388.1646904712
Gcorr4073 T1936 T3867 T1936 T3867 -8.0760763029012472e-07
Rt12152 T1936 T3897 595613.89318262925
Rt12153 T1937 T2215 4063936.2062291279
Gcorr4074 T1937 T2398 T1937 T2398 -8.3949774315308155e-08
Rt12154 T1937 T2661 6628577.3005211446
Rt12155 T1937 T3010 2929334.427962285
Rt12156 T1937 T3139 3798501.1896754955
Rt12157 T1937 T3140 425909.53568346368
Rt12158 T1937 T3725 7113723.4757734807
Gcorr4075 T1937 T3728 T1937 T3728 -8.5719627072059893e-07
Rt12159 T1938 T2025 3876570.8835324533
Rt12160 T1938 T2381 18040002.562425639
Rt12161 T1938 T2587 2343828.9874230539
Rt12162 T1938 T3275 2514490.260102246
Gcorr4076 T1938 T3354 T1938 T3354 -9.6439213379262972e-09
Rt12163 T1938 T3871 2546839.8508460154
Rt12164 T1938 T3966 4661913.3734352188
Rt12165 T1939 T2340 4139287.1859476008
Rt12166 T1939 T2519 2341334.8414379111
Rt12167 T1939 T2662 1955531.0820156555
Rt12168 T1939 T2938 15620160.588650858
Rt12169 T1939 T2939 880482.37190850941
Rt12170 T1939 T2995 1062827.4651334593
Gcorr4077 T1939 T3007 T1939 T3007 -1.7288240862579667e-07
Rt12171 T1940 T1988 12398031.818416581
Rt12172 T1940 T2289 1133945.1284448521
Rt12173 T1940 T2494 23841612.619203143
Rt12174 T1940 T3171 1094708.05738705
Gcorr4078 T1940 T3172 T1940 T3172 -8.6811822320541129e-08
Gcorr4079 T1940 T3371 T1940 T3371 -7.8899635781178473e-07
Rt12175 T1940 T3920 605027.15236338589
Rt12176 T1940 T4011 521680.63609301212
Rt12177 T1941 T2069 5300703.3107532933
Rt12178 T1941 T2413 5472860.4148064703
Rt12179 T1941 T2517 3367735.3512508129
Rt12180 T1941 T2983 3701951.4547096682
Rt12181 T1941 T3878 2982281.7654296583
Rt12182 T1941 T3879 4361117.495135406
Gcorr4080 T1941 T4111 T1941 T4111 -1.2522153299896864e-07
Gcorr4081 T1941 T4157 T1941 T4157 -7.7259780452345837e-08
Rt12183 T1942 T2440 3027354.9418918211
Rt12184 T1942 T2539 946400.48619453702
Rt12185 T1942 T2620 6721334.8467448158
Gcorr4082 T1942 T3146 T1942 T3146 -5.1067683040992318e-08
Rt12186 T1942 T3147 2255719.3598147398
Rt12187 T1942 T3148 741671.46973787295
Gcorr4083 T1942 T3198 T1942 T3198 -8.7777136995175417e-07
Rt12188 T1943 T2106 4382728.5841257451
Rt12189 T1943 T2567 3025881.6570262415
Rt12190 T1943 T2597 2615624.2457413762
Rt12191 T1944 T2425 2597176.4259404652
Rt12192 T1944 T2536 593664.69988296099
Rt12193 T1944 T2627 1929559.6258396674
Rt12194 T1944 T2672 2566370.1221689405
Gcorr4084 T1944 T3131 T1944 T3131 -6.3067560051840063e-07
Gcorr4085 T1944 T3616 T1944 T3616 -1.6749968046737175e-07
Rt12195 T1944 T3617 328125.94646469346
Gcorr4086 T1944 T3650 T1944 T3650 -2.7699692464180196e-07
Gcorr4087 T1944 T3928 T1944 T3928 -1.4934238916918494e-06
Rt12196 T1945 T2408 11588911.036998481
Rt12197 T1945 T3002 3243151.2006436698
Rt12198 T1945 T3402 1875093.3970302299
Gcorr4088 T1945 T3403 T1945 T3403 -5.0181365969742036e-07
Rt12199 T1945 T4136 619368.51837101893
Rt12200 T1946 T2036 6968313.3714238787
Rt12201 T1946 T2085 10217611.467098983
Rt12202 T1946 T2723 982099.61196118209
Rt12203 T1946 T2759 13329153.222945398
Rt12204 T1946 T3835 17087096.276271671
Rt12205 T1947 T1960 4844354.5348747512
Rt12206 T1947 T2004 5782109.2022936707
Rt12207 T1947 T2211 3493185.2490038988
Rt12208 T1947 T2655 8498068.9754057638
Rt12209 T1947 T3199 2303399.2652112152
Rt12210 T1947 T3431 3089524.4439743967
Gcorr4089 T1947 T3982 T1947 T3982 -4.1802835182733922e-08
Gcorr4090 T1947 T4064 T1947 T4064 -9.2064341997050148e-08
Rt12211 T1947 T4088 8842834.0404453706
Rt12212 T1948 T1949 3858022.8481141631
Rt12213 T1948 T2065 10075578.60132923
Rt12214 T1948 T2222 3754944.3480328987
Rt12215 T1948 T3228 3396765.596386224
Gcorr4091 T1948 T3447 T1948 T3447 -9.6327131524683321e-08
Rt12216 T1948 T3472 1996643.7867640408
Rt12217 T1948 T3841 5852940.5921952855
Rt12218 T1949 T1966 43349599.929686069
Rt12219 T1949 T2065 5468832.9572845409
Gcorr4092 T1949 T2132 T1949 T2132 -8.7101709721857573e-09
Rt12220 T1949 T2692 1958792.6552518758
Rt12221 T1949 T2695 3061138.581420959
Rt12222 T1949 T3447 1642873.9041868299
Gcorr4093 T1949 T3472 T1949 T3472 -1.5389885182472304e-07
Rt12223 T1949 T3606 5742829.8691859553
Gcorr4094 T1949 T3892 T1949 T3892 -3.0547015428182279e-08
Rt12224 T1950 T2374 4717761.2508551041
Rt12225 T1950 T2393 10168115.164467016
Rt12226 T1950 T2633 4362711.282445957
Rt12227 T1950 T3008 6836358.5542879878
Rt12228 T1950 T3072 2111170.913211138
Rt12229 T1950 T3073 935459.01632909325
Gcorr4095 T1950 T3843 T1950 T3843 -2.0027783837096042e-07
Gcorr4096 T1950 T4047 T1950 T4047 -2.0115902675674296e-07
Rt12230 T1951 T2544 2770104.2411626903
Rt12231 T1951 T2545 7500510.309891873
Rt12232 T1951 T2610 2538559.7703941963
Rt12233 T1951 T2669 21532992.516349256
Gcorr4097 T1951 T3341 T1951 T3341 -9.5873618069737168e-08
Rt12234 T1951 T3513 2978411.1006656392
Rt12235 T1951 T3864 3907759.0672835107
Rt12236 T1952 T1953 3702146.6903420165
Rt12237 T1952 T1977 5027148.2543750992
Rt12238 T1952 T2405 7516359.9630002957
Rt12239 T1952 T2749 15568011.497063387
Rt12240 T1952 T3644 2664301.5167741603
Gcorr4098 T1952 T4070 T1952 T4070 -1.2374437440341533e-07
Rt12241 T1953 T2321 1593236.3400296716
Rt12242 T1953 T2366 2874136.1968206302
Rt12243 T1953 T2405 4134817.0865835492
Rt12244 T1954 T2396 826533.42541327293
Rt12245 T1954 T2540 4253905.6656240029
Gcorr4099 T1954 T2624 T1954 T2624 -7.6860036395401676e-08
Rt12246 T1954 T2704 6304593.0758565301
Gcorr4100 T1954 T2937 T1954 T2937 -1.1126153139356422e-06
Rt12247 T1954 T2992 577469.53822679573
Rt12248 T1954 T3046 2035202.5391047599
Rt12249 T1954 T3958 1668035.8807983096
Rt12250 T1955 T1956 85663698.99596405
Rt12251 T1955 T2057 17694712.131600309
Rt12252 T1955 T2361 2744931.224249437
Gcorr4101 T1955 T3249 T1955 T3249 -1.936935530805873e-07
Rt12253 T1955 T3254 647202.63465679402
Rt12254 T1955 T3973 2010439.6144910555
Rt12255 T1955 T3986 1195394.3026940967
Rt12256 T1956 T2361 7930698.3332604747
Rt12257 T1956 T2403 4968276.3815053301
Gcorr4102 T1956 T2556 T1956 T2556 -3.4188986973008192e-08
Rt12258 T1956 T2599 2869809.8559334772
Rt12259 T1956 T3252 2923600.8066114173
Rt12260 T1956 T3254 3159028.5954495142
Gcorr4103 T1956 T3436 T1956 T3436 -3.7191177178624153e-08
Rt12261 T1956 T3987 735108.21471900237
Gcorr4104 T1957 T2389 T1957 T2389 -3.7936515112745603e-08
Rt12262 T1957 T2436 2915277.4177443474
Rt12263 T1957 T2650 2897004.1277660206
Rt12264 T1957 T2722 4157160.8012794438
Rt12265 T1957 T2744 7356582.0188481677
Rt12266 T1957 T3646 31983011.148014277
Rt12267 T1958 T2139 3973254.9467828693
Rt12268 T1958 T2582 2416417.3732116865
Rt12269 T1958 T2689 1650261.4582429631
Rt12270 T1958 T2785 4385818.904904021
Rt12271 T1958 T3543 1583434.103317512
Gcorr4105 T1958 T3936 T1958 T3936 -1.1501321969385167e-07
Rt12272 T1959 T2260 3346328.962152265
Rt12273 T1959 T2267 3483121.5351095842
Rt12274 T1959 T2459 3912653.9618681381
Rt12275 T1960 T2072 5445262.6539593255
Rt12276 T1960 T2240 3638182.3580370136
Rt12277 T1960 T2613 7832092.9511460615
Gcorr4106 T1960 T2866 T1960 T2866 -1.4888760763983377e-07
Rt12278 T1960 T2873 2330308.9862391171
Rt12279 T1960 T3199 7398269.7776635131
Rt12280 T1960 T4064 4259060.6139788879
Rt12281 T1961 T2498 4486281.4137946889
Rt12282 T1961 T2506 720868.7368488491
Gcorr4107 T1961 T3138 T1961 T3138 -3.6965113963210689e-08
Rt12283 T1961 T3551 2557323.0471342355
Rt12284 T1961 T3881 261962.29113989207
Gcorr4108 T1961 T3968 T1961 T3968 -1.0122041344370235e-07
Gcorr4109 T1961 T4087 T1961 T4087 -1.209149806197955e-07
Gcorr4110 T1962 T2421 T1962 T2421 -6.8939750940788583e-09
Rt12285 T1962 T2422 6093075.0740511464
Rt12286 T1962 T2423 3749019.8643815992
Gcorr4111 T1962 T2497 T1962 T2497 -1.4819655946840403e-07
Rt12287 T1962 T2977 976986.47577906388
Rt12288 T1962 T3030 1729859.694769545
Rt12289 T1962 T3032 1489875.7728597182
Gcorr4112 T1962 T3833 T1962 T3833 -4.3258378550878669e-07
Rt12290 T1963 T2432 11367025.55129049
Rt12291 T1963 T2444 995008.81057353551
Gcorr4113 T1963 T2474 T1963 T2474 -1.4200558288916957e-08
Gcorr4114 T1963 T3282 T1963 T3282 -5.6369126813820402e-08
Rt12292 T1963 T3325 584877.33799094136
Gcorr4115 T1963 T3798 T1963 T3798 -5.2546880110493711e-07
Rt12293 T1963 T4037 561074.57412148919
Rt12294 T1964 T1965 12655829.041069098
Rt12295 T1964 T2310 85115321.01728861
Rt12296 T1964 T2365 3094749.416797806
Gcorr4116 T1964 T2441 T1964 T2441 -2.7060502612997625e-08
Rt12297 T1964 T3085 18042394.234664325
Rt12298 T1964 T3935 2636318.6209391351
Gcorr4117 T1964 T3956 T1964 T3956 -1.8250426915020944e-07
Rt12299 T1964 T4013 1768153.9890626252
Rt12300 T1965 T2310 4762953.6257615853
Rt12301 T1965 T2375 3081117.2005944503
Rt12302 T1965 T2528 1595266.005370623
Rt12303 T1965 T2667 4228657.5645800214
Gcorr4118 T1965 T2984 T1965 T2984 -1.5114224545570823e-07
Gcorr4119 T1965 T3027 T1965 T3027 -4.0506825003569568e-07
Rt12304 T1965 T3219 38835290.568719305
Rt12305 T1965 T3703 925315.34373308509
Rt12306 T1965 T4013 4768667.3373267129
Rt12307 T1966 T2401 2611976.877063801
Rt12308 T1966 T2692 1136887.9532220706
Rt12309 T1966 T2712 29158233.896190755
Rt12310 T1966 T2734 2579809.8090587473
Gcorr4120 T1966 T2777 T1966 T2777 -2.6481447605490069e-07
Gcorr4121 T1966 T3447 T1966 T3447 -1.6093813769432765e-07
Rt12311 T1966 T3566 1026265.3928199329
Gcorr4122 T1966 T3698 T1966 T3698 -1.9389724730361735e-07
Rt12312 T1966 T3964 7765411.4505894994
Rt12313 T1967 T1976 9241953.3817228414
Rt12314 T1967 T2402 673722.94573725841
Gcorr4123 T1967 T2940 T1967 T2940 -5.0720044929632561e-07
Rt12315 T1967 T3295 18788583.780383807
Rt12316 T1967 T3444 254053.74728926097
Rt12317 T1967 T3601 34974612.106319986
Rt12318 T1967 T3926 14397011.879565377
Gcorr4124 T1968 T2075 T1968 T2075 -1.0790841787248403e-07
Rt12319 T1968 T2552 4483465.5875748973
Rt12320 T1968 T2623 4143118.2627705401
Rt12321 T1968 T2811 406690.37336272036
Rt12322 T1968 T2812 3188426.6574330134
Gcorr4125 T1968 T2813 T1968 T2813 -6.2357061378376834e-08
Rt12323 T1968 T2814 2614176.9971254962
Rt12324 T1968 T3969 1420993.8235128247
Rt12325 T1969 T1970 3192533.9834684012
Rt12326 T1969 T2222 19904466.734264843
Rt12327 T1969 T2694 2271154.9353603586
Rt12328 T1969 T3050 7076043.8393068146
Rt12329 T1969 T3230 2001819.3955779499
Rt12330 T1969 T3324 2543554.6045079837
Gcorr4126 T1969 T3503 T1969 T3503 -3.3963997284948182e-07
Rt12331 T1970 T2268 4549818.3249299116
Rt12332 T1970 T2578 3335540.8562505585
Rt12333 T1970 T2671 3356490.1598215201
Rt12334 T1970 T3050 2407574.9176680571
Rt12335 T1970 T3324 8190228.1543309959
Rt12336 T1970 T3736 3815918.4188404973
Gcorr4127 T1970 T4090 T1970 T4090 -1.3101751902767163e-07
Rt12337 T1971 T2249 1623776.6117858924
Rt12338 T1971 T2272 1556237.0720865715
Rt12339 T1971 T2888 573759.56095233047
Gcorr4128 T1971 T3531 T1971 T3531 -4.8702305060537183e-07
Rt12340 T1971 T3686 23099365.442712568
Gcorr4129 T1971 T3719 T1971 T3719 -1.5230245443179621e-07
Rt12341 T1971 T3733 28452611.630318541
Rt12342 T1972 T2390 3714470.4698533081
Rt12343 T1972 T2478 5313300.1897873525
Gcorr4130 T1972 T2615 T1972 T2615 -5.6911663518196522e-08
Rt12344 T1972 T2681 4308386.1739303349
Rt12345 T1972 T2985 5105460.5127967745
Rt12346 T1972 T3052 1811167.9728954376
Rt12347 T1972 T3053 10910253.385006633
Rt12348 T1972 T4184 3542039.1884014294
Rt12349 T1973 T2031 2887169.9396325978
Rt12350 T1973 T2032 2040246.2063917068
Rt12351 T1973 T2188 4370214.8608633466
Rt12352 T1973 T2753 31096122.940566923
Rt12353 T1973 T3516 13764658.302571734
Rt12354 T1973 T3870 1023708.5157006033
Rt12355 T1974 T1998 1307608.6233820182
Rt12356 T1974 T2083 4211613.2938373536
Rt12357 T1974 T2205 1592482.7450447385
Rt12358 T1975 T1976 1216425.8090475993
Rt12359 T1975 T2404 22133436.82284876
Rt12360 T1975 T2585 1416868.5055496059
Rt12361 T1975 T3290 3378292.8461794318
Rt12362 T1975 T3292 29007731.057406161
Rt12363 T1975 T3518 471266.81102304219
Gcorr4131 T1975 T3926 T1975 T3926 -4.7973458359891288e-07
Gcorr4132 T1975 T4006 T1975 T4006 -4.3870016534430195e-07
Rt12364 T1976 T2243 3547290.3684119852
Rt12365 T1976 T3292 1480330.6327111125
Rt12366 T1976 T3295 1079404.1303126786
Gcorr4133 T1976 T3518 T1976 T3518 -5.4136021425093595e-07
Rt12367 T1976 T3926 824008.68679020507
Rt12368 T1977 T1978 8817990.3027991652
Rt12369 T1977 T2405 2676787.283607848
Rt12370 T1977 T2749 7755327.3237991994
Rt12371 T1977 T3630 36356891.719415113
Rt12372 T1978 T2090 9513627.4356343541
Rt12373 T1978 T2394 2931195.6898656231
Rt12374 T1978 T2405 6014407.0447797161
Rt12375 T1978 T2407 5592621.5680751065
Rt12376 T1979 T1980 4716511.274425447
Rt12377 T1979 T2040 4398172.9618557775
Rt12378 T1979 T2203 4708013.6048487443
Gcorr4134 T1979 T2786 T1979 T2786 -1.3924969067878713e-07
Gcorr4135 T1979 T2818 T1979 T2818 -1.5609518626084804e-07
Rt12379 T1979 T3544 914342.3764946186
Gcorr4136 T1979 T3665 T1979 T3665 -4.2793141889270994e-07
Rt12380 T1980 T1981 5114285.9402552713
Rt12381 T1980 T2203 10061804.915457336
Rt12382 T1980 T2275 3739480.0403043269
Rt12383 T1980 T2333 4530931.1523242099
Rt12384 T1980 T2818 8057619.9996094704
Rt12385 T1981 T1982 4551343.9015885098
Rt12386 T1981 T2333 4165242.7001984054
Gcorr4137 T1981 T2818 T1981 T2818 -1.4674938559160882e-07
Gcorr4138 T1981 T3399 T1981 T3399 -3.9818652946567852e-09
Rt12387 T1981 T3759 1278008.469319579
Gcorr4139 T1981 T4085 T1981 T4085 -3.1569539904408091e-07
Rt12388 T1982 T2021 10317191.888327107
Rt12389 T1982 T2313 3218280.7368591363
Rt12390 T1982 T2333 27973245.971542273
Rt12391 T1982 T2371 2017521.4344385087
Gcorr4140 T1982 T3399 T1982 T3399 -1.7407654053422834e-07
Rt12392 T1983 T2546 5217964.2853933712
Rt12393 T1983 T2656 2596862.3515125648
Rt12394 T1983 T2658 5196473.9100194788
Rt12395 T1983 T3323 1351276.7004692082
Rt12396 T1983 T3712 2598302.3611488873
Rt12397 T1983 T3856 1984857.1085904948
Rt12398 T1983 T4108 4799463.4571145587
Rt12399 T1984 T1985 40004819.140511967
Rt12400 T1984 T2409 83351813.838198021
Rt12401 T1984 T2410 1134918.6476532223
Gcorr4141 T1984 T2591 T1984 T2591 -2.2551725064225993e-08
Rt12402 T1984 T2921 1258998.0519575202
Gcorr4142 T1984 T3183 T1984 T3183 -4.4465732844908602e-07
Rt12403 T1984 T3830 457719.47982861003
Rt12404 T1984 T4028 1113170.5899879544
Gcorr4143 T1985 T1986 T1985 T1986 -5.8512599435425972e-08
Rt12405 T1985 T2409 4524786.0277453307
Rt12406 T1985 T2477 3936529.4351691194
Gcorr4144 T1985 T2917 T1985 T2917 -4.4004122860438138e-07
Rt12407 T1985 T2921 9692647.3798654135
Rt12408 T1985 T3508 1123282.9697559667
Rt12409 T1985 T3828 2547978.852038295
Rt12410 T1985 T4028 4172345.3987245336
Rt12411 T1985 T4125 433565.62747945357
Gcorr4145 T1986 T2318 T1986 T2318 -1.3824513768057107e-07
Rt12412 T1986 T2435 5464640.422953628
Rt12413 T1986 T2477 57412339.54373458
Rt12414 T1986 T2520 1101563.2083449387
Gcorr4146 T1986 T2917 T1986 T2917 -1.0911477652805323e-07
Gcorr4147 T1986 T3193 T1986 T3193 -4.272622686874279e-07
Rt12415 T1986 T3206 1284234.4746524065
Rt12416 T1986 T3828 696686.80900741892
Rt12417 T1986 T4122 1199118.5870657617
Rt12418 T1987 T2016 1614153.7669982233
Rt12419 T1987 T2017 6442408.3888300648
Rt12420 T1987 T2572 7409219.8795942133
Rt12421 T1987 T2576 241212.61650633608
Gcorr4148 T1987 T2944 T1987 T2944 -5.2668500914492428e-07
Gcorr4149 T1987 T3091 T1987 T3091 -5.5875044273143821e-07
Gcorr4150 T1987 T3093 T1987 T3093 -1.5989162216283101e-07
Gcorr4151 T1987 T3495 T1987 T3495 -2.4074231709000657e-06
Rt12422 T1987 T3591 318637.57485386857
Rt12423 T1987 T3950 310145.60437826504
Gcorr4152 T1987 T4129 T1987 T4129 -5.6367098438017823e-07
Rt12424 T1988 T2494 3792788.000742536
Gcorr4153 T1988 T2498 T1988 T2498 -6.7031612956255672e-08
Rt12425 T1988 T2702 10618527.765961843
Rt12426 T1988 T3081 2774218.9387056245
Gcorr4154 T1988 T3171 T1988 T3171 -5.5818113078399322e-08
Rt12427 T1988 T3172 504088.25035934104
Gcorr4155 T1988 T3550 T1988 T3550 -6.8014320933671603e-07
Rt12428 T1988 T4120 3593668.4011353408
Rt12429 T1989 T2399 2549434.1822451227
Rt12430 T1989 T2463 8036752.1330286004
Rt12431 T1989 T2707 163830176.0536986
Rt12432 T1989 T2942 786914.68676090997
Rt12433 T1989 T3844 1434618.2103593862
Rt12434 T1989 T3942 3282029.9576774403
Gcorr4156 T1989 T3962 T1989 T3962 -1.2165035227158985e-07
Gcorr4157 T1989 T4150 T1989 T4150 -7.5235832510187742e-08
Rt12435 T1990 T2148 4929456.6838343916
Rt12436 T1990 T2338 4509471.846214083
Rt12437 T1990 T2542 2291651.8651713245
Rt12438 T1990 T3308 3864284.2089454765
Rt12439 T1990 T3309 3886298.1799799772
Rt12440 T1990 T3757 20402388.046747811
Rt12441 T1990 T4165 4534016.4273110097
Gcorr4158 T1991 T2261 T1991 T2261 -3.0769957036862451e-07
Rt12442 T1991 T2563 786445.17364997615
Gcorr4159 T1991 T2679 T1991 T2679 -1.575743891987335e-07
Gcorr4160 T1991 T3384 T1991 T3384 -5.6520419295200867e-07
Rt12443 T1991 T3610 473817.49343069043
Rt12444 T1991 T4066 297406.41694853723
Gcorr4161 T1992 T2003 T1992 T2003 -1.347487391741164e-08
Rt12445 T1992 T2135 7205492.3627823014
Rt12446 T1992 T2530 3707235.9480670798
Rt12447 T1992 T2718 1317511.4119996198
Rt12448 T1992 T3143 3606795.4829263114
Rt12449 T1992 T3145 30722905.175123405
Rt12450 T1992 T3700 1043241.00681016
Gcorr4162 T1992 T4051 T1992 T4051 -3.5429520015581075e-07
Gcorr4163 T1992 T4069 T1992 T4069 -1.8852917022631893e-07
Rt12451 T1993 T1994 14021896.723765159
Rt12452 T1993 T2351 6311848.7350227935
Rt12453 T1993 T2372 4408212.8165141018
Rt12454 T1993 T2720 5397964.3898020051
Rt12455 T1993 T2798 1371565.1836432302
Rt12456 T1993 T3664 4296886.5014437204
Gcorr4164 T1993 T3666 T1993 T3666 -1.7134581422451981e-09
Gcorr4165 T1993 T4030 T1993 T4030 -4.2830712282213573e-07
Rt12457 T1994 T2372 3944322.2557839253
Rt12458 T1994 T2551 12281084.48498204
Rt12459 T1994 T2637 2776081.4980416577
Rt12460 T1994 T2797 11387619.765673418
Rt12461 T1994 T3664 5069214.1176711535
Rt12462 T1994 T3918 4972224.5194158154
Rt12463 T1995 T2094 9616674.4753073845
Rt12464 T1995 T2273 2799955.4792210083
Rt12465 T1995 T2552 2032967.1159590858
Rt12466 T1995 T2813 27847727.118076235
Gcorr4166 T1995 T2875 T1995 T2875 -8.2206067365214432e-07
Rt12467 T1995 T3731 461570.25397651241
Rt12468 T1996 T2292 13713566.171152376
Rt12469 T1996 T2322 2120525.6685910844
Rt12470 T1996 T2408 1316879.0914692064
Rt12471 T1996 T2964 378390.11175198323
Rt12472 T1996 T3427 9459435.5411184262
Gcorr4167 T1996 T3825 T1996 T3825 -1.6953708338937284e-07
Rt12473 T1996 T4190 11592313.056415642
Rt12474 T1997 T2280 3320230.2291546413
Gcorr4168 T1997 T2417 T1997 T2417 -4.8339872310523265e-08
Gcorr4169 T1997 T2615 T1997 T2615 -1.1027183788362478e-07
Rt12475 T1997 T2680 1791770.0819471308
Rt12476 T1997 T2898 2716897.432249242
Rt12477 T1997 T2933 536308.34727904387
Rt12478 T1997 T3748 10540314.311556783
Rt12479 T1998 T2205 9796426.0988854934
Rt12480 T1998 T2312 3752776.8422466042
Rt12481 T1998 T2380 4993337.2257635128
Rt12482 T1999 T2250 12599180.433977256
Rt12483 T1999 T2606 2533330.4506719555
Rt12484 T1999 T2607 2666631.3869930096
Gcorr4170 T1999 T3479 T1999 T3479 -8.560916126157248e-08
Rt12485 T1999 T3480 3275760.9458206417
Rt12486 T1999 T3585 5226911.4319198597
Rt12487 T1999 T3613 2077903.5062016547
Rt12488 T2000 T2450 7663528.2679894958
Rt12489 T2000 T2493 1384967.6331671115
Gcorr4171 T2000 T2657 T2000 T2657 -1.1055518134279622e-08
Rt12490 T2000 T2979 159111346.62401846
Rt12491 T2000 T3035 2576978.2549123759
Rt12492 T2000 T3286 3223999.1891012294
Rt12493 T2000 T3951 474154.93082810519
Gcorr4172 T2000 T4106 T2000 T4106 -1.5694095388679814e-07
Rt12494 T2001 T2002 1730380.8334701736
Rt12495 T2001 T2098 4574835.0977871092
Rt12496 T2001 T2189 10379850.234879691
Rt12497 T2001 T3654 3783891.3252690122
Rt12498 T2001 T3659 1810679.474940215
Gcorr4173 T2001 T4176 T2001 T4176 -2.8761079164945407e-07
Rt12499 T2002 T2038 4570875.0674623773
Rt12500 T2002 T2125 1783625.7740142553
Rt12501 T2002 T2189 1630836.1025236933
Gcorr4174 T2002 T2768 T2002 T2768 -4.309387683351072e-07
Gcorr4175 T2002 T3659 T2002 T3659 -4.0004023130190527e-07
Rt12502 T2003 T2138 4784960.4794807173
Gcorr4176 T2003 T2139 T2003 T2139 -6.2828267603492761e-09
Rt12503 T2003 T2440 2330278.1726469323
Rt12504 T2003 T2718 2111077.3388536507
Rt12505 T2003 T3145 1510972.6415065392
Gcorr4177 T2003 T3146 T2003 T3146 -1.4910081480375244e-07
Rt12506 T2003 T3532 3768188.3842133204
Gcorr4178 T2003 T3861 T2003 T3861 -6.7314789146669121e-08
Rt12507 T2004 T2348 3117362.7461426593
Rt12508 T2004 T2655 2635130.4821341839
Gcorr4179 T2004 T3431 T2004 T3431 -1.3346304281371224e-07
Rt12509 T2004 T3564 1735132.7632371699
Gcorr4180 T2004 T3763 T2004 T3763 -1.5666075556689489e-07
Rt12510 T2004 T3982 3912674.0437328084
Rt12511 T2005 T2169 4446205.0649299128
Rt12512 T2005 T2383 7180873.1144809248
Rt12513 T2005 T2696 2389297.6840501516
Gcorr4181 T2006 T2007 T2006 T2007 -4.0863617612461632e-07
Gcorr4182 T2006 T2442 T2006 T2442 -6.7501678423584476e-08
Rt12514 T2006 T2581 654703.36223173689
Gcorr4183 T2006 T2652 T2006 T2652 -2.9202786590303506e-08
Rt12515 T2006 T2855 613744.34367525962
Rt12516 T2006 T3057 1169397.7572694505
Rt12517 T2006 T3572 426594.64077531861
Gcorr4184 T2006 T3787 T2006 T3787 -6.3854462321980303e-07
Gcorr4185 T2007 T2033 T2007 T2033 -1.9370213352230476e-07
Gcorr4186 T2007 T2550 T2007 T2550 -2.8415717859317109e-07
Rt12518 T2007 T2581 1635232.5575381326
Rt12519 T2007 T2855 448685.93253412849
Rt12520 T2007 T3486 615175.03703605384
Rt12521 T2007 T3787 870341.6675086735
Rt12522 T2007 T3993 3817596.9200886427
Rt12523 T2008 T2009 34333789.699234068
Rt12524 T2008 T2589 1077092.1532019123
Rt12525 T2008 T2628 1495945.7891228013
Gcorr4187 T2008 T2737 T2008 T2737 -1.2751848664295389e-07
Rt12526 T2008 T3428 221909.6832416348
Gcorr4188 T2008 T3429 T2008 T3429 -4.2814339038219088e-07
Rt12527 T2008 T3717 5166358.3910704236
Rt12528 T2008 T3718 21318857.706256788
Gcorr4189 T2008 T4073 T2008 T4073 -3.6910437274711771e-06
Gcorr4190 T2009 T2194 T2009 T2194 -2.982465579805057e-08
Rt12529 T2009 T2406 1480879.1214922713
Gcorr4191 T2009 T2566 T2009 T2566 -4.3839234734124165e-08
Rt12530 T2009 T2594 2362415.7872159677
Rt12531 T2009 T2628 1913508.7623300082
Rt12532 T2009 T2737 17337992.199358769
Rt12533 T2009 T3718 1948105.8747813862
Rt12534 T2009 T3842 3194666.5609373068
Gcorr4192 T2009 T3890 T2009 T3890 -3.8734143325845933e-07
Rt12535 T2010 T2011 12378960.393439895
Rt12536 T2010 T2379 3463483.133449113
Rt12537 T2010 T2854 3037927.7921194425
Gcorr4193 T2010 T3818 T2010 T3818 -8.3706978538288997e-08
Rt12538 T2011 T2217 4574262.5456450293
Rt12539 T2011 T2320 10210221.081291668
Rt12540 T2011 T2330 3333873.580011291
Rt12541 T2011 T2379 3855490.2726434567
Rt12542 T2012 T2196 4323554.4854201265
Rt12543 T2012 T2206 4239540.9599802131
Rt12544 T2012 T2778 13597719.522840464
Gcorr4194 T2012 T3800 T2012 T3800 -1.4239512649556145e-07
Rt12545 T2012 T3889 1993318.2490128083
Rt12546 T2013 T2073 666153.20575315342
Rt12547 T2013 T2451 1593112.1818472259
Gcorr4195 T2013 T2511 T2013 T2511 -3.1754053448779982e-07
Rt12548 T2013 T2586 2855805.3021167293
Rt12549 T2013 T2922 488456.74452331587
Rt12550 T2013 T2961 11582562.613008905
Rt12551 T2013 T2962 504205.59036992089
Gcorr4196 T2013 T3509 T2013 T3509 -1.1359613149403339e-06
Gcorr4197 T2014 T2353 T2014 T2353 -1.3608932601086763e-07
Rt12552 T2014 T2687 1132817.3542704913
Rt12553 T2014 T3523 457695.80168493418
Rt12554 T2014 T4083 2489765.6104580904
Gcorr4198 T2014 T4175 T2014 T4175 -6.1907854362472107e-08
Gcorr4199 T2015 T2219 T2015 T2219 -3.4737553357972882e-08
Rt12555 T2015 T2332 1787266.2147271151
Gcorr4200 T2015 T2554 T2015 T2554 -4.3650426234833327e-08
Rt12556 T2015 T2605 1379988.0484108296
Rt12557 T2015 T2682 3208439.5216077934
Gcorr4201 T2015 T3004 T2015 T3004 -3.310775971182352e-08
Gcorr4202 T2015 T3458 T2015 T3458 -2.0114307724528928e-07
Gcorr4203 T2015 T3602 T2015 T3602 -1.1795327581899977e-08
Rt12558 T2015 T3761 668235.54193446599
Gcorr4204 T2015 T4135 T2015 T4135 -5.9309108238143512e-10
Gcorr4205 T2016 T2017 T2016 T2017 -1.2361063941996465e-08
Gcorr4206 T2016 T2018 T2016 T2018 -1.8882131102346907e-08
Rt12559 T2016 T2602 1188094.9543513111
Gcorr4207 T2016 T3090 T2016 T3090 -2.8801682351346917e-07
Rt12560 T2016 T3091 779999.34191528196
Gcorr4208 T2016 T3092 T2016 T3092 -1.7112662151440843e-08
Rt12561 T2016 T3093 1121329.8098824734
Gcorr4209 T2016 T3591 T2016 T3591 -5.1699467486080521e-07
Rt12562 T2017 T2018 6576226.3963816985
Rt12563 T2017 T2571 4873226.6371507924
Rt12564 T2017 T2572 4564152.2999488562
Rt12565 T2017 T2640 5996287.5973334154
Rt12566 T2017 T3093 2766898.3790095244
Rt12567 T2017 T3095 1884251.1909592447
Gcorr4210 T2017 T3130 T2017 T3130 -1.2445648490589191e-07
Rt12568 T2017 T3950 2205426.9384532981
Rt12569 T2018 T2359 16809783.701163035
Rt12570 T2018 T2427 22774979.802302487
Rt12571 T2018 T2602 2615363.3435617001
Rt12572 T2018 T2640 2110694.0441091568
Rt12573 T2018 T2686 2155411.0720048263
Gcorr4211 T2018 T3092 T2018 T3092 -1.3977987363674359e-07
Rt12574 T2018 T3093 3840814.8955003293
Rt12575 T2018 T3094 1047583.4656782896
Gcorr4212 T2018 T3095 T2018 T3095 -2.2935950834315711e-07
Rt12576 T2019 T2596 2690772.0286190612
Rt12577 T2019 T2626 2864460.0129248961
Gcorr4213 T2019 T2688 T2019 T2688 -2.5986811245441547e-08
Rt12578 T2019 T2725 2704566.7369173598
Rt12579 T2019 T2770 3982043.2613850329
Rt12580 T2019 T3668 23260597.281765353
Gcorr4214 T2019 T3859 T2019 T3859 -3.7165845485491807e-08
Rt12581 T2019 T4086 5578535.5474789487
Rt12582 T2019 T4095 109229045.89729516
Rt12583 T2020 T2311 3749081.5743636289
Rt12584 T2020 T2397 6943515.9828522643
Rt12585 T2020 T2765 11335672.591334645
Gcorr4215 T2020 T3232 T2020 T3232 -2.2945538904456091e-07
Rt12586 T2020 T3542 7957053.0931187896
Rt12587 T2020 T3623 1880702.8112370083
Rt12588 T2021 T2079 5265837.8412870588
Rt12589 T2021 T2371 4159874.1440959685
Rt12590 T2021 T2839 4583039.8298886847
Rt12591 T2021 T3746 17208034.962271567
Rt12592 T2022 T2244 6908106.8208247041
Rt12593 T2022 T2700 2321376.7705010804
Gcorr4216 T2022 T2743 T2022 T2743 -1.713975654166829e-07
Rt12594 T2023 T2428 3375404.1725479863
Rt12595 T2023 T2659 1972885.9489399181
Gcorr4217 T2023 T2996 T2023 T2996 -5.8157024789975528e-07
Rt12596 T2023 T3372 442269.449199397
Rt12597 T2023 T3374 5537609.2576528229
Gcorr4218 T2023 T3772 T2023 T3772 -1.0065442246932225e-07
Rt12598 T2024 T2398 8220104.6131070508
Rt12599 T2024 T2514 5281209.2779992595
Rt12600 T2024 T3111 1178614.4469902909
Rt12601 T2024 T3776 1727886.0524078473
Rt12602 T2024 T3821 832717.51476609183
Rt12603 T2024 T3939 15309673.489873184
Rt12604 T2025 T2026 4629562.6208629068
Rt12605 T2025 T2343 14232379.53453457
Gcorr4219 T2025 T2587 T2025 T2587 -4.9567787910524326e-08
Rt12606 T2025 T3299 15022912.018428175
Gcorr4220 T2025 T3352 T2025 T3352 -1.3200299510322952e-07
Rt12607 T2025 T3354 1631068.4901206419
Rt12608 T2025 T3451 2808431.9582830179
Gcorr4221 T2025 T3871 T2025 T3871 -7.9817094320104341e-08
Rt12609 T2026 T2343 3624688.4163339916
Rt12610 T2026 T2367 1850203.1625508687
Rt12611 T2026 T2636 2401585.4164382196
Rt12612 T2026 T3352 3125039.8188537899
Gcorr4222 T2026 T3451 T2026 T3451 -1.3303955854919093e-07
Gcorr4223 T2026 T3587 T2026 T3587 -2.456547624802167e-07
Rt12613 T2026 T4009 7929205.2088087881
Rt12614 T2026 T4140 2269817.9235438639
Rt12615 T2027 T2082 4155994.5207523005
Gcorr4224 T2027 T2364 T2027 T2364 -1.3738217406767355e-08
Rt12616 T2027 T2387 9403249.9901583381
Rt12617 T2027 T2414 2178535.3670164682
Gcorr4225 T2027 T3207 T2027 T3207 -1.3072956381813434e-07
Rt12618 T2027 T3433 1970654.39968156
Rt12619 T2027 T3537 7285929.7289243648
Rt12620 T2027 T3692 2058589.0427792915
Gcorr4226 T2027 T4191 T2027 T4191 -2.1488272365992205e-07
Gcorr4227 T2028 T2464 T2028 T2464 -1.2295024381870332e-08
Rt12621 T2028 T2465 4589748.4226352191
Rt12622 T2028 T2606 2787905.1175384
Rt12623 T2028 T2705 5476667.6125506442
Rt12624 T2028 T3477 1729480.9248155747
Gcorr4228 T2028 T3479 T2028 T3479 -7.5769290015826799e-08
Rt12625 T2028 T4052 31730344.732881125
Rt12626 T2028 T4053 2226293.9950010008
Rt12627 T2029 T2068 4338397.9147395138
Rt12628 T2029 T2246 5947614.5478020469
Rt12629 T2029 T2274 4799589.8171949573
Rt12630 T2029 T2756 2788815.3555263691
Gcorr4229 T2029 T3891 T2029 T3891 -1.1072027464290011e-07
Gcorr4230 T2029 T3923 T2029 T3923 -2.0080390150706859e-07
Rt12631 T2030 T2465 2924738.1798668848
Rt12632 T2030 T2503 4546221.9483601479
Rt12633 T2030 T2507 3173645.6233092607
Gcorr4231 T2030 T3003 T2030 T3003 -3.4049726024956425e-07
Gcorr4232 T2030 T3351 T2030 T3351 -6.483090954702524e-08
Rt12634 T2030 T3401 675091.15979443351
Rt12635 T2030 T3823 1696635.4908411617
Gcorr4233 T2030 T4033 T2030 T4033 -5.4593504451075335e-07
Gcorr4234 T2030 T4052 T2030 T4052 -1.636466256886291e-07
Rt12636 T2031 T2032 9790605.1776677016
Rt12637 T2031 T2209 4134425.4874863978
Rt12638 T2031 T2885 8060550.9668278238
Gcorr4235 T2031 T3870 T2031 T3870 -1.9159757504024212e-07
Rt12639 T2032 T2188 10627888.776889149
Rt12640 T2032 T2209 5108926.3702265499
Rt12641 T2032 T2213 4002999.9641739884
Gcorr4236 T2032 T3870 T2032 T3870 -3.6296067603440715e-07
Rt12642 T2033 T2396 11727091.802826479
Gcorr4237 T2033 T2540 T2033 T2540 -5.6106498919726525e-08
Rt12643 T2033 T2874 678785.52373721404
Rt12644 T2033 T3486 2407039.0132412179
Rt12645 T2033 T3993 691356.34265145462
Rt12646 T2033 T4130 475241.04578661313
Rt12647 T2034 T2347 4228139.9072357193
Gcorr4238 T2034 T2373 T2034 T2373 -2.6492095567704209e-08
Rt12648 T2034 T2495 2379707.1212320453
Gcorr4239 T2035 T2369 T2035 T2369 -5.7828141884489196e-08
Rt12649 T2035 T2485 11817479.544226713
Rt12650 T2035 T2668 60430130.406836472
Gcorr4240 T2035 T3307 T2035 T3307 -1.0497074198534965e-07
Rt12651 T2035 T3312 2598896.5287432624
Rt12652 T2035 T3313 916660.41185458435
Rt12653 T2035 T3314 7500886.8448022502
Gcorr4241 T2035 T3315 T2035 T3315 -2.5938951380768305e-07
Rt12654 T2036 T2037 3958780.5474652061
Rt12655 T2036 T2723 4044485.5102054998
Rt12656 T2037 T2232 3911302.4832130563
Rt12657 T2037 T2426 4169343.8675529128
Rt12658 T2037 T2579 6774207.8938348535
Rt12659 T2038 T2189 21976900.842516456
Rt12660 T2038 T2309 7591501.4559742473
Rt12661 T2039 T2110 4675443.6216905303
Rt12662 T2039 T2700 4494554.9072727747
Rt12663 T2039 T2716 234634.71050767132
Gcorr4242 T2039 T3649 T2039 T3649 -1.8413201800396071e-07
Rt12664 T2040 T2185 4194508.6994514214
Rt12665 T2040 T2203 9515709.0802857373
Rt12666 T2040 T2786 2526429.5220792978
Gcorr4243 T2040 T3661 T2040 T3661 -1.6264443446576205e-07
Rt12667 T2041 T2042 21840435.729988229
Rt12668 T2041 T2708 2492942.2594872057
Rt12669 T2041 T3149 2229673.9363203528
Rt12670 T2041 T3980 87938158.278045788
Rt12671 T2041 T4103 14220526.924338235
Rt12672 T2042 T2110 6795912.5486791916
Rt12673 T2042 T2536 1826653.9331608259
Rt12674 T2042 T2708 2839687.9768749359
Rt12675 T2042 T2762 2851620.6481533819
Rt12676 T2042 T3522 5528848.3882809645
Gcorr4244 T2042 T3649 T2042 T3649 -4.9593942759061722e-08
Gcorr4245 T2042 T3928 T2042 T3928 -3.1138504329144292e-07
Rt12677 T2042 T4103 3087600.0036312686
Rt12678 T2043 T2096 3906602.456125801
Rt12679 T2043 T2217 4078710.2289738734
Rt12680 T2043 T2237 4223211.9353626575
Rt12681 T2043 T2856 4384941.4932402326
Rt12682 T2043 T3592 203824803.36534485
Rt12683 T2044 T2100 8969092.278313769
Rt12684 T2044 T2184 4448964.9457614077
Gcorr4246 T2044 T2761 T2044 T2761 -1.5336458175655997e-07
Rt12685 T2044 T2801 9581281.9032181501
Rt12686 T2044 T3994 7067746.5496389922
Rt12687 T2045 T2296 4380801.9554502098
Rt12688 T2045 T2846 889768.9389420955
Gcorr4247 T2045 T3766 T2045 T3766 -4.7914996706978925e-07
Rt12689 T2045 T3788 13494604.196449604
Gcorr4248 T2045 T3919 T2045 T3919 -1.4722679690849318e-07
Rt12690 T2046 T2047 5122973.3831417607
Rt12691 T2046 T2429 7818171.2337191487
Rt12692 T2046 T2455 6473842.4364275923
Gcorr4249 T2046 T2656 T2046 T2656 -8.0335925782052131e-08
Gcorr4250 T2046 T3319 T2046 T3319 -1.0863764821828189e-07
Rt12693 T2046 T3320 1680954.8158742283
Rt12694 T2046 T3321 1916196.3564956661
Rt12695 T2046 T3839 4763069.7227543546
Rt12696 T2047 T2403 92419126.574145272
Rt12697 T2047 T2599 3507674.332604622
Rt12698 T2047 T2656 3001087.3849477223
Rt12699 T2047 T3321 1633033.6051971528
Rt12700 T2047 T3436 2240939.9246321702
Gcorr4251 T2047 T3839 T2047 T3839 -5.011462304221303e-08
Rt12701 T2047 T3998 25261849.240724847
Gcorr4252 T2048 T2384 T2048 T2384 -1.2718445522570152e-08
Rt12702 T2048 T2385 3379109.2842380526
Rt12703 T2048 T2399 4603872.8220887277
Rt12704 T2048 T2724 5047460.0460034935
Rt12705 T2048 T3066 130024235.8370859
Rt12706 T2048 T3102 1816553.9774957506
Rt12707 T2048 T3103 2632692.7520635095
Rt12708 T2048 T3104 4686557.4613450989
Rt12709 T2049 T2050 1863422.0674639309
Rt12710 T2049 T2081 1625434.3972096827
Rt12711 T2049 T2611 2161671.4403743851
Rt12712 T2049 T3177 176598.05163727154
Rt12713 T2049 T3446 6445617.2919598427
Gcorr4253 T2049 T3705 T2049 T3705 -2.3208480673106023e-07
Gcorr4254 T2049 T3781 T2049 T3781 -7.3705224701576879e-07
Gcorr4255 T2050 T2056 T2050 T2056 -1.2429070221216562e-07
Rt12714 T2050 T2057 627910376.76969635
Rt12715 T2050 T2081 1033502.6804621868
Rt12716 T2050 T2538 3911461.7856020308
Gcorr4256 T2050 T3177 T2050 T3177 -7.8130372586735846e-07
Rt12717 T2050 T3251 1368705.5429848407
Rt12718 T2050 T3705 286875.57268356334
Rt12719 T2050 T3706 940423.41817569756
Gcorr4257 T2050 T4000 T2050 T4000 -2.7948236030978033e-07
Rt12720 T2051 T2505 1186901.4807781021
Rt12721 T2051 T2659 848807.65886328742
Rt12722 T2051 T3012 261526.36507750172
Gcorr4258 T2051 T3481 T2051 T3481 -5.4816074711753897e-07
Gcorr4259 T2051 T4124 T2051 T4124 -3.9784568289537342e-07
Rt12723 T2052 T2053 4774130.2306445306
Rt12724 T2052 T2054 9271192.2492760047
Gcorr4260 T2052 T2258 T2052 T2258 -1.5477049617365138e-08
Rt12725 T2052 T2638 2120403.4906251477
Gcorr4261 T2052 T3243 T2052 T3243 -1.8116341685249553e-07
Rt12726 T2052 T3248 1745604.873275456
Rt12727 T2052 T3328 34278175.33605741
Rt12728 T2052 T3331 2495769.8008818673
Rt12729 T2052 T4099 6137350.464488213
Rt12730 T2053 T2054 4840756.2444485156
Rt12731 T2053 T2055 5420517.6638310719
Rt12732 T2053 T2500 3847621.5041299034
Rt12733 T2053 T2515 4921029.7044494683
Rt12734 T2053 T3241 1671224.8273473284
Gcorr4262 T2053 T3242 T2053 T3242 -1.5383427171569242e-07
Rt12735 T2053 T3243 2347897.1698083617
Gcorr4263 T2053 T3622 T2053 T3622 -2.6985272771329893e-07
Rt12736 T2053 T4099 2587980.9464957495
Gcorr4264 T2054 T2181 T2054 T2181 -1.2339502716446129e-08
Rt12737 T2054 T2515 979751.49731129885
Rt12738 T2054 T2638 1411562.8258572398
Rt12739 T2054 T2703 1073020.1795960667
Gcorr4265 T2054 T3331 T2054 T3331 -1.5688686115890959e-07
Gcorr4266 T2054 T3622 T2054 T3622 -3.5981716480364626e-07
Gcorr4267 T2054 T3795 T2054 T3795 -3.8177837410010574e-07
Gcorr4268 T2054 T3796 T2054 T3796 -7.1910593822396644e-08
Rt12740 T2054 T3974 528579.12992815219
Gcorr4269 T2054 T4098 T2054 T4098 -4.6939535992363046e-07
Rt12741 T2054 T4099 18055027.519837935
Rt12742 T2055 T2056 5780167.9927500281
Gcorr4270 T2055 T2462 T2055 T2462 -1.316497908971432e-07
Rt12743 T2055 T2500 11864782.612726728
Rt12744 T2055 T3242 1678251.586071505
Rt12745 T2055 T3243 18354386.210750148
Rt12746 T2055 T3245 1370317.040870457
Rt12747 T2055 T3246 6720032.7932300838
Rt12748 T2056 T2462 2050859.0405623603
Rt12749 T2056 T2538 2738296.5974066937
Rt12750 T2056 T3245 11786632.24009205
Rt12751 T2056 T3246 1277902.3993906607
Rt12752 T2056 T3251 793375.67347919347
Rt12753 T2056 T3370 20608593.705939103
Gcorr4271 T2056 T4166 T2056 T4166 -3.7006467904706528e-07
Rt12754 T2057 T2081 10906732.724028291
Gcorr4272 T2057 T2858 T2057 T2858 -1.1030665422551723e-07
Rt12755 T2057 T3706 503095.23502853722
Rt12756 T2057 T3973 1440329.23272722
Rt12757 T2057 T3986 1170939.5832527995
Rt12758 T2057 T4000 26277722.022427574
Rt12759 T2058 T2198 10180247.484927116
Rt12760 T2058 T2254 4335698.4576641461
Rt12761 T2058 T3648 2794146.5425949912
Rt12762 T2058 T3756 8020455.2075127037
Rt12763 T2059 T2060 5638060.8512303568
Rt12764 T2059 T2566 1979381.8477416486
Gcorr4273 T2059 T2754 T2059 T2754 -2.7724706847911458e-07
Gcorr4274 T2059 T2926 T2059 T2926 -2.4514767693865675e-07
Rt12765 T2059 T3687 837455.26863855182
Gcorr4275 T2059 T3820 T2059 T3820 -3.2653174241877613e-07
Rt12766 T2060 T2061 1668296.9020461217
Rt12767 T2060 T2062 16571283.016738676
Rt12768 T2060 T2566 6444866.0165632432
Rt12769 T2060 T2594 3375930.455746992
Rt12770 T2060 T2926 10470417.781436747
Rt12771 T2061 T2062 4734644.735379165
Rt12772 T2061 T2236 2555535.4072068511
Rt12773 T2061 T2349 2106512.1366364555
Rt12774 T2061 T2434 6942558.4096146664
Rt12775 T2062 T2194 13017082.685571231
Rt12776 T2062 T2245 1816961.80732663
Rt12777 T2062 T2349 9017446.0980702229
Rt12778 T2062 T2594 3195141.0492236093
Rt12779 T2063 T2186 2814759.9667537264
Gcorr4276 T2063 T2956 T2063 T2956 -1.1615437904279625e-07
Gcorr4277 T2063 T3701 T2063 T3701 -4.6265086788714356e-07
Rt12780 T2064 T2354 1605143.330333703
Rt12781 T2064 T2437 7925699.7991720075
Rt12782 T2064 T2861 2319141.2021736777
Rt12783 T2064 T3671 11276490.78549049
Rt12784 T2065 T2222 5556369.870838441
Rt12785 T2065 T2664 2432977.7932636882
Rt12786 T2065 T2695 4110570.0212502638
Rt12787 T2065 T3472 5807826.939048673
Rt12788 T2065 T3892 2956228.4112892742
Gcorr4278 T2065 T3937 T2065 T3937 -2.7117456157206149e-08
Rt12789 T2066 T2067 16979483.314629026
Rt12790 T2066 T2117 72787075.688212454
Rt12791 T2066 T2341 1645191.6121907679
Rt12792 T2066 T2669 3520627.1938094292
Rt12793 T2066 T3107 4384969.7594957249
Gcorr4279 T2066 T3283 T2066 T3283 -4.8310880074054145e-07
Rt12794 T2066 T3452 5988332.0441469494
Rt12795 T2066 T3832 1274156.5857823628
Gcorr4280 T2067 T2116 T2067 T2116 -4.2965591402136165e-08
Rt12796 T2067 T2341 860288.31031400582
Rt12797 T2067 T2385 4259996.5519312229
Rt12798 T2067 T3105 2486772.0974226194
Rt12799 T2067 T3106 3814701.0093022515
Rt12800 T2067 T3107 876714.13084551564
Gcorr4281 T2067 T3283 T2067 T3283 -6.2438489117969745e-07
Rt12801 T2068 T2158 4233026.8778937869
Rt12802 T2068 T2246 4497206.2853463003
Rt12803 T2068 T3923 10735032.25128568
Rt12804 T2069 T2413 3821661.1386752506
Rt12805 T2069 T2983 8546322.0315634981
Gcorr4282 T2069 T3574 T2069 T3574 -1.2155608066379469e-07
Rt12806 T2069 T3911 1831055.779164779
Rt12807 T2069 T4157 16305871.928834165
Rt12808 T2070 T2279 13802923.114758741
Gcorr4283 T2070 T2344 T2070 T2344 -3.4128564941107226e-08
Rt12809 T2070 T2382 4534812.1312869471
Rt12810 T2070 T2470 1155414.435220924
Rt12811 T2070 T2792 14969025.339465488
Rt12812 T2070 T3797 4259265.0192315606
Rt12813 T2071 T2242 6211871.9552986892
Rt12814 T2071 T2352 2237733.8987293104
Rt12815 T2071 T2370 2572070.3645558963
Gcorr4284 T2071 T3013 T2071 T3013 -1.585666089900682e-07
Rt12816 T2071 T3067 1740966.922333512
Gcorr4285 T2071 T3176 T2071 T3176 -6.287034309731019e-07
Gcorr4286 T2071 T3190 T2071 T3190 -2.4127521155329568e-07
Rt12817 T2071 T3847 558917.4255120646
Gcorr4287 T2072 T2498 T2072 T2498 -1.3902326683228851e-07
Rt12818 T2072 T2613 1246735.6579093745
Gcorr4288 T2072 T2873 T2072 T2873 -1.8990256049160177e-07
Gcorr4289 T2072 T2905 T2072 T2905 -3.0662645527427662e-07
Rt12819 T2072 T2931 601856.16720597423
Gcorr4290 T2072 T3549 T2072 T3549 -1.3280556976247541e-08
Gcorr4291 T2072 T3550 T2072 T3550 -1.0447955152844679e-07
Rt12820 T2072 T3905 18127194.622270178
Rt12821 T2072 T4064 9863335.5370049514
Rt12822 T2073 T2093 2872061.0996521795
Rt12823 T2073 T2511 2621266.0991484686
Gcorr4292 T2073 T2625 T2073 T2625 -1.0725236232402311e-07
Rt12824 T2073 T2922 3627623.9717257312
Gcorr4293 T2073 T2923 T2073 T2923 -1.3369948624769454e-08
Gcorr4294 T2073 T2962 T2073 T2962 -1.114412866648856e-06
Rt12825 T2073 T3509 280821.80224566587
Gcorr4295 T2074 T2378 T2074 T2378 -5.9320080817333421e-08
Rt12826 T2074 T2422 1307028.5551630044
Gcorr4296 T2074 T2423 T2074 T2423 -5.0869300119845732e-08
Rt12827 T2074 T2622 2296780.1311763823
Rt12828 T2074 T2978 16671009.632661141
Gcorr4297 T2074 T3030 T2074 T3030 -2.9165563216709196e-07
Rt12829 T2074 T3031 969680.96676946478
Rt12830 T2074 T4115 1949430.9511310253
Rt12831 T2075 T2623 1932093.4841095917
Rt12832 T2075 T2698 2120994.4020861587
Rt12833 T2075 T2812 400120.62069207535
Rt12834 T2075 T2816 1073185.1830390634
Rt12835 T2075 T2817 617318.23637763294
Gcorr4298 T2075 T3552 T2075 T3552 -1.2339409357400467e-06
Rt12836 T2076 T2077 4429325.7704120651
Rt12837 T2076 T2429 5172016.7795930905
Rt12838 T2076 T2454 2642289.2908870084
Gcorr4299 T2076 T3343 T2076 T3343 -4.5154435051584285e-08
Rt12839 T2076 T3569 3105014.7766690864
Rt12840 T2076 T3739 16906187.293098792
Gcorr4300 T2076 T3941 T2076 T3941 -5.3930011514013796e-07
Rt12841 T2076 T4134 1305889.0597875977
Rt12842 T2077 T2078 1271423.7957525477
Rt12843 T2077 T2508 340076557.45961583
Rt12844 T2077 T2788 859857.39423608338
Gcorr4301 T2077 T3713 T2077 T3713 -7.2866706765932396e-07
Rt12845 T2077 T3739 5115554.0492323618
Gcorr4302 T2077 T4134 T2077 T4134 -9.3210857953523766e-08
Rt12846 T2078 T2508 3293662.0277240532
Rt12847 T2078 T2781 15166885.981692823
Gcorr4303 T2078 T2788 T2078 T2788 -7.1435521152945048e-07
Rt12848 T2078 T3713 1057318.3168828245
Rt12849 T2079 T2080 4942566.802574574
Rt12850 T2079 T2371 4228201.346038932
Gcorr4304 T2079 T3745 T2079 T3745 -4.4057244397308283e-07
Gcorr4305 T2079 T3746 T2079 T3746 -1.4838474140851965e-07
Rt12851 T2080 T2371 11089942.420942817
Rt12852 T2080 T2443 3645361.3266941314
Rt12853 T2080 T2548 3205863.9073575088
Gcorr4306 T2081 T2611 T2081 T2611 -3.7523871654170046e-07
Rt12854 T2081 T2719 6621291.1002700636
Rt12855 T2081 T2858 3161063.5190099184
Rt12856 T2081 T3177 1769786.1552571983
Gcorr4307 T2081 T3705 T2081 T3705 -1.2426480131300206e-06
Rt12857 T2081 T3706 480833.06850239541
Rt12858 T2081 T3781 430932.0572461519
Gcorr4308 T2082 T2180 T2082 T2180 -4.1587444236963545e-09
Rt12859 T2082 T2364 2198343.7981290035
Rt12860 T2082 T2666 2289432.2229393045
Rt12861 T2082 T3207 9247716.9650163818
Rt12862 T2082 T3422 1740862.4614664477
Rt12863 T2082 T3433 17103573.128931094
Gcorr4309 T2082 T4163 T2082 T4163 -1.8483918509853605e-07
Gcorr4310 T2083 T2758 T2083 T2758 -1.4926439341508995e-07
Rt12864 T2083 T3682 2844459.4767130241
Gcorr4311 T2083 T3961 T2083 T3961 -9.5108056289619317e-08
Rt12865 T2084 T2095 9773095.9059496745
Gcorr4312 T2084 T3651 T2084 T3651 -1.2139867533954353e-07
Rt12866 T2084 T3876 4635076.5089932643
Rt12867 T2085 T2691 2787738.1913414947
Rt12868 T2085 T2723 4886048.5386808272
Gcorr4313 T2085 T4036 T2085 T4036 -6.7755395209667882e-08
Rt12869 T2086 T2087 1666544.8458276344
Rt12870 T2086 T2089 9216006.2439288609
Rt12871 T2086 T2739 11858307.037126051
Gcorr4314 T2086 T3704 T2086 T3704 -1.2227104977256172e-07
Rt12872 T2087 T2089 3876813.8500049235
Rt12873 T2087 T2548 3455856.5197133189
Rt12874 T2087 T2649 665693.3487081097
Rt12875 T2088 T2609 2808066.8606067467
Rt12876 T2088 T2688 2467755.9725171858
Gcorr4315 T2088 T2771 T2088 T2771 -5.9318951001311178e-08
Rt12877 T2088 T3562 2868841.4634207236
Rt12878 T2089 T2166 4730791.9786506062
Rt12879 T2089 T2167 1248736.9404842153
Gcorr4316 T2089 T2649 T2089 T2649 -2.3033601982024801e-09
Rt12880 T2090 T2204 11345077.585595574
Rt12881 T2090 T2407 3396668.5467311745
Rt12882 T2090 T2479 4085167.8549022651
Rt12883 T2091 T2097 5494302.9816972744
Rt12884 T2091 T2246 9871708.4992235433
Rt12885 T2091 T2274 1202384.0325326012
Rt12886 T2092 T2509 72369254.394063249
Gcorr4317 T2092 T2790 T2092 T2790 -1.8733575356813256e-07
Rt12887 T2092 T3453 1800131.413789355
Rt12888 T2092 T4022 4629504.632234796
Rt12889 T2093 T2192 9883442.4709352851
Gcorr4318 T2093 T2511 T2093 T2511 -1.6172265829269393e-07
Rt12890 T2093 T2923 685429.56364407472
Gcorr4319 T2093 T3160 T2093 T3160 -2.5754149209157456e-07
Rt12891 T2093 T3509 2026146.9412364985
Rt12892 T2093 T3809 453943.02624797047
Gcorr4320 T2093 T4031 T2093 T4031 -2.5435349514242628e-07
Rt12893 T2094 T2273 5507822.2317076344
Gcorr4321 T2094 T2446 T2094 T2446 -2.409158904593897e-08
Rt12894 T2094 T2491 2910910.3806414343
Rt12895 T2094 T2721 1819520.0452798742
Gcorr4322 T2094 T3637 T2094 T3637 -1.4141876769410425e-07
Rt12896 T2094 T3730 1433645.7427699897
Rt12897 T2094 T3731 8215944.5075750686
Rt12898 T2094 T4032 4255137.5637547923
Rt12899 T2095 T2221 9701380.8029406555
Rt12900 T2096 T2237 4032873.4114933503
Gcorr4323 T2096 T2856 T2096 T2856 -1.3431877776871666e-07
Rt12901 T2096 T3409 5487670.8087711278
Rt12902 T2097 T2784 3331330.7850701823
Gcorr4324 T2097 T3812 T2097 T3812 -1.6111987889116282e-07
Gcorr4325 T2097 T3815 T2097 T3815 -7.8607294290725262e-07
Rt12903 T2098 T2162 2967611.2806656626
Rt12904 T2098 T2189 4531625.243050674
Gcorr4326 T2098 T2767 T2098 T2767 -4.2755243557337347e-07
Gcorr4327 T2098 T3654 T2098 T3654 -1.7963358241979344e-07
Rt12905 T2099 T2411 2878123.529697082
Rt12906 T2099 T2412 1725042.195575559
Gcorr4328 T2099 T2521 T2099 T2521 -3.5545653078415006e-07
Rt12907 T2099 T2821 3368938.6902993354
Rt12908 T2099 T2829 389398.02827603486
Gcorr4329 T2099 T2878 T2099 T2878 -4.177771081539364e-07
Rt12909 T2099 T3525 396264.60501291993
Rt12910 T2099 T4012 1917137.062779838
Rt12911 T2100 T2157 4414588.4757819064
Rt12912 T2100 T2184 2982457.1242839298
Gcorr4330 T2100 T3632 T2100 T3632 -1.9442881425162634e-07
Rt12913 T2101 T2102 11179447.573830977
Rt12914 T2101 T2349 11136245.543170981
Rt12915 T2101 T2434 3810263.2989406148
Gcorr4331 T2101 T3579 T2101 T3579 -1.4335474289326935e-07
Rt12916 T2102 T2103 4795489.607100049
Rt12917 T2102 T2104 10740910.502650209
Rt12918 T2102 T2434 4729101.9504508059
Rt12919 T2102 T2562 3398337.2492374554
Rt12920 T2102 T2832 5599000.916430952
Rt12921 T2102 T3670 30342234.665082645
Rt12922 T2103 T2104 2689925.2502688835
Rt12923 T2103 T2362 3735028.4208157556
Rt12924 T2103 T2369 12071152.509143962
Rt12925 T2103 T2668 7378906.2077915287
Rt12926 T2103 T2832 7773580.1414654115
Gcorr4332 T2103 T3670 T2103 T3670 -1.9351149898443257e-07
Rt12927 T2103 T3785 1714264.1189406069
Gcorr4333 T2103 T4065 T2103 T4065 -7.7314590916344882e-08
Rt12928 T2104 T2369 1578187.0303377826
Rt12929 T2104 T2562 2918748.0709855119
Rt12930 T2104 T2654 1547710.6070557216
Gcorr4334 T2104 T3359 T2104 T3359 -1.1182626919069943e-07
Rt12931 T2104 T3670 935925.05460174941
Gcorr4335 T2104 T3785 T2104 T3785 -4.3184542032773997e-07
Gcorr4336 T2104 T3805 T2104 T3805 -8.5442834251739475e-08
Rt12932 T2105 T2383 3696888.9684920483
Gcorr4337 T2105 T3450 T2105 T3450 -1.7432364441285569e-07
Rt12933 T2105 T3916 2251589.5507648657
Rt12934 T2106 T2386 2958191.1462195134
Rt12935 T2106 T2597 6794418.8446705751
Rt12936 T2107 T2479 6069637.400986542
Rt12937 T2107 T2535 5517454.9911982641
Rt12938 T2108 T2123 4767975.3235249901
Rt12939 T2108 T2331 9610494.9072208107
Rt12940 T2108 T2448 3675710.2610600721
Gcorr4338 T2108 T3611 T2108 T3611 -8.5131501373236704e-08
Rt12941 T2109 T2201 1324558.9748708326
Rt12942 T2109 T2400 1369583.8839916657
Rt12943 T2109 T2574 1774398.7164430625
Rt12944 T2110 T2716 18094095.746214077
Rt12945 T2110 T2762 8935518.5708372016
Rt12946 T2110 T3649 46616222.613534227
Rt12947 T2111 T2112 10590893.093944576
Rt12948 T2112 T2113 10696854.856795145
Rt12949 T2112 T2114 4680798.9773020623
Rt12950 T2112 T2251 9275752.5830865018
Rt12951 T2112 T2766 10368764.409409696
Rt12952 T2113 T2114 4572616.5318572652
Rt12953 T2114 T2251 3253183.6630946635
Gcorr4339 T2114 T2766 T2114 T2766 -9.3984321129290781e-08
Rt12954 T2114 T3557 1795125.6846464733
Rt12955 T2115 T2116 5086283.4309334354
Rt12956 T2115 T2384 3494695.2278916501
Rt12957 T2115 T2773 14665538.930987064
Rt12958 T2115 T3435 11304407.217043066
Rt12959 T2115 T3696 2226558.4676374528
Gcorr4340 T2115 T4177 T2115 T4177 -1.4229450205944192e-07
Rt12960 T2116 T2341 2357001.3896990665
Rt12961 T2116 T2384 6650047.3025200116
Rt12962 T2116 T2385 4261790.1540668849
Rt12963 T2116 T3105 5596801.1648162501
Rt12964 T2116 T3435 3158712.1955375019
Rt12965 T2116 T4177 8587432.4055669736
Rt12966 T2117 T2341 3454729.2147623356
Rt12967 T2117 T3283 13045457.666749351
Gcorr4341 T2117 T3548 T2117 T3548 -6.0019584629083287e-08
Rt12968 T2117 T3653 2587246.3500227011
Rt12969 T2117 T3832 8807488.7450933158
Rt12970 T2118 T2120 4199565.2205616813
Rt12971 T2119 T2198 10472407.052552078
Rt12972 T2119 T2254 1633707.2762544509
Rt12973 T2120 T2237 3966826.6164406859
Rt12974 T2121 T2122 4388298.4207250988
Rt12975 T2121 T2129 4281027.5384105965
Rt12976 T2121 T2504 7197722.8325430229
Gcorr4342 T2121 T2752 T2121 T2752 -8.5007585496496732e-08
Rt12977 T2121 T3853 2972921.3320950279
Rt12978 T2122 T2504 4776719.3989978572
Rt12979 T2122 T2614 2785390.0183829363
Rt12980 T2122 T2752 2819671.6773069426
Rt12981 T2122 T2967 10422133.376920518
Rt12982 T2122 T3620 9967088.5063462518
Gcorr4343 T2122 T3853 T2122 T3853 -1.1410593011397787e-07
Rt12983 T2123 T2130 4896160.363243307
Rt12984 T2123 T2331 1445331.4096511472
Rt12985 T2124 T2664 3180188.4755589846
Rt12986 T2124 T2750 3491120.340323118
Rt12987 T2124 T3503 152202877.40644121
Rt12988 T2124 T3694 5283196.3693841305
Gcorr4344 T2124 T4005 T2124 T4005 -5.1109516103934189e-08
Rt12989 T2125 T2248 4714642.1772557469
Rt12990 T2125 T2768 3788940.7833195711
Rt12991 T2125 T4114 6011525.9698881544
Rt12992 T2126 T2128 3633829.1050598258
Rt12993 T2127 T2137 9842589.3024934866
Rt12994 T2127 T2161 4692807.996445029
Rt12995 T2127 T2213 4621342.5712812133
Rt12996 T2128 T2596 2980662.1953421384
Rt12997 T2129 T2430 8439654.7375686057
Rt12998 T2129 T2504 3630014.3576910133
Rt12999 T2129 T3582 3129900.0828825249
Gcorr4345 T2129 T3853 T2129 T3853 -1.055182110205578e-07
Rt13000 T2130 T2331 3894171.8039705646
Rt13001 T2130 T2351 13044904.563777855
Rt13002 T2131 T2311 2667482.8565591341
Rt13003 T2131 T2397 7274023.8709395202
Rt13004 T2132 T2692 1180743.3325196553
Rt13005 T2132 T2695 2725382.1739235045
Gcorr4346 T2132 T2777 T2132 T2777 -9.8264671906544969e-07
Rt13006 T2132 T2982 8559219.1394814812
Rt13007 T2132 T3606 20412613.910538923
Rt13008 T2132 T4055 726735.23930282262
Rt13009 T2133 T2134 10061891.625956994
Rt13010 T2133 T2307 4295132.7363264672
Rt13011 T2133 T2742 8892385.2336072139
Rt13012 T2133 T3629 4070124.2144237016
Rt13013 T2133 T3711 1403362.4227409107
Gcorr4347 T2133 T3899 T2133 T3899 -1.2262333414509139e-07
Gcorr4348 T2133 T4160 T2133 T4160 -4.8584675361225304e-07
Rt13014 T2134 T2302 9093745.1459730025
Rt13015 T2134 T2303 3373587.7469721884
Rt13016 T2134 T2307 3199621.9881968526
Rt13017 T2134 T3554 1959073.3397108701
Rt13018 T2134 T3711 4661994.8052584101
Rt13019 T2134 T4024 4000343.6339382636
Gcorr4349 T2134 T4160 T2134 T4160 -4.1341561477397263e-07
Rt13020 T2135 T2530 2742986.2981543154
Gcorr4350 T2135 T2718 T2135 T2718 -2.8661987876748449e-08
Rt13021 T2135 T2764 1959911.2224766968
Gcorr4351 T2135 T3700 T2135 T3700 -1.5174485175543796e-07
Rt13022 T2135 T4051 5232179.3385981657
Rt13023 T2135 T4171 4976406.3993256008
Rt13024 T2136 T2156 4097786.8926381697
Rt13025 T2137 T2161 4284545.9309704285
Rt13026 T2138 T2139 2971914.2789481543
Rt13027 T2138 T2718 35200461.508395739
Gcorr4352 T2138 T2785 T2138 T2785 -8.6999908795489307e-08
Rt13028 T2138 T3532 10751739.687223855
Rt13029 T2138 T3660 2446303.4294320857
Rt13030 T2138 T3861 12499808.308102163
Rt13031 T2139 T2785 9385120.1616049893
Rt13032 T2139 T3532 5539295.4985929886
Rt13033 T2139 T3936 3316953.8107320769
Rt13034 T2140 T2165 3962939.4965214846
Rt13035 T2141 T2171 4774751.12048788
Rt13036 T2141 T2229 4781489.1658612844
Rt13037 T2142 T2249 4844002.3152131615
Rt13038 T2142 T2272 3480819.7575459303
Rt13039 T2143 T2382 8207450.8734751474
Rt13040 T2143 T2793 3143662.5537909865
Rt13041 T2143 T3663 3206478.7583541418
Gcorr4353 T2143 T3782 T2143 T3782 -8.2374664516806506e-08
Rt13042 T2144 T2259 18334323.289407279
Rt13043 T2144 T2336 4257756.8193497853
Rt13044 T2144 T2644 3256740.1809097924
Rt13045 T2145 T2170 1731321.782398863
Rt13046 T2145 T2178 3965108.7059838842
Rt13047 T2145 T2181 10207550.784326909
Gcorr4354 T2145 T2779 T2145 T2779 -5.072289722929393e-07
Rt13048 T2146 T2256 10797096.823447291
Rt13049 T2146 T2285 4246155.3967595082
Rt13050 T2146 T3535 17317296.798801661
Rt13051 T2146 T3577 2873880.2632670938
Rt13052 T2146 T3593 5392908.4567002747
Gcorr4355 T2146 T3898 T2146 T3898 -1.297133933211713e-07
Rt13053 T2147 T2734 2342417.671806796
Gcorr4356 T2147 T3964 T2147 T3964 -6.5297280641969476e-08
Rt13054 T2148 T2542 10066278.712922229
Gcorr4357 T2148 T3309 T2148 T3309 -6.6806569963982147e-08
Rt13055 T2148 T3669 12906752.739069456
Gcorr4358 T2148 T3672 T2148 T3672 -1.8046388964720439e-07
Rt13056 T2148 T3757 9488342.6015099455
Rt13057 T2148 T4116 1863367.5946839906
Rt13058 T2149 T2178 4977713.4476621402
Rt13059 T2149 T2181 5322169.065654329
Rt13060 T2149 T2703 3025326.1639151266
Rt13061 T2149 T2780 137284514.87356436
Rt13062 T2149 T3795 10613248.180321516
Rt13063 T2150 T2193 10039702.696332907
Rt13064 T2150 T2245 2145919.231720977
Rt13065 T2151 T2196 2987734.7495631333
Rt13066 T2151 T2206 4979524.0630771108
Rt13067 T2152 T2187 11257209.330107706
Rt13068 T2152 T2437 3766260.2933532265
Rt13069 T2152 T2499 2711690.0976059372
Rt13070 T2153 T2154 4418024.0267483322
Rt13071 T2153 T2155 4474188.3237954825
Gcorr4359 T2153 T2842 T2153 T2842 -2.0307471336823183e-07
Rt13072 T2153 T3695 8221408.8370083934
Rt13073 T2153 T3752 2175689.8782888111
Rt13074 T2153 T3819 11540038.091646165
Rt13075 T2154 T2155 11207831.782902606
Rt13076 T2154 T2431 2281316.0239640172
Rt13077 T2154 T2706 7842611.6226771735
Rt13078 T2154 T2713 3559849.8623504736
Gcorr4360 T2154 T3376 T2154 T3376 -2.0529034827600762e-07
Rt13079 T2154 T3380 2590906.8695505494
Rt13080 T2154 T3695 2447742.9573168284
Gcorr4361 T2154 T3819 T2154 T3819 -1.4992899027598386e-07
Rt13081 T2155 T2431 2780569.7816747753
Gcorr4362 T2155 T2842 T2155 T2842 -3.0077675066352309e-07
Gcorr4363 T2155 T3376 T2155 T3376 -1.7003252182671099e-07
Gcorr4364 T2155 T3383 T2155 T3383 -6.2554351863865117e-07
Rt13082 T2155 T3695 2879217.4015390775
Rt13083 T2155 T4131 828087.6355948057
Rt13084 T2156 T2163 4130182.7341478537
Rt13085 T2157 T2184 10584079.336973505
Rt13086 T2158 T2246 10681756.71749768
Rt13087 T2159 T2210 11736867.934102604
Rt13088 T2159 T2588 3899760.4120546458
Rt13089 T2159 T2691 1080992.0796616205
Rt13090 T2160 T2276 23981136.408664402
Rt13091 T2160 T2654 1205284.7275979472
Rt13092 T2160 T2834 4086877.0523565267
Gcorr4365 T2160 T3805 T2160 T3805 -4.2791507125488089e-07
Rt13093 T2161 T2213 4568652.3608222883
Rt13094 T2162 T2189 10136619.865923468
Rt13095 T2163 T2164 3521186.8811882362
Rt13096 T2163 T2265 3543689.5337000713
Rt13097 T2163 T2329 26466474.585073948
Rt13098 T2164 T2207 4729725.6395263532
Rt13099 T2164 T2329 3229372.5596490321
Rt13100 T2164 T2616 2880131.2109510768
Rt13101 T2164 T2775 3579249.9101295425
Rt13102 T2164 T3657 3384829.100788957
Gcorr4366 T2164 T3902 T2164 T3902 -1.322768382956423e-07
Rt13103 T2165 T2348 4388870.7928790879
Rt13104 T2166 T2167 10735297.141405221
Rt13105 T2166 T2201 3733685.3024718268
Gcorr4367 T2166 T3845 T2166 T3845 -1.5088745785603464e-07
Rt13106 T2167 T2173 2458613.5405243556
Rt13107 T2167 T2201 4218961.3709962089
Rt13108 T2168 T2260 1375840.0512800943
Rt13109 T2169 T2383 5141174.6795846894
Rt13110 T2169 T2660 3036470.78543047
Rt13111 T2169 T2746 1755646.2101795052
Gcorr4368 T2169 T3813 T2169 T3813 -2.8898531729547418e-09
Gcorr4369 T2169 T4127 T2169 T4127 -1.1950959618839488e-07
Gcorr4370 T2169 T4169 T2169 T4169 -3.494371128120342e-08
Rt13112 T2170 T2181 1818751.2027066441
Rt13113 T2170 T2515 2075539.8707601049
Rt13114 T2170 T2779 659952.68751825381
Rt13115 T2170 T3237 20631025.853901498
Rt13116 T2170 T3238 24194587.150325682
Gcorr4371 T2170 T3796 T2170 T3796 -5.2850558631331583e-07
Rt13117 T2171 T2229 5032949.6745612845
Rt13118 T2171 T2295 1784639.0703484246
Gcorr4372 T2171 T3042 T2171 T3042 -5.2976696117949846e-07
Rt13119 T2172 T2216 4472814.1286369869
Rt13120 T2172 T2464 3482395.2491012644
Gcorr4373 T2172 T2859 T2172 T2859 -4.5421148992913298e-07
Rt13121 T2172 T3474 1827459.5971728067
Gcorr4374 T2172 T3476 T2172 T3476 -9.2506551731240031e-08
Rt13122 T2172 T3992 2196786.3780365982
Rt13123 T2173 T2845 12079410.648391122
Rt13124 T2173 T3773 18493115.962653436
Rt13125 T2174 T2175 9675176.6430632826
Rt13126 T2174 T2310 4603635.1597622167
Gcorr4375 T2174 T2891 T2174 T2891 -1.5016683621776038e-07
Rt13127 T2174 T3565 2446996.7502618465
Rt13128 T2174 T3762 8366189.0448224284
Rt13129 T2174 T4061 11948029.567315238
Rt13130 T2175 T2176 3886856.4835227705
Rt13131 T2175 T2177 14003838.09993455
Rt13132 T2175 T2310 3178820.1776301828
Rt13133 T2175 T2667 3276664.0728072478
Gcorr4376 T2175 T2893 T2175 T2893 -9.3740632703691925e-08
Rt13134 T2175 T2896 2121017.2908668965
Gcorr4377 T2175 T3219 T2175 T3219 -1.6186581468872666e-07
Rt13135 T2175 T3565 3762559.3370172
Rt13136 T2176 T2177 4703492.9516848484
Rt13137 T2176 T2218 3780439.7829816956
Rt13138 T2176 T2583 4054909.4258210445
Rt13139 T2176 T2651 8161577.8032254269
Rt13140 T2176 T2893 4325100.8143575843
Gcorr4378 T2176 T2894 T2176 T2894 -7.8994452969576431e-08
Rt13141 T2176 T2895 2281603.3796478831
Gcorr4379 T2176 T2896 T2176 T2896 -1.025189566096951e-07
Rt13142 T2177 T2286 15460101.992575314
Rt13143 T2177 T2528 3365678.8941891175
Rt13144 T2177 T2651 2582729.1301356512
Rt13145 T2177 T2667 3318020.2691197223
Gcorr4380 T2177 T2895 T2177 T2895 -1.1645401164549912e-07
Rt13146 T2177 T2896 4127519.0314442911
Rt13147 T2177 T2916 1476820.7262854027
Gcorr4381 T2177 T2984 T2177 T2984 -1.7617625419291818e-07
Rt13148 T2178 T2181 5032801.265844563
Rt13149 T2179 T2221 11216808.743235314
Rt13150 T2180 T2648 5925491.7475495283
Rt13151 T2180 T2666 2310314.7432756354
Gcorr4382 T2180 T3422 T2180 T3422 -6.8276283551714437e-10
Rt13152 T2180 T3423 1859322.0253678092
Gcorr4383 T2180 T3507 T2180 T3507 -8.2884086541176891e-08
Rt13153 T2181 T2515 5798994.7213172205
Rt13154 T2181 T2703 3195048.7015277338
Gcorr4384 T2181 T2779 T2181 T2779 -4.967783018493767e-07
Gcorr4385 T2181 T3795 T2181 T3795 -2.3148019418521841e-07
Rt13155 T2181 T3796 1124412.5209395534
Rt13156 T2182 T2197 10412452.537165724
Rt13157 T2182 T2214 4684429.3813364962
Rt13158 T2183 T2415 3952909.9289936451
Rt13159 T2183 T2512 3219218.4157827687
Gcorr4386 T2183 T2755 T2183 T2755 -1.3357782562417319e-07
Gcorr4387 T2183 T3505 T2183 T3505 -5.0555463081621832e-09
Rt13160 T2183 T3506 2955462.5499402029
Rt13161 T2183 T3865 2673491.9710645066
Gcorr4388 T2183 T4034 T2183 T4034 -1.2767549844485068e-07
Rt13162 T2184 T2229 5041392.8800038528
Rt13163 T2185 T2203 3931178.7099084868
Rt13164 T2186 T2212 1866932.6255242275
Rt13165 T2187 T2499 2069264.9764985992
Rt13166 T2187 T2588 1512508.8420667169
Rt13167 T2188 T2753 7861399.9699026737
Rt13168 T2188 T4189 11057982.785276387
Rt13169 T2190 T2639 3339237.4936882919
Gcorr4389 T2190 T2823 T2190 T2823 -1.9501639570847181e-07
Rt13170 T2190 T2849 9466463.6718218122
Rt13171 T2190 T2850 2210888.8642553715
Rt13172 T2190 T2851 10165618.359850518
Rt13173 T2191 T2255 3509772.8894970152
Rt13174 T2191 T2416 4605248.4377647312
Rt13175 T2191 T2732 5871131.559059171
Gcorr4390 T2191 T3123 T2191 T3123 -1.3421344332055862e-07
Rt13176 T2191 T3460 2938727.1751408451
Gcorr4391 T2191 T3996 T2191 T3996 -1.0941401944107059e-07
Rt13177 T2191 T4078 2808541.0803508749
Gcorr4392 T2192 T2306 T2192 T2306 -1.1306321564757466e-07
Rt13178 T2192 T2449 7916058.6279071616
Rt13179 T2192 T2653 10264108.710215099
Gcorr4393 T2192 T3084 T2192 T3084 -1.3042195142356498e-07
Rt13180 T2192 T3162 1202567.9807125065
Rt13181 T2192 T3809 476447.98692033935
Rt13182 T2192 T3837 1078960.7118940135
Rt13183 T2192 T4031 1038897.4346363064
Rt13184 T2193 T2194 5144955.4892805414
Rt13185 T2193 T2245 2793260.8734449646
Rt13186 T2194 T2245 3585145.027648238
Rt13187 T2194 T2594 5106028.437729341
Rt13188 T2194 T2628 2297368.8841043948
Gcorr4394 T2194 T2737 T2194 T2737 -1.2825946670889542e-08
Rt13189 T2195 T2454 5237384.586786774
Rt13190 T2195 T2789 3014476.1662233365
Gcorr4395 T2195 T3561 T2195 T3561 -1.2675892131675023e-07
Rt13191 T2195 T3742 12380435.880473845
Rt13192 T2195 T4039 5510812.0774694681
Rt13193 T2196 T2206 17636686.072135873
Rt13194 T2196 T2778 11025773.615739839
Rt13195 T2197 T2214 4648436.3240009444
Rt13196 T2198 T2254 4731727.1123067299
Rt13197 T2199 T2200 4575005.2164199324
Rt13198 T2199 T2486 10568514.759116339
Rt13199 T2199 T3389 5879923.7391398298
Rt13200 T2199 T3393 15946625.513533911
Rt13201 T2199 T3721 301976.30944988679
Gcorr4396 T2199 T4084 T2199 T4084 -3.0611797201101432e-06
Rt13202 T2200 T2486 1891160.1659883019
Rt13203 T2200 T2487 3366969.3196440199
Rt13204 T2200 T2690 6400971.7174825398
Rt13205 T2200 T3387 2166412.5874615037
Rt13206 T2200 T3388 22505082.035783641
Rt13207 T2200 T3389 3186209.6105391756
Gcorr4397 T2200 T3393 T2200 T3393 -1.0921898856060319e-07
Rt13208 T2201 T2400 10525380.547422215
Rt13209 T2202 T2401 3766495.0563627565
Rt13210 T2202 T2965 854009.98500273377
Gcorr4398 T2202 T3609 T2202 T3609 -3.2947607706401772e-09
Gcorr4399 T2202 T3698 T2202 T3698 -2.2258408284725422e-07
Gcorr4400 T2202 T3940 T2202 T3940 -1.6447077554386709e-07
Rt13211 T2202 T4023 9906371.2080767583
Rt13212 T2203 T2275 4579514.0927411001
Rt13213 T2204 T2479 3528825.0034609186
Rt13214 T2205 T2212 7752536.7787859403
Rt13215 T2206 T2344 3080729.7113591721
Rt13216 T2207 T2616 3188173.2030337215
Rt13217 T2207 T2775 16922396.421864841
Rt13218 T2207 T3764 3031022.0963460268
Gcorr4401 T2207 T3972 T2207 T3972 -1.2107891271522644e-07
Rt13219 T2208 T2605 3185905.4075976163
Rt13220 T2208 T2670 2549772.9634028692
Rt13221 T2208 T2690 1059637.5133082708
Rt13222 T2208 T3385 1952820.2338034553
Rt13223 T2208 T3386 5550379.5041671023
Gcorr4402 T2208 T3387 T2208 T3387 -4.2487479906556253e-07
Rt13224 T2208 T3783 1684913.9409334445
Gcorr4403 T2208 T4135 T2208 T4135 -1.3362729603140893e-07
Rt13225 T2209 T2213 28743080.245260235
Rt13226 T2209 T2391 6791435.0606879285
Rt13227 T2210 T2499 16987882.598508462
Rt13228 T2210 T2588 3177526.5329981521
Rt13229 T2211 T2655 2581149.5323431897
Rt13230 T2211 T2929 30670831.557233494
Gcorr4404 T2211 T3199 T2211 T3199 -1.518245318264147e-07
Rt13231 T2211 T3556 2601848.7797944639
Rt13232 T2211 T4088 3408320.0951061337
Rt13233 T2214 T2413 3192525.9055164121
Rt13234 T2215 T2223 4012383.3021619911
Gcorr4405 T2215 T2263 T2215 T2263 -6.0845078100520422e-08
Rt13235 T2215 T2398 3125286.0118698678
Gcorr4406 T2215 T2914 T2215 T2914 -1.896229586177396e-07
Rt13236 T2215 T2915 2298905.0601468589
Rt13237 T2215 T3010 1167852.9409306697
Rt13238 T2215 T3011 3020897.9567362396
Gcorr4407 T2215 T3139 T2215 T3139 -1.3576181656926863e-07
Rt13239 T2216 T2464 9784213.06585286
Rt13240 T2216 T2705 3371488.0882504261
Rt13241 T2216 T3476 2477951.3983178698
Gcorr4408 T2216 T3478 T2216 T3478 -1.296327900279314e-07
Rt13242 T2216 T3674 3924599.2631411888
Gcorr4409 T2216 T3992 T2216 T3992 -7.3909328862140497e-08
Rt13243 T2217 T2237 5400034.0518573765
Rt13244 T2217 T2320 855356.69465433527
Rt13245 T2218 T2583 21677433.841539752
Rt13246 T2218 T2892 3881766.4972395496
Gcorr4410 T2218 T2893 T2218 T2893 -8.031868122001665e-08
Rt13247 T2218 T2894 2472602.1168152876
Gcorr4411 T2218 T2901 T2218 T2901 -9.9485998924539322e-08
Rt13248 T2219 T2332 2650696.4527383307
Gcorr4412 T2219 T3459 T2219 T3459 -1.57643706125771e-07
Rt13249 T2219 T3546 7057435.9253020044
Rt13250 T2219 T3602 1411403.6648457129
Rt13251 T2219 T3603 13419341.810881285
Gcorr4413 T2219 T4041 T2219 T4041 -1.3591486011961239e-07
Rt13252 T2220 T2539 2492765.4012492816
Rt13253 T2220 T2619 13424345.755772797
Rt13254 T2220 T2951 12456407.500088314
Gcorr4414 T2220 T3198 T2220 T3198 -2.1699565685971122e-07
Rt13255 T2220 T3456 435170.21107838402
Rt13256 T2220 T4046 4045767.6519282735
Rt13257 T2221 T2296 12591531.535558186
Rt13258 T2222 T2664 67409807.818859249
Rt13259 T2222 T2694 3074232.5814316333
Rt13260 T2222 T3230 2748847.0051204935
Rt13261 T2222 T3472 10169606.016995799
Rt13262 T2222 T3841 7161657.0157431085
Rt13263 T2222 T3937 6883124.1446942538
Rt13264 T2223 T2231 8909927.9008824732
Rt13265 T2223 T2263 3071631.2855759631
Rt13266 T2223 T2513 2143008.7332513621
Rt13267 T2223 T2900 3040176.6030707909
Rt13268 T2223 T2914 3817056.4288457721
Rt13269 T2223 T2915 1787359.9547812319
Gcorr4415 T2223 T4020 T2223 T4020 -1.2175252847061344e-07
Gcorr4416 T2223 T4194 T2223 T4194 -2.303771599966909e-07
Rt13270 T2224 T2345 27701425.732923154
Rt13271 T2224 T2346 5776671.641424573
Rt13272 T2224 T2625 2883470.3971124529
Rt13273 T2224 T2701 3385086.5998155661
Rt13274 T2224 T3024 2558479.4671990476
Rt13275 T2224 T3036 2241236.4025627873
Rt13276 T2224 T3209 908260.09541972156
Gcorr4417 T2224 T3210 T2224 T3210 -3.0134069444330544e-07
Rt13277 T2225 T2553 2991661.1940697776
Rt13278 T2225 T2677 5406427.8843102511
Gcorr4418 T2225 T2853 T2225 T2853 -1.1444152793726326e-07
Rt13279 T2225 T3494 6724433.5392174888
Rt13280 T2225 T3789 10572781.071560433
Rt13281 T2225 T4152 2217791.9967432912
Gcorr4419 T2225 T4167 T2225 T4167 -6.4033541117662887e-08
Rt13282 T2226 T2451 622722.66455546371
Rt13283 T2226 T2919 2549337.8674708293
Gcorr4420 T2226 T2961 T2226 T2961 -8.9607026614597513e-07
Gcorr4421 T2226 T3022 T2226 T3022 -1.3254481730861466e-06
Rt13284 T2226 T3514 183608.94449225185
Gcorr4422 T2226 T4146 T2226 T4146 -4.0747651976714384e-07
Rt13285 T2227 T2228 8062788.0490672197
Rt13286 T2227 T2387 8218467.0083541637
Rt13287 T2227 T3432 498400.69988522056
Gcorr4423 T2227 T3684 T2227 T3684 -6.4440178239620361e-07
Gcorr4424 T2227 T3808 T2227 T3808 -4.6540147397706846e-07
Gcorr4425 T2227 T4185 T2227 T4185 -4.2891626427664234e-07
Rt13288 T2228 T2387 3263258.9992653215
Rt13289 T2228 T2577 1048816.476443799
Rt13290 T2228 T2578 2946145.2156205424
Rt13291 T2228 T2671 10502218.68096875
Gcorr4426 T2228 T3044 T2228 T3044 -4.3780148610136407e-07
Gcorr4427 T2228 T3164 T2228 T3164 -1.0684048174812766e-07
Rt13292 T2228 T3165 1000087.4979688358
Rt13293 T2228 T3432 20030474.47581584
Rt13294 T2229 T2295 11228148.040218381
Rt13295 T2230 T2231 4336721.2035358297
Rt13296 T2230 T2360 12705590.685704373
Rt13297 T2230 T2441 3841173.0914912852
Rt13298 T2230 T2869 7180698.6452542804
Rt13299 T2230 T2870 6438440.9532589875
Rt13300 T2230 T2871 5930944.5350032104
Rt13301 T2231 T2360 3498843.6476706001
Gcorr4428 T2231 T2870 T2231 T2870 -1.8465845135037593e-07
Rt13302 T2231 T2871 20222028.031097282
Rt13303 T2231 T2879 1100447.7080276276
Rt13304 T2231 T2880 20310945.925823927
Gcorr4429 T2231 T2900 T2231 T2900 -1.5105350407855942e-07
Rt13305 T2231 T2914 76652720.420416623
Rt13306 T2231 T4042 12020918.705141269
Rt13307 T2232 T2426 13623593.815310162
Gcorr4430 T2232 T2825 T2232 T2825 -4.6723914118310772e-07
Rt13308 T2232 T3741 3845676.2819791939
Rt13309 T2233 T2234 3901793.6168830697
Rt13310 T2233 T2324 1137313.4629342314
Gcorr4431 T2233 T2769 T2233 T2769 -1.8903623165541969e-07
Gcorr4432 T2233 T3200 T2233 T3200 -6.7499347567634484e-07
Rt13311 T2233 T3652 8363474.3472534288
Rt13312 T2233 T3903 831613.42182249681
Rt13313 T2234 T2263 3146315.3317262875
Rt13314 T2234 T2324 7594865.3542923015
Rt13315 T2234 T2634 2355833.5703333085
Gcorr4433 T2234 T3015 T2234 T3015 -3.6036486276290774e-08
Rt13316 T2234 T3200 2743003.613425422
Rt13317 T2234 T3327 5727545.9487925163
Gcorr4434 T2234 T3903 T2234 T3903 -7.1902267039138342e-08
Rt13318 T2235 T2308 5115389.0792644219
Rt13319 T2236 T2434 1602876.7663226314
Rt13320 T2236 T2562 6264190.7538749846
Rt13321 T2238 T2631 3069666.9620490028
Rt13322 T2238 T2730 2277018.2932280381
Rt13323 T2238 T2741 6828318.7395343939
Gcorr4435 T2238 T3885 T2238 T3885 -2.2630057956409273e-08
Rt13324 T2239 T2524 3706009.4361176654
Rt13325 T2239 T2608 2941739.6751907477
Rt13326 T2239 T3379 5067003.4467725791
Rt13327 T2239 T3381 6354963.0189330801
Rt13328 T2239 T3464 6172117.609891491
Rt13329 T2239 T4110 8116701.5231140712
Rt13330 T2240 T2613 3296622.0744560757
Gcorr4436 T2240 T2865 T2240 T2865 -1.0356330955890651e-07
Rt13331 T2240 T2866 2756119.6357586347
Rt13332 T2240 T2867 3577262.5501310728
Gcorr4437 T2240 T2873 T2240 T2873 -8.051234625846154e-08
Rt13333 T2241 T2724 3726431.0161183462
Rt13334 T2241 T3163 12794526.125523787
Rt13335 T2241 T3697 4297111.4603184862
Rt13336 T2241 T4161 6555390.9522545272
Rt13337 T2242 T2565 2657007.499407033
Rt13338 T2242 T3176 2060179.7635727485
Rt13339 T2242 T3470 3498244.9982066988
Rt13340 T2242 T3504 1875018.137859154
Gcorr4438 T2242 T3743 T2242 T3743 -3.1315010652122907e-07
Gcorr4439 T2242 T3847 T2242 T3847 -8.8632810626098044e-08
Rt13341 T2243 T2710 4532709.4089365071
Gcorr4440 T2243 T3292 T2243 T3292 -1.0134104802924127e-07
Rt13342 T2243 T3293 915504.48076113104
Rt13343 T2243 T3295 5242544.9105539946
Gcorr4441 T2243 T3296 T2243 T3296 -1.3916535481178465e-07
Rt13344 T2244 T2501 404722.20851048763
Gcorr4442 T2244 T2886 T2244 T2886 -1.9559389577613487e-06
Rt13345 T2244 T3642 491948.70653173915
Rt13346 T2245 T2349 3826216.5701872464
Rt13347 T2246 T2274 5704191.9703173963
Rt13348 T2247 T2554 2231790.826906627
Rt13349 T2247 T2673 2015758.2797729829
Gcorr4443 T2247 T3418 T2247 T3418 -4.9985426819086568e-08
Rt13350 T2247 T3420 1291635.3885009564
Gcorr4444 T2247 T3458 T2247 T3458 -4.097221844364747e-08
Rt13351 T2247 T3463 5255895.8028870644
Gcorr4445 T2247 T3952 T2247 T3952 -4.6623374220722909e-08
Rt13352 T2248 T2324 3431639.8936597933
Rt13353 T2248 T2768 5025426.9448456634
Rt13354 T2248 T3356 3584657.4487174591
Rt13355 T2248 T3468 4349228.8407402895
Gcorr4446 T2248 T3619 T2248 T3619 -1.1268107772273919e-07
Gcorr4447 T2248 T4114 T2248 T4114 -1.0828623677187021e-07
Rt13356 T2249 T2272 12179491.073455593
Gcorr4448 T2249 T2888 T2249 T2888 -4.5422466023779128e-07
Rt13357 T2250 T2505 1768937.9973401842
Rt13358 T2250 T2573 44748110.464530766
Rt13359 T2250 T2584 2061459.2771892634
Rt13360 T2250 T2607 9040913.7818344254
Gcorr4449 T2250 T3481 T2250 T3481 -5.3128163018754894e-07
Rt13361 T2250 T3482 9141188.2889595721
Gcorr4450 T2250 T3484 T2250 T3484 -2.906766015723602e-08
Rt13362 T2250 T3585 708588.01390353346
Rt13363 T2250 T4092 48685274.065983318
Rt13364 T2251 T2283 4867103.0426507955
Rt13365 T2251 T2359 4101697.958853269
Rt13366 T2251 T2766 858581.89641470648
Gcorr4451 T2251 T3467 T2251 T3467 -1.9058572583012293e-07
Gcorr4452 T2251 T3557 T2251 T3557 -4.963286259872604e-07
Gcorr4453 T2251 T3655 T2251 T3655 -1.8130512033661304e-07
Rt13367 T2251 T3811 6974863.4247514745
Rt13368 T2252 T2488 2587813.4811663409
Rt13369 T2252 T2585 1284002.9198883926
Rt13370 T2252 T3279 2837246.8887783587
Rt13371 T2252 T3280 12964274.559450703
Rt13372 T2252 T3281 849654.70352219185
Gcorr4454 T2252 T4006 T2252 T4006 -5.1535020886330739e-07
Rt13373 T2253 T2490 4161648.4088645284
Rt13374 T2253 T2661 2714314.881908752
Gcorr4455 T2253 T3070 T2253 T3070 -6.3364400035994613e-07
Gcorr4456 T2253 T3397 T2253 T3397 -9.3674131492569553e-07
Rt13375 T2253 T3726 1348049.2361048907
Rt13376 T2253 T3727 3168600.8209719481
Rt13377 T2253 T4112 383770.92893479666
Rt13378 T2254 T2501 6670185.4341796301
Gcorr4457 T2254 T3756 T2254 T3756 -1.5290813284191773e-07
Rt13379 T2255 T2416 11780740.922412502
Rt13380 T2255 T2557 3203939.5635066475
Rt13381 T2255 T3123 3338436.3969666115
Gcorr4458 T2255 T3202 T2255 T3202 -1.2340649181316827e-07
Rt13382 T2255 T3358 2303603.6484734146
Gcorr4459 T2255 T3460 T2255 T3460 -9.6945669523006228e-08
Rt13383 T2256 T2257 11180546.289679285
Rt13384 T2256 T2285 4092739.5677357204
Rt13385 T2256 T3287 17364178.799879242
Rt13386 T2256 T3577 2439484.5027856193
Gcorr4460 T2256 T3898 T2256 T3898 -5.2887652733188626e-07
Rt13387 T2256 T4054 1894495.7682029344
Rt13388 T2257 T2285 3269951.8691321691
Rt13389 T2257 T2489 2666165.2605983769
Rt13390 T2257 T3064 24303379.09106186
Rt13391 T2257 T3287 2411487.8792963917
Rt13392 T2257 T4168 6687120.2158881119
Rt13393 T2258 T2638 2926184.4154693759
Rt13394 T2258 T3328 2737518.7253970373
Rt13395 T2258 T3995 5581110.3678362602
Gcorr4461 T2258 T4149 T2258 T4149 -3.0420519834151456e-08
Rt13396 T2259 T2644 3302723.3185124346
Gcorr4462 T2260 T2267 T2260 T2267 -7.9023569681043902e-09
Rt13397 T2261 T2796 212148.21576588979
Gcorr4463 T2261 T3978 T2261 T3978 -4.5657713040768008e-07
Rt13398 T2261 T3979 2576393.4744487875
Rt13399 T2261 T4066 1521617.090809735
Rt13400 T2262 T2309 9566854.7396603115
Rt13401 T2262 T2391 31090787.314834747
Rt13402 T2263 T2513 1811438.1984718477
Gcorr4464 T2263 T2634 T2263 T2634 -2.6362782410985871e-08
Gcorr4465 T2263 T2915 T2263 T2915 -9.6645343893426851e-08
Rt13403 T2263 T3015 15478578.956780426
Rt13404 T2263 T3327 12746250.041088013
Gcorr4466 T2263 T4020 T2263 T4020 -4.1825867023932692e-07
Rt13405 T2263 T4194 756073.26508199517
Rt13406 T2264 T2463 3343115.8602379435
Rt13407 T2264 T2568 1083250.2852141568
Gcorr4467 T2264 T3461 T2264 T3461 -4.839280954862023e-07
Rt13408 T2264 T3462 281361.19715741999
Gcorr4468 T2264 T4150 T2264 T4150 -4.5006319617460763e-07
Rt13409 T2265 T2329 12673005.444740159
Rt13410 T2265 T2567 2796638.7026276528
Gcorr4469 T2265 T4118 T2265 T4118 -1.01918893042096e-07
Rt13411 T2266 T2297 16312245.902828446
Rt13412 T2266 T2342 10877170.612782201
Rt13413 T2266 T2616 2861232.1389496354
Rt13414 T2266 T3326 2010448.114867354
Gcorr4470 T2266 T3902 T2266 T3902 -9.1652929367059452e-08
Rt13415 T2266 T3972 10178083.683012433
Rt13416 T2266 T4018 11365054.333624195
Rt13417 T2267 T3597 2629638.3777995012
Gcorr4471 T2267 T3913 T2267 T3913 -8.2998694861297752e-08
Rt13418 T2268 T2671 3174085.8533371696
Gcorr4472 T2268 T3324 T2268 T3324 -1.3662776684653195e-07
Rt13419 T2268 T3614 2132869.8161478103
Rt13420 T2268 T3684 45372130.644025043
Rt13421 T2268 T3736 11325191.619109498
Rt13422 T2269 T2342 1302538.184180883
Rt13423 T2269 T2480 2369818.1792430342
Rt13424 T2269 T2675 1470677.5316623265
Gcorr4473 T2269 T2913 T2269 T2913 -1.5025343072951916e-07
Rt13425 T2269 T3005 5104283.3666247614
Rt13426 T2269 T3006 349588.90666819393
Gcorr4474 T2269 T3017 T2269 T3017 -4.398273726473068e-07
Gcorr4475 T2269 T3018 T2269 T3018 -4.4989949767602054e-07
Gcorr4476 T2269 T3136 T2269 T3136 -1.5064224447631523e-07
Gcorr4477 T2269 T3938 T2269 T3938 -4.9011057277082581e-07
Rt13427 T2270 T2317 2146849.9641767764
Rt13428 T2270 T2318 25180361.309782926
Rt13429 T2270 T2435 4757633.3665622966
Rt13430 T2270 T2945 6169799.9797723563
Gcorr4478 T2270 T3223 T2270 T3223 -4.0935301777250933e-07
Rt13431 T2270 T3487 2405671.8099986115
Rt13432 T2270 T3688 600624.69444229139
Rt13433 T2271 T2358 95570001.469209701
Rt13434 T2271 T2432 2545394.9958324539
Gcorr4479 T2271 T2646 T2271 T2646 -7.9379472449715577e-09
Rt13435 T2271 T2857 1827835.7474493592
Rt13436 T2271 T3777 227793.14577215124
Rt13437 T2271 T3886 6957994.5644237362
Rt13438 T2272 T2730 2925497.9734091815
Gcorr4480 T2272 T2888 T2272 T2888 -4.5328088447390659e-07
Rt13439 T2272 T3531 2885715.4378609392
Gcorr4481 T2273 T2491 T2273 T2491 -4.2954762573483445e-08
Rt13440 T2273 T2492 3747184.0079608099
Gcorr4482 T2273 T2813 T2273 T2813 -1.2379494236723667e-07
Rt13441 T2273 T3038 756700.43510416406
Rt13442 T2273 T3731 4052551.6363660786
Rt13443 T2273 T4032 4346077.1928785965
Rt13444 T2274 T2495 3733059.2817691891
Rt13445 T2275 T2333 10321116.355233291
Gcorr4483 T2276 T2369 T2276 T2369 -9.0363384285522673e-10
Rt13446 T2276 T2654 1521299.1807955015
Rt13447 T2276 T2834 1928931.0836328927
Rt13448 T2276 T3359 11345224.95204776
Gcorr4484 T2276 T3607 T2276 T3607 -4.8700308644331008e-07
Gcorr4485 T2276 T3805 T2276 T3805 -1.4058844407883458e-07
Rt13449 T2276 T3959 2036107.2915412893
Gcorr4486 T2277 T2507 T2277 T2507 -3.5055389309293128e-08
Rt13450 T2277 T2532 2653015.5543980547
Gcorr4487 T2277 T3347 T2277 T3347 -1.37592873489371e-07
Rt13451 T2277 T3349 2213503.9727231967
Gcorr4488 T2277 T3493 T2277 T3493 -5.8891512921059946e-09
Rt13452 T2277 T4155 3474397.7883200976
Rt13453 T2278 T2279 11886107.384702509
Rt13454 T2278 T2645 1985876.4361480891
Gcorr4489 T2278 T3256 T2278 T3256 -4.121788309559461e-07
Gcorr4490 T2278 T3260 T2278 T3260 -1.5521769654302604e-07
Rt13455 T2278 T3699 790776.23238791153
Gcorr4491 T2278 T4002 T2278 T4002 -1.4891388038351851e-07
Gcorr4492 T2278 T4081 T2278 T4081 -1.0754994186495989e-07
Rt13456 T2279 T2382 3249904.9844307103
Rt13457 T2279 T2645 995291.78262077633
Rt13458 T2279 T2792 25480018.399602205
Gcorr4493 T2279 T3345 T2279 T3345 -6.3217595805262911e-07
Gcorr4494 T2279 T3797 T2279 T3797 -2.1946205393722567e-07
Rt13459 T2279 T3827 1824184.4217672662
Rt13460 T2279 T4002 1362658.0035367245
Rt13461 T2280 T2615 12222197.187250232
Gcorr4495 T2280 T2680 T2280 T2680 -6.8979480336491031e-08
Gcorr4496 T2280 T2933 T2280 T2933 -3.0774593451457353e-09
Rt13462 T2280 T2998 560271.32144746673
Rt13463 T2280 T3157 5219161.5706482865
Rt13464 T2280 T3748 2316870.2935991501
Rt13465 T2281 T2630 10656374.217091406
Rt13466 T2281 T2648 4542611.9564492125
Rt13467 T2281 T3087 6589648.2203746475
Rt13468 T2281 T3794 3284637.9147101687
Gcorr4497 T2281 T3983 T2281 T3983 -2.9344652633515201e-07
Rt13469 T2281 T4147 10708672.81684356
Rt13470 T2281 T4197 4738806.217853724
Rt13471 T2282 T2489 11097130.552810613
Rt13472 T2282 T2622 4018437.6388325435
Rt13473 T2282 T3168 2614876.159417165
Gcorr4498 T2282 T3527 T2282 T3527 -1.1161223732200407e-07
Rt13474 T2282 T3540 3058648.1194539368
Gcorr4499 T2282 T3749 T2282 T3749 -1.3035526513059722e-07
Rt13475 T2283 T2359 9416160.258553803
Rt13476 T2283 T2686 3266687.0450457931
Rt13477 T2283 T3204 2017039.9709501918
Gcorr4500 T2283 T3594 T2283 T3594 -4.6803337902330592e-07
Rt13478 T2283 T3655 4837785.7499502795
Rt13479 T2283 T3811 5180395.4103408484
Rt13480 T2284 T2316 8326592.8547154441
Rt13481 T2284 T2502 10737534.586441413
Rt13482 T2284 T2604 3626337.1738350056
Rt13483 T2284 T3225 27307013.672185946
Rt13484 T2284 T3497 2612673.5624797791
Gcorr4501 T2284 T3498 T2284 T3498 -1.0718191478420087e-06
Rt13485 T2284 T3555 892749.05732015276
Rt13486 T2285 T2715 6373288.7095019426
Rt13487 T2285 T3287 191467423.62683725
Gcorr4502 T2285 T3535 T2285 T3535 -1.798832400838616e-07
Rt13488 T2285 T3536 1849993.3782698011
Rt13489 T2285 T3577 6077615.5562878754
Gcorr4503 T2285 T4168 T2285 T4168 -5.2544827258525109e-08
Rt13490 T2286 T2287 4209290.0217746105
Rt13491 T2286 T2528 5996389.5825006608
Gcorr4504 T2286 T2651 T2286 T2651 -6.5232861760089513e-08
Rt13492 T2286 T2916 5543850.5297228424
Rt13493 T2286 T3020 2003220.4163547496
Rt13494 T2286 T3054 2469038.2484290861
Rt13495 T2286 T3169 2506640.9518158683
Gcorr4505 T2287 T2288 T2287 T2288 -3.9284800584763211e-08
Rt13496 T2287 T3054 2372614.9298775219
Rt13497 T2287 T3169 10768588.816713104
Rt13498 T2287 T3170 888797.04880645394
Rt13499 T2287 T3689 4632036.1813222561
Rt13500 T2288 T2541 46493141.156154484
Rt13501 T2288 T3170 1307770.0701046609
Gcorr4506 T2288 T3690 T2288 T3690 -6.3409611805869652e-07
Rt13502 T2288 T3753 414628.15366967709
Rt13503 T2288 T3924 1261113.3000967456
Rt13504 T2289 T2392 2942408.8920229161
Rt13505 T2289 T2494 3338909.4642921411
Rt13506 T2289 T2679 5273334.0375622166
Rt13507 T2289 T3082 2382086.4506104141
Gcorr4507 T2289 T3171 T2289 T3171 -5.3579861361027815e-08
Rt13508 T2289 T3371 459590.44876290509
Gcorr4508 T2289 T3824 T2289 T3824 -7.6078597624918842e-08
Gcorr4509 T2289 T4011 T2289 T4011 -7.8097669283925418e-07
Rt13509 T2290 T2291 5926721.24200847
Rt13510 T2290 T2618 7988247.5782352919
Rt13511 T2290 T3612 5185774.8117973413
Rt13512 T2290 T3679 12090494.630336042
Rt13513 T2290 T3957 3188726.6804384943
Gcorr4510 T2290 T4068 T2290 T4068 -1.0652135794719465e-07
Rt13514 T2291 T2292 3476747.7489377293
Rt13515 T2291 T2612 18427213.780754857
Rt13516 T2291 T2618 2373637.939627992
Gcorr4511 T2291 T3427 T2291 T3427 -7.4554304047554193e-07
Gcorr4512 T2291 T3612 T2291 T3612 -1.6285872625699149e-07
Rt13517 T2291 T3678 635847.00315083179
Rt13518 T2291 T3679 8571043.3815621678
Rt13519 T2292 T2322 9273858.8736760616
Rt13520 T2292 T2612 1181219.7178887166
Gcorr4513 T2292 T3369 T2292 T3369 -3.1665631588167898e-07
Rt13521 T2292 T3427 4053258.1918075085
Rt13522 T2292 T3678 36336497.720528416
Rt13523 T2292 T3825 823177.12199741264
Rt13524 T2293 T2294 3426333.8879952114
Rt13525 T2293 T2471 8858620.4317375515
Rt13526 T2293 T3346 2247795.3522137939
Gcorr4514 T2293 T3347 T2293 T3347 -1.2961856378364849e-07
Rt13527 T2293 T3910 6405825.5757428873
Rt13528 T2294 T2471 2710822.5653810441
Rt13529 T2294 T2532 3528359.3394256472
Rt13530 T2294 T2697 2731710.5616463674
Rt13531 T2294 T3274 1885065.0302206308
Gcorr4515 T2294 T3346 T2294 T3346 -1.4452138089537021e-07
Rt13532 T2294 T3347 3457733.8915720996
Gcorr4516 T2294 T3348 T2294 T3348 -1.0852768645470717e-07
Rt13533 T2295 T2395 3768588.1935091605
Rt13534 T2295 T3042 1323127.2849886229
Gcorr4517 T2295 T3445 T2295 T3445 -1.6642153516285269e-07
Rt13535 T2295 T3880 6108195.1311523141
Rt13536 T2296 T2355 8712576.6146150939
Rt13537 T2297 T2342 3537453.1306318752
Rt13538 T2297 T2899 2143710.7605581298
Gcorr4518 T2297 T2913 T2297 T2913 -1.3218610503559132e-07
Gcorr4519 T2297 T3595 T2297 T3595 -1.4112041592455433e-07
Rt13539 T2297 T4018 2012083.9033348211
Rt13540 T2298 T2446 12590231.205919689
Rt13541 T2298 T2721 3438058.1384313749
Rt13542 T2298 T3633 9083414.9865328092
Rt13543 T2298 T3635 5312259.2465756517
Rt13544 T2298 T3639 6659335.9185526669
Rt13545 T2299 T2496 3703636.1965081715
Rt13546 T2299 T3075 3146140.6343891569
Rt13547 T2299 T3077 7355936.9606228778
Gcorr4520 T2299 T3750 T2299 T3750 -1.5106526798920653e-07
Rt13548 T2299 T3868 4864794.7577897003
Rt13549 T2300 T2706 3058465.969393109
Gcorr4521 T2300 T3768 T2300 T3768 -4.1062442044767894e-07
Gcorr4522 T2300 T3769 T2300 T3769 -3.6254383187355333e-07
Rt13550 T2300 T3770 497699.22863391886
Gcorr4523 T2300 T3772 T2300 T3772 -1.2467397498665622e-07
Gcorr4524 T2300 T4137 T2300 T4137 -6.054306126442966e-07
Gcorr4525 T2301 T2328 T2301 T2328 -7.9396415395791433e-09
Rt13551 T2301 T2493 2670835.0332773468
Rt13552 T2301 T2953 896803.77717058058
Gcorr4526 T2301 T2979 T2301 T2979 -6.6061051619455151e-08
Rt13553 T2301 T3009 2036471.0398146261
Rt13554 T2301 T4181 4712193.4936820418
Rt13555 T2302 T2303 2769929.8426309493
Rt13556 T2302 T2543 2380480.0891104974
Gcorr4527 T2302 T3553 T2302 T3553 -4.9865188981112558e-07
Rt13557 T2302 T3554 4620856.9072364904
Gcorr4528 T2302 T3954 T2302 T3954 -5.635390769715945e-07
Rt13558 T2302 T4138 648232.97048479051
Gcorr4529 T2302 T4160 T2302 T4160 -2.1828084366853987e-07
Rt13559 T2303 T2304 3883317.7961801542
Rt13560 T2303 T2543 2804392.8268660675
Rt13561 T2303 T2936 34547507.593199126
Rt13562 T2303 T3112 1514606.2282472712
Rt13563 T2303 T3553 2734126.0463503976
Rt13564 T2303 T3554 7258950.9840847841
Gcorr4530 T2303 T4024 T2303 T4024 -6.0372595152707236e-08
Gcorr4531 T2303 T4138 T2303 T4138 -2.9099265843594075e-07
Rt13565 T2304 T2305 20416304.575753398
Rt13566 T2304 T2510 1822203.8152914194
Gcorr4532 T2304 T2936 T2304 T2936 -2.8053689860374806e-07
Rt13567 T2304 T3000 855628.64543301263
Rt13568 T2304 T3112 1968875.9620922501
Rt13569 T2304 T3113 6039603.6927550128
Gcorr4533 T2304 T4123 T2304 T4123 -2.8575129220804972e-07
Rt13570 T2305 T2306 4906339.3005631529
Rt13571 T2305 T2529 13708331.512446916
Gcorr4534 T2305 T2936 T2305 T2936 -4.1411685524922137e-07
Rt13572 T2305 T2999 787045.10375437466
Rt13573 T2305 T3000 1156409.5120512175
Gcorr4535 T2305 T3162 T2305 T3162 -3.008104002379013e-07
Rt13574 T2305 T3925 1728849.3185901728
Rt13575 T2306 T2561 115999462.78743699
Gcorr4536 T2306 T3114 T2306 T3114 -6.0063923795718921e-07
Rt13576 T2306 T3162 1508185.3813705617
Rt13577 T2306 T3576 1065892.2661603489
Rt13578 T2306 T3925 604001.97990981815
Rt13579 T2306 T4031 1568788.9189570888
Rt13580 T2307 T3441 6942850.9022987345
Gcorr4537 T2307 T3711 T2307 T3711 -1.8077537951599171e-08
Rt13581 T2307 T3899 4174660.2221929072
Rt13582 T2307 T4024 2985518.9892005748
Gcorr4538 T2307 T4123 T2307 T4123 -2.9507409064673938e-07
Rt13583 T2308 T2689 1801266.4764185143
Rt13584 T2310 T2667 6243162.0038193818
Rt13585 T2310 T3219 1103306.0357832983
Gcorr4539 T2310 T3565 T2310 T3565 -1.1594393647385702e-07
Gcorr4540 T2310 T4013 T2310 T4013 -8.8804575270510944e-08
Gcorr4541 T2310 T4061 T2310 T4061 -1.2888921667482278e-07
Rt13586 T2311 T2397 5165366.6428844687
Rt13587 T2311 T2765 12818684.745098816
Rt13588 T2311 T3623 82331541.513210133
Rt13589 T2312 T2380 60373615.241719894
Rt13590 T2312 T2838 2817367.9634240554
Gcorr4542 T2312 T3398 T2312 T3398 -4.5769215088834913e-07
Rt13591 T2313 T2333 4194040.1759919631
Rt13592 T2313 T2371 4371940.0016344888
Rt13593 T2314 T2315 6067090.0907958699
Rt13594 T2314 T2645 2682721.3526443117
Rt13595 T2314 T3268 7359433.3033004533
Rt13596 T2314 T3344 4022349.5670295367
Rt13597 T2314 T3345 747753.19004603592
Gcorr4543 T2314 T3827 T2314 T3827 -1.172579871067637e-06
Rt13598 T2314 T4144 9163910.3722262476
Rt13599 T2315 T2647 3240337.3170478242
Rt13600 T2315 T2717 1384769.8091283047
Gcorr4544 T2315 T3262 T2315 T3262 -2.6468050740590179e-07
Rt13601 T2315 T3267 3181823.3239304028
Rt13602 T2315 T3268 3966231.8423225256
Rt13603 T2315 T4144 2016721.4766367907
Rt13604 T2316 T2317 10276722.174237907
Rt13605 T2316 T2604 5770313.4400419584
Rt13606 T2316 T3225 1009700.6854262665
Gcorr4545 T2316 T3751 T2316 T3751 -4.6050715382961994e-07
Rt13607 T2317 T2318 1654199.8737278422
Rt13608 T2317 T2604 1242015.8146903412
Gcorr4546 T2317 T3194 T2317 T3194 -4.3771450507092578e-07
Rt13609 T2317 T3223 359090.86769144447
Gcorr4547 T2317 T3225 T2317 T3225 -1.7429564552853246e-07
Gcorr4548 T2317 T3688 T2317 T3688 -5.8824122955697169e-07
Gcorr4549 T2317 T3948 T2317 T3948 -5.3128244332090918e-07
Rt13610 T2318 T2435 18097288.806971557
Rt13611 T2318 T2438 23403139.920768194
Rt13612 T2318 T2520 813618.47257153329
Gcorr4550 T2318 T3193 T2318 T3193 -7.47867504930973e-07
Rt13613 T2318 T3194 473832.36710991198
Rt13614 T2318 T3206 1583015.4933886237
Gcorr4551 T2318 T3223 T2318 T3223 -4.8684147676070519e-07
Rt13615 T2318 T3688 1912945.5289503587
Rt13616 T2319 T2370 1521441.5047537137
Rt13617 T2319 T2521 4889038.7162041226
Rt13618 T2319 T2714 2775924.4425208219
Rt13619 T2319 T2941 1791616.0841829523
Rt13620 T2319 T2986 709167.42571442644
Rt13621 T2319 T3013 10281123.255786823
Rt13622 T2320 T2330 1725583.3345483851
Gcorr4552 T2321 T2366 T2321 T2366 -2.1950178562861015e-08
Rt13623 T2321 T2884 13809610.342688777
Rt13624 T2321 T3631 18127016.927856617
Rt13625 T2322 T2472 4070073.1969990893
Gcorr4553 T2322 T2964 T2322 T2964 -1.5889434123365418e-07
Gcorr4554 T2322 T3367 T2322 T3367 -9.9245075236830565e-08
Rt13626 T2322 T3500 923370.54638982855
Rt13627 T2322 T3825 1793550.3912230108
Gcorr4555 T2322 T4190 T2322 T4190 -9.9700745916844346e-08
Rt13628 T2323 T2608 2248301.498177805
Rt13629 T2323 T2620 3007900.4103789558
Rt13630 T2323 T3222 1510555.460657916
Gcorr4556 T2323 T3464 T2323 T3464 -1.2695839515201332e-07
Rt13631 T2323 T3465 9149597.4239763264
Rt13632 T2323 T4045 175883958.78549179
Gcorr4557 T2324 T2634 T2324 T2634 -2.6973422083155856e-08
Rt13633 T2324 T3200 1045064.4098256162
Gcorr4558 T2324 T3356 T2324 T3356 -1.1823295188755297e-07
Rt13634 T2324 T3468 3540075.7023569103
Gcorr4559 T2324 T3652 T2324 T3652 -1.2597385435859543e-07
Gcorr4560 T2324 T3903 T2324 T3903 -5.2012362007332513e-07
Rt13635 T2325 T2326 4482543.4971459564
Rt13636 T2325 T2392 9326829.6660450865
Rt13637 T2325 T2639 23988488.571036797
Rt13638 T2325 T3791 4164782.5440750676
Gcorr4561 T2325 T4027 T2325 T4027 -5.9126349768843427e-08
Gcorr4562 T2325 T4038 T2325 T4038 -7.9185754436531452e-08
Rt13639 T2325 T4077 1395835.0210047078
Rt13640 T2326 T2392 1434814.5234845967
Rt13641 T2326 T2889 12425236.343964651
Rt13642 T2326 T2943 946461.20000236284
Gcorr4563 T2326 T3824 T2326 T3824 -4.5825901106884693e-07
Rt13643 T2326 T4038 3189707.6690903073
Rt13644 T2326 T4077 6744691.679240589
Rt13645 T2327 T2328 14562004.085553093
Rt13646 T2327 T2603 6521491.1908680638
Rt13647 T2327 T3197 8866397.3139787614
Gcorr4564 T2327 T3524 T2327 T3524 -7.657059951728093e-07
Gcorr4565 T2327 T3779 T2327 T3779 -4.1216707107091728e-07
Rt13648 T2327 T3831 599917.52527989168
Rt13649 T2328 T2603 3913861.784649461
Rt13650 T2328 T2909 3434907.3074284829
Rt13651 T2328 T2953 3338685.7539447895
Rt13652 T2328 T2954 1849911.7478670154
Gcorr4566 T2328 T3779 T2328 T3779 -3.5848449499437381e-07
Rt13653 T2328 T3831 4564851.5988030229
Rt13654 T2329 T3488 7336116.5057152789
Rt13655 T2329 T3657 5519267.4900476243
Rt13656 T2329 T4118 9202148.2087331899
Rt13657 T2330 T2379 9896679.3301598262
Rt13658 T2331 T2351 8348302.3203957863
Rt13659 T2331 T2448 4395600.4839753928
Rt13660 T2331 T2799 10510177.983061861
Rt13661 T2331 T3816 29726327.975759506
Rt13662 T2332 T2553 8866463.1669470463
Rt13663 T2332 T2554 1921286.7279932287
Gcorr4567 T2332 T3458 T2332 T3458 -1.1722504476351799e-07
Rt13664 T2332 T3459 1321925.0618361516
Gcorr4568 T2332 T3602 T2332 T3602 -1.0360248132553456e-07
Gcorr4569 T2332 T3761 T2332 T3761 -2.9646294049345702e-08
Rt13665 T2334 T2439 4388367.2393527729
Rt13666 T2334 T2571 16009996.213089503
Rt13667 T2334 T2572 2485423.2283482119
Rt13668 T2334 T2635 27862784.463077705
Gcorr4570 T2334 T2932 T2334 T2932 -2.0836007391698505e-06
Rt13669 T2334 T3130 1531074079.5942371
Rt13670 T2334 T3454 19554453.641944818
Rt13671 T2334 T3945 2736936.4159123623
Rt13672 T2334 T3946 274691.27948803804
Rt13673 T2335 T2660 2632133.4257080117
Gcorr4571 T2335 T3125 T2335 T3125 -1.977328362133302e-07
Rt13674 T2335 T3332 1332353.7651267215
Gcorr4572 T2335 T3491 T2335 T3491 -1.1997267844862773e-08
Gcorr4573 T2335 T3901 T2335 T3901 -4.047123226754159e-08
Rt13675 T2336 T2337 11616090.799415659
Rt13676 T2336 T2508 5763038.869907001
Rt13677 T2336 T2644 5201631.9111998016
Rt13678 T2337 T2564 3196700.0838794764
Rt13679 T2337 T2644 1593164.5569487484
Gcorr4574 T2337 T4071 T2337 T4071 -1.3227583181688793e-07
Rt13680 T2338 T3301 10043297.045597123
Rt13681 T2338 T3303 2423405.7723977147
Gcorr4575 T2338 T3308 T2338 T3308 -5.8199472269035659e-08
Rt13682 T2338 T4165 3015403.0100086224
Rt13683 T2339 T2602 4665602.4448847473
Gcorr4576 T2339 T3090 T2339 T3090 -3.5996557124593045e-07
Rt13684 T2339 T3092 3810902.6851823153
Rt13685 T2339 T3425 25724981.90097427
Rt13686 T2339 T4151 2146351.3082243018
Gcorr4577 T2340 T2396 T2340 T2396 -3.8210922333260023e-08
Rt13687 T2340 T2904 795934.34824702353
Rt13688 T2340 T2937 1261150.6917930876
Rt13689 T2340 T2938 626938.13485300192
Gcorr4578 T2340 T2939 T2340 T2939 -6.9210615142810208e-08
Gcorr4579 T2341 T3105 T2341 T3105 -8.3419526737132662e-08
Gcorr4580 T2341 T3107 T2341 T3107 -6.3813418256923948e-07
Rt13690 T2341 T3283 554771.2683128583
Gcorr4581 T2341 T3435 T2341 T3435 -1.1172266155501964e-07
Gcorr4582 T2341 T3832 T2341 T3832 -5.0558723881284824e-07
Gcorr4583 T2342 T2480 T2342 T2480 -3.7351408348550761e-08
Rt13691 T2342 T2913 1279158.9077768924
Gcorr4584 T2342 T3006 T2342 T3006 -4.2229161652821762e-07
Rt13692 T2342 T3017 1911280.7804619542
Rt13693 T2342 T3326 15070726.98048765
Gcorr4585 T2342 T4018 T2342 T4018 -8.3969019636575255e-08
Rt13694 T2343 T2636 7027864.2885050457
Rt13695 T2343 T2783 10836605.400059519
Gcorr4586 T2343 T3340 T2343 T3340 -5.324150088589341e-08
Rt13696 T2343 T3451 2831458.7006845493
Rt13697 T2343 T3947 6905072.5394927384
Gcorr4587 T2343 T4140 T2343 T4140 -7.7532777840255911e-08
Rt13698 T2344 T2470 6328585.873909506
Rt13699 T2344 T2726 4665945.636832919
Rt13700 T2345 T2346 3532059.851530123
Rt13701 T2345 T2672 5104385.6632598536
Gcorr4588 T2345 T3023 T2345 T3023 -1.7103880034585328e-07
Rt13702 T2345 T3036 1403285.5535582344
Rt13703 T2345 T3131 12441768.494500302
Rt13704 T2345 T4035 5485274.9169462109
Rt13705 T2346 T2701 3424684.1433261344
Rt13706 T2346 T3036 4968518.326312108
Rt13707 T2346 T3210 2464201.7970840344
Rt13708 T2346 T3284 1542307.9931496584
Gcorr4589 T2346 T3501 T2346 T3501 -4.1438204009148154e-07
Gcorr4590 T2346 T4035 T2346 T4035 -1.2243170673541196e-07
Rt13709 T2347 T2534 2934572.6901483946
Gcorr4591 T2347 T4173 T2347 T4173 -5.47635830078688e-07
Rt13710 T2348 T2655 2336001.5525103179
Gcorr4592 T2348 T2822 T2348 T2822 -1.5122530046110172e-07
Gcorr4593 T2348 T2929 T2348 T2929 -2.8824776764884545e-07
Gcorr4594 T2348 T3564 T2348 T3564 -3.3955417685705123e-07
Rt13711 T2348 T3763 933084.97746243444
Rt13712 T2349 T2434 2794374.565915267
Gcorr4595 T2350 T2546 T2350 T2546 -2.5712580984807053e-07
Rt13713 T2350 T2549 3165419.8811519952
Rt13714 T2350 T2946 1920157.2701479699
Rt13715 T2350 T3715 5698870.7095802203
Rt13716 T2350 T3906 424085.59818352934
Gcorr4596 T2351 T2798 T2351 T2798 -1.3160418440820238e-07
Rt13717 T2351 T3814 2766468.7309533381
Rt13718 T2351 T3816 17603537.148674138
Gcorr4597 T2351 T4192 T2351 T4192 -1.1743125865390276e-07
Rt13719 T2352 T3190 861249.61446346424
Gcorr4598 T2352 T3504 T2352 T3504 -5.3870696591491278e-07
Rt13720 T2352 T3847 49885367.352867328
Gcorr4599 T2352 T3884 T2352 T3884 -1.294192454520755e-07
Rt13721 T2353 T2697 2260557.0987560432
Gcorr4600 T2353 T2958 T2353 T2958 -2.0031192244040362e-07
Gcorr4601 T2353 T3272 T2353 T3272 -1.2950720237215601e-07
Rt13722 T2353 T3786 1047842.6547809805
Rt13723 T2353 T4043 7657335.7609166289
Rt13724 T2353 T4083 1432917.2864903719
Rt13725 T2354 T2355 7049122.7361393152
Rt13726 T2354 T2437 4023329.0529144052
Gcorr4602 T2354 T2861 T2354 T2861 -4.0437109821272589e-07
Gcorr4603 T2354 T3545 T2354 T3545 -4.6167882451383503e-07
Rt13727 T2356 T2415 9621219.0170765053
Rt13728 T2356 T2430 20690163.827702254
Rt13729 T2356 T3019 4292318.31562314
Rt13730 T2356 T3836 7912103.5763806012
Rt13731 T2356 T3869 3733448.1365951733
Gcorr4604 T2357 T2453 T2357 T2453 -2.9683757547666783e-08
Rt13732 T2357 T2496 6576159.4953610832
Rt13733 T2357 T2674 3092323.9640881759
Gcorr4605 T2357 T2835 T2357 T2835 -4.4509060222635715e-07
Gcorr4606 T2357 T3076 T2357 T3076 -1.9767312762654636e-07
Rt13734 T2357 T3333 3042739.9888045322
Rt13735 T2357 T3738 1063053.4642582524
Rt13736 T2357 T3931 701609.25111918547
Gcorr4607 T2357 T4094 T2357 T4094 -9.2634749448585222e-07
Rt13737 T2358 T2432 199497467.96214825
Gcorr4608 T2358 T2559 T2358 T2559 -7.1769408588247014e-08
Gcorr4609 T2358 T2857 T2358 T2857 -9.2030806195751971e-08
Gcorr4610 T2358 T3282 T2358 T3282 -1.2558735239367533e-06
Rt13738 T2358 T3784 1781795.6000528664
Rt13739 T2358 T3886 304915.37554188218
Rt13740 T2358 T4128 1457483.3035116098
Rt13741 T2359 T2427 3297463.6217682688
Rt13742 T2359 T2686 3419247.1318746693
Rt13743 T2359 T3094 21801369.53896242
Rt13744 T2359 T3467 5109068.3950898424
Rt13745 T2359 T3811 4442978.770583665
Rt13746 T2360 T2441 1841238.3816194253
Rt13747 T2360 T2598 3659469.7437152239
Rt13748 T2360 T2871 2646945.6779346783
Rt13749 T2360 T2880 4823472.1738469088
Rt13750 T2360 T2881 3164258.0840991586
Gcorr4611 T2360 T3803 T2360 T3803 -3.7392801078915105e-07
Rt13751 T2361 T2556 5655941.3777044974
Rt13752 T2361 T3254 4780223.7709962456
Rt13753 T2361 T3496 399506.14984729647
Rt13754 T2361 T3986 14895134.93687148
Rt13755 T2361 T3987 35793559.93012289
Rt13756 T2362 T2668 3183816.8844310832
Gcorr4612 T2362 T3310 T2362 T3310 -1.8786869019551052e-07
Rt13757 T2362 T3311 2091316.8161475621
Gcorr4613 T2362 T3785 T2362 T3785 -2.0050310641696739e-07
Rt13758 T2362 T4065 2504023.929623988
Rt13759 T2363 T2442 5522628.6125241192
Rt13760 T2363 T2484 3047016.047037825
Rt13761 T2363 T2975 2923131.2042697854
Rt13762 T2363 T3039 2124725.8580411524
Rt13763 T2363 T3040 901947.52178538358
Rt13764 T2363 T3589 23381009.655534565
Rt13765 T2364 T2414 2139066.0390906865
Rt13766 T2364 T2736 4758723.6567352889
Gcorr4614 T2364 T3422 T2364 T3422 -3.4835522501234436e-07
Gcorr4615 T2364 T3433 T2364 T3433 -2.5054294358716901e-07
Gcorr4616 T2364 T4156 T2364 T4156 -1.3140922444557319e-07
Rt13767 T2364 T4163 996288.27744781121
Rt13768 T2365 T2441 1522296.8069310945
Rt13769 T2365 T3220 1868787.9855913722
Gcorr4617 T2365 T3803 T2365 T3803 -4.7163587139238019e-07
Rt13770 T2365 T3935 2944742.3641854664
Rt13771 T2365 T3956 3197898.3603626806
Gcorr4618 T2365 T4193 T2365 T4193 -3.2319932417163388e-07
Rt13772 T2367 T3257 8500301.3064089175
Gcorr4619 T2367 T3352 T2367 T3352 -3.4437731177675117e-08
Rt13773 T2367 T3587 1610529.5038713405
Gcorr4620 T2367 T4009 T2367 T4009 -3.201107304465792e-07
Rt13774 T2368 T2641 13126906.265204554
Rt13775 T2368 T2715 12045094.63883475
Gcorr4621 T2368 T3117 T2368 T3117 -9.0391575171813778e-08
Rt13776 T2368 T3118 2172384.364922788
Rt13777 T2368 T3533 9414551.1272570658
Gcorr4622 T2369 T2654 T2369 T2654 -1.0970154626597349e-08
Rt13778 T2369 T2668 2606048.7826933488
Rt13779 T2369 T3312 5124355.177210045
Rt13780 T2369 T3359 2158596.2872030027
Gcorr4623 T2369 T3670 T2369 T3670 -3.620214178392851e-07
Rt13781 T2369 T3785 2920038.1308826562
Rt13782 T2370 T2714 18819971.73046083
Gcorr4624 T2370 T2986 T2370 T2986 -4.9823862114742012e-07
Rt13783 T2370 T3013 403677.64764445572
Gcorr4625 T2370 T3014 T2370 T3014 -4.7445738809254981e-07
Gcorr4626 T2370 T3067 T2370 T3067 -9.5257975863173776e-08
Rt13784 T2372 T2551 2948156.4012407721
Rt13785 T2372 T2720 2716819.0164141697
Gcorr4627 T2372 T2797 T2372 T2797 -1.3703715543185961e-07
Rt13786 T2372 T3664 26119083.538238574
Rt13787 T2373 T2495 5915619.9422188336
Gcorr4628 T2373 T2517 T2373 T2517 -4.5545528644825204e-08
Gcorr4629 T2373 T2738 T2373 T2738 -5.1867677469334065e-08
Gcorr4630 T2373 T2989 T2373 T2989 -9.4449352190291134e-08
Rt13788 T2373 T4050 2491066.7113262275
Rt13789 T2374 T2393 12541403.823348565
Rt13790 T2374 T2580 2825324.6761036888
Gcorr4631 T2374 T3008 T2374 T3008 -3.0929620789407743e-09
Rt13791 T2374 T3071 9495056.0554386918
Rt13792 T2374 T3072 1954776.6552986214
Rt13793 T2374 T4188 5381256.2377798799
Gcorr4632 T2375 T2528 T2375 T2528 -8.6370932572924481e-09
Rt13794 T2375 T2731 2867471.5127530536
Rt13795 T2375 T3027 1119843.473013147
Gcorr4633 T2375 T3703 T2375 T3703 -6.3240690232624143e-08
Rt13796 T2375 T3915 5415601.6893620603
Rt13797 T2375 T4044 58205910.029836394
Rt13798 T2376 T2377 3104223.316578324
Rt13799 T2376 T2457 1913163.9982698725
Rt13800 T2376 T3187 2505964.6894700904
Rt13801 T2376 T3188 5389258.6650413312
Rt13802 T2376 T3285 5540252.7748260796
Gcorr4634 T2376 T3449 T2376 T3449 -1.369441125559884e-07
Rt13803 T2377 T2478 4595662.3183443416
Rt13804 T2377 T2681 5541149.3646896705
Rt13805 T2377 T3053 2925763.6085408302
Gcorr4635 T2377 T3187 T2377 T3187 -1.6230176804206093e-07
Rt13806 T2377 T3188 1410219.5226506833
Gcorr4636 T2377 T3930 T2377 T3930 -2.2207940436752019e-09
Rt13807 T2378 T2422 1098832.5688681903
Rt13808 T2378 T2497 2483350.4628666136
Gcorr4637 T2378 T3030 T2378 T3030 -6.4210381808122034e-07
Rt13809 T2378 T3135 685726.30911760905
Gcorr4638 T2378 T4115 T2378 T4115 -2.1630213715721586e-08
Rt13810 T2379 T2522 3453229.6445139255
Rt13811 T2380 T2460 1259480.626155799
Gcorr4639 T2380 T3398 T2380 T3398 -1.2392898123297383e-07
Gcorr4640 T2380 T3760 T2380 T3760 -4.5675288180141422e-07
Gcorr4641 T2381 T3264 T2381 T3264 -1.2501654384643314e-07
Rt13812 T2381 T3266 1134602.8837730456
Rt13813 T2381 T3275 1238022.7870164674
Rt13814 T2381 T3276 30579628.801912788
Rt13815 T2382 T2792 4282480.4092511628
Rt13816 T2382 T3663 3502380.4171959586
Gcorr4642 T2382 T3827 T2382 T3827 -4.8292621367389089e-08
Rt13817 T2383 T2660 27552638.599515107
Gcorr4643 T2383 T3450 T2383 T3450 -1.6151575638934268e-07
Rt13818 T2383 T4169 2525849.8351781033
Rt13819 T2384 T2385 4791453.7753677201
Rt13820 T2384 T2724 1275063.4130379546
Rt13821 T2384 T3103 21532385.405283693
Gcorr4644 T2384 T3163 T2384 T3163 -4.5508900573236589e-07
Gcorr4645 T2384 T3696 T2384 T3696 -4.3057040323509183e-07
Rt13822 T2384 T4177 703830.17316590098
Rt13823 T2385 T3103 3869595.5136032966
Rt13824 T2385 T3104 2614171.1897029774
Rt13825 T2385 T3105 1989691.096880554
Gcorr4646 T2385 T3106 T2385 T3106 -1.8556602276954082e-07
Gcorr4647 T2385 T4177 T2385 T4177 -1.5562432932648381e-07
Gcorr4648 T2386 T2535 T2386 T2535 -3.6816498760216954e-09
Rt13826 T2386 T2696 2633571.5711571653
Rt13827 T2387 T2577 10347536.635453084
Rt13828 T2387 T3164 2061846.103338544
Rt13829 T2387 T3432 12924824.756905828
Rt13830 T2387 T3537 7892961.0689832885
Gcorr4649 T2387 T3692 T2387 T3692 -1.1243576193129541e-07
Rt13831 T2388 T2523 6618967.0573062161
Rt13832 T2388 T2524 3409413.3338448708
Rt13833 T2388 T3377 774365.17305843614
Gcorr4650 T2388 T3378 T2388 T3378 -1.4811407381584329e-07
Gcorr4651 T2388 T3379 T2388 T3379 -1.7081188075102292e-07
Gcorr4652 T2388 T3519 T2388 T3519 -4.0892666640798033e-07
Rt13834 T2389 T2436 3485657.2384929899
Rt13835 T2390 T2681 5390998.7977223182
Gcorr4653 T2390 T3052 T2390 T3052 -1.5750363054959156e-08
Rt13836 T2390 T3053 21257658.480494682
Rt13837 T2390 T3186 1760776.766910346
Rt13838 T2392 T2679 2881836.8082503676
Gcorr4654 T2392 T2943 T2392 T2943 -4.4499573091073813e-07
Gcorr4655 T2392 T3082 T2392 T3082 -1.4491710345907841e-07
Gcorr4656 T2392 T3083 T2392 T3083 -5.2117006174794355e-07
Rt13839 T2392 T3824 428158.17918498121
Rt13840 T2392 T4077 16744830.597009668
Rt13841 T2393 T2580 3913622.6963707176
Rt13842 T2393 T2633 9910158.272492189
Rt13843 T2393 T2662 5351186.7832313515
Rt13844 T2393 T3008 971488.43640366721
Gcorr4657 T2394 T2405 T2394 T2405 -1.4833097879821167e-08
Rt13845 T2394 T2407 11413392.988707829
Rt13846 T2395 T2674 3419954.551038173
Gcorr4658 T2395 T3042 T2395 T3042 -1.321160839844767e-07
Rt13847 T2395 T3043 3057728.211651173
Rt13848 T2395 T3445 3483397.0030063433
Gcorr4659 T2395 T3955 T2395 T3955 -6.8558167427031523e-08
Rt13849 T2396 T2540 10337814.091619954
Rt13850 T2396 T2704 3632112.4066020595
Rt13851 T2396 T2874 4484928.1948352456
Rt13852 T2396 T2937 269568.38928445592
Gcorr4660 T2396 T2992 T2396 T2992 -1.1469323479235167e-06
Rt13853 T2396 T3958 1041352.4680982336
Gcorr4661 T2396 T4130 T2396 T4130 -4.0003868046619963e-07
Rt13854 T2397 T2530 17441031.911081783
Rt13855 T2397 T3623 6553508.7385342084
Rt13856 T2397 T3667 6630753.4184657531
Rt13857 T2398 T3011 10383105.842904951
Rt13858 T2398 T3139 1311936.0089666427
Gcorr4662 T2398 T3821 T2398 T3821 -2.6500743299425391e-06
Rt13859 T2398 T3939 266315.89567760087
Rt13860 T2399 T2461 12526032.476118069
Rt13861 T2399 T3102 2704532.3788667736
Gcorr4663 T2399 T3104 T2399 T3104 -2.0583728968136633e-07
Rt13862 T2399 T3844 2325081.5128674596
Rt13863 T2399 T3962 941843.80698898772
Rt13864 T2400 T2574 13617901.801813304
Rt13865 T2401 T2712 2921439.1463064686
Gcorr4664 T2401 T3566 T2401 T3566 -7.6020539703480766e-08
Rt13866 T2401 T3609 4445180.0262602959
Rt13867 T2401 T3698 5749531.1303618802
Rt13868 T2402 T2537 3288598.9490474449
Rt13869 T2402 T2940 462211.40143015701
Gcorr4665 T2402 T3444 T2402 T3444 -8.386947982628088e-07
Rt13870 T2402 T3601 1486887.0205515309
Rt13871 T2402 T4186 13214490.235434009
Rt13872 T2403 T2599 31561527.637423936
Rt13873 T2403 T2601 13778292.955527639
Rt13874 T2403 T3252 2318318.4659426576
Rt13875 T2403 T3253 3877832.3504665927
Rt13876 T2403 T3436 1136178.1638051865
Rt13877 T2404 T2424 6374618.2647031117
Rt13878 T2404 T2585 4046459.2854293138
Rt13879 T2404 T2924 3058212.3746887064
Rt13880 T2404 T3518 1373143.3618832896
Rt13881 T2404 T3567 989190.28551337111
Gcorr4666 T2404 T4006 T2404 T4006 -1.3889273978304112e-07
Rt13882 T2406 T2566 2511746.4255325114
Rt13883 T2406 T2663 1489728.2544080047
Gcorr4667 T2406 T3205 T2406 T3205 -2.551048681407012e-07
Gcorr4668 T2406 T3442 T2406 T3442 -3.3167985610870955e-07
Gcorr4669 T2406 T3718 T2406 T3718 -1.0025809667783147e-07
Gcorr4670 T2406 T3842 T2406 T3842 -3.3686329437449047e-07
Rt13884 T2406 T3890 734498.71687461133
Gcorr4671 T2408 T2964 T2408 T2964 -1.7080098406704474e-08
Rt13885 T2408 T3402 585893.00490565889
Rt13886 T2408 T3427 5049860.9874971993
Gcorr4672 T2408 T3921 T2408 T3921 -1.5486173697463983e-07
Rt13887 T2409 T2410 3249684.7503460669
Rt13888 T2409 T2727 1083743.1727287211
Rt13889 T2409 T3179 8094207.3345353613
Gcorr4673 T2409 T3183 T2409 T3183 -1.0490486094413873e-07
Rt13890 T2409 T3508 2682305.5335907131
Rt13891 T2409 T4028 1090925.4720827995
Rt13892 T2410 T2591 2245111.884631413
Gcorr4674 T2410 T2727 T2410 T2727 -4.8884332987236252e-08
Rt13893 T2410 T2729 1895329.0407179256
Rt13894 T2410 T3183 535502.74420973775
Gcorr4675 T2410 T3830 T2410 T3830 -2.7779694403040334e-07
Gcorr4676 T2410 T3933 T2410 T3933 -8.5364766030522563e-08
Rt13895 T2410 T3934 4555113.4794707326
Gcorr4677 T2410 T4028 T2410 T4028 -4.5157662670524616e-07
Rt13896 T2411 T2521 2569094.3370205453
Rt13897 T2411 T2698 640903.50092446664
Gcorr4678 T2411 T2817 T2411 T2817 -6.0939954655144395e-07
Rt13898 T2411 T2820 731318.65888620098
Rt13899 T2411 T2821 319201.45759659988
Gcorr4679 T2411 T3525 T2411 T3525 -6.6055197770540305e-08
Rt13900 T2412 T2665 1987775.9278240569
Gcorr4680 T2412 T2878 T2412 T2878 -3.5252398063040392e-08
Rt13901 T2412 T3069 1774816.0058633704
Gcorr4681 T2412 T3512 T2412 T3512 -8.5964292685395052e-07
Rt13902 T2412 T3525 14284547.819418767
Rt13903 T2412 T4012 278546.01467134117
Rt13904 T2413 T2517 14585704.746187307
Gcorr4682 T2413 T2983 T2413 T2983 -8.1972858068645578e-08
Gcorr4683 T2414 T2736 T2414 T2736 -3.0110888105948583e-08
Rt13905 T2414 T3433 8731834.9966866057
Gcorr4684 T2414 T3537 T2414 T3537 -3.6997605208052076e-07
Rt13906 T2414 T3691 139614774.98216739
Gcorr4685 T2414 T4163 T2414 T4163 -2.5215659507722091e-07
Rt13907 T2414 T4191 1092501.1580544671
Rt13908 T2415 T2512 17079603.334448345
Gcorr4686 T2415 T2755 T2415 T2755 -1.5518703319732211e-07
Rt13909 T2415 T3505 3203819.2290197974
Gcorr4687 T2415 T3521 T2415 T3521 -1.1721431517918462e-07
Rt13910 T2415 T3836 2415387.936337648
Rt13911 T2416 T2484 4766630.5507681323
Rt13912 T2416 T2557 2220668.0697095678
Rt13913 T2416 T2732 4972303.8729385193
Gcorr4688 T2416 T3051 T2416 T3051 -1.4016388500961691e-07
Rt13914 T2416 T3068 7154916.0477978969
Rt13915 T2416 T3123 1768270.9694115038
Gcorr4689 T2416 T4078 T2416 T4078 -1.8016998522713438e-07
Rt13916 T2416 T4143 2305023.8656287282
Rt13917 T2417 T2526 658963.65026993211
Gcorr4690 T2417 T2665 T2417 T2665 -3.5503889262207861e-07
Rt13918 T2417 T2680 2208310.4129074868
Rt13919 T2417 T2847 104082713.18849736
Rt13920 T2417 T2878 4920298.3358646175
Rt13921 T2417 T2898 232832.86766759734
Gcorr4691 T2417 T2925 T2417 T2925 -7.4828605865317731e-07
Rt13922 T2418 T2447 6651719.1664590109
Rt13923 T2418 T2642 3596294.8562649596
Rt13924 T2418 T3417 15957861.285837358
Rt13925 T2418 T3418 2219699.654807162
Rt13926 T2418 T3434 735622.54642308736
Gcorr4692 T2418 T3952 T2418 T3952 -4.2143594909739012e-07
Gcorr4693 T2418 T4198 T2418 T4198 -4.5457568678557886e-08
Gcorr4694 T2419 T2642 T2419 T2642 -3.5786408039192226e-08
Rt13927 T2419 T3413 2405736.6277890643
Gcorr4695 T2419 T3707 T2419 T3707 -8.597728102976801e-08
Gcorr4696 T2419 T3846 T2419 T3846 -7.7048253980772707e-09
Rt13928 T2419 T4126 3545101.0937157399
Rt13929 T2420 T2421 104846671.25915611
Rt13930 T2420 T2483 3357629.2547486094
Rt13931 T2420 T3134 4475256.2941263802
Gcorr4697 T2420 T3338 T2420 T3338 -7.3528983482704106e-08
Rt13932 T2420 T3953 2484799.4801484924
Rt13933 T2420 T4100 19615292.772665035
Rt13934 T2421 T2483 2205579.3535389178
Rt13935 T2421 T3032 1192924.2830709883
Rt13936 T2421 T3134 3687508.7551479368
Gcorr4698 T2421 T3833 T2421 T3833 -9.8380326912026079e-08
Rt13937 T2422 T2423 1634132.7539332428
Rt13938 T2422 T2497 9487225.5176153071
Gcorr4699 T2422 T2978 T2422 T2978 -4.2998528491548845e-07
Rt13939 T2422 T3030 453812.68989971181
Gcorr4700 T2422 T3135 T2422 T3135 -6.9470479004152272e-07
Gcorr4701 T2422 T4115 T2422 T4115 -5.7886228988189254e-08
Gcorr4702 T2423 T2526 T2423 T2526 -1.5296543867168227e-07
Rt13940 T2423 T2925 7053490.4693735214
Rt13941 T2423 T2977 2072749.8999015165
Rt13942 T2423 T2978 574381.61122703925
Gcorr4703 T2423 T3030 T2423 T3030 -1.7668980464327473e-07
Rt13943 T2424 T2617 1151992.2034798963
Rt13944 T2424 T2924 749970.01917723299
Rt13945 T2424 T3355 989753.15648709494
Gcorr4704 T2424 T3567 T2424 T3567 -5.7810909565179089e-08
Gcorr4705 T2425 T2627 T2425 T2627 -2.8671469703878695e-08
Rt13946 T2425 T2672 3265142.1717965221
Gcorr4706 T2425 T2747 T2425 T2747 -1.0009663369585228e-07
Gcorr4707 T2425 T3617 T2425 T3617 -5.3854333737329638e-08
Rt13947 T2425 T3618 2555669.5386911877
Rt13948 T2425 T3650 5628326.9112628242
Rt13949 T2426 T2579 4463326.4262003107
Gcorr4708 T2426 T2825 T2426 T2825 -5.726954396663333e-07
Rt13950 T2427 T2640 3655619.3224778143
Rt13951 T2427 T3094 17538630.919459011
Rt13952 T2427 T3096 2760184.5406333543
Rt13953 T2427 T3467 6348963.4219024153
Rt13954 T2428 T2431 1545641.1376975018
Rt13955 T2428 T2523 32735976.690849777
Rt13956 T2428 T2713 3960054.0717465058
Gcorr4709 T2428 T2996 T2428 T2996 -3.2472670393180418e-09
Rt13957 T2428 T3374 851244.56853057677
Rt13958 T2428 T3375 2036893.3238604278
Gcorr4710 T2428 T3376 T2428 T3376 -5.0485782413095863e-07
Rt13959 T2429 T2454 5922928.2719409829
Rt13960 T2429 T2455 2779862.4108651918
Gcorr4711 T2429 T3318 T2429 T3318 -1.4727941822239044e-07
Rt13961 T2429 T3320 1785534.0784704569
Rt13962 T2429 T3343 3336194.9302971088
Gcorr4712 T2429 T3569 T2429 T3569 -4.24356155149363e-08
Rt13963 T2430 T2504 5417239.0931222923
Rt13964 T2430 T3019 11344807.301649854
Rt13965 T2430 T3582 3423088.3712283759
Rt13966 T2430 T3887 6134974.1491651116
Gcorr4713 T2430 T4091 T2430 T4091 -1.0774032025446845e-07
Rt13967 T2431 T2523 1452582.4083740914
Rt13968 T2431 T2713 1419307.6984636285
Gcorr4714 T2431 T3374 T2431 T3374 -6.6094269895020715e-07
Gcorr4715 T2431 T3375 T2431 T3375 -3.897033359472032e-07
Rt13969 T2431 T3376 499826.23306031624
Gcorr4716 T2431 T3695 T2431 T3695 -4.2579435094326389e-07
Gcorr4717 T2432 T3167 T2432 T3167 -5.0602789943868174e-07
Gcorr4718 T2432 T3282 T2432 T3282 -5.0835142870331975e-08
Rt13970 T2432 T3777 3680292.4948713682
Rt13971 T2432 T3886 1025636.7091982078
Rt13972 T2432 T4037 497773.62440685643
Gcorr4719 T2433 T2710 T2433 T2710 -3.7903742122843782e-08
Rt13973 T2433 T3297 1942754.7751482325
Gcorr4720 T2433 T3298 T2433 T3298 -1.3004988691693917e-07
Rt13974 T2433 T3559 3389991.9089894732
Gcorr4721 T2433 T3852 T2433 T3852 -9.3822873636154614e-08
Rt13975 T2434 T2562 5114003.5571803339
Gcorr4722 T2435 T2945 T2435 T2945 -3.5394901003040591e-07
Rt13976 T2435 T3206 2056598.4426232337
Rt13977 T2435 T3688 4767274.7058012309
Rt13978 T2435 T4121 581653.63688604475
Rt13979 T2435 T4122 1393844.647787729
Rt13980 T2437 T2499 11440064.903516887
Rt13981 T2438 T3192 2605117.6062959796
Rt13982 T2438 T3194 4860446.9335431317
Rt13983 T2438 T3195 3166945.7510683527
Rt13984 T2438 T3490 14004362.424878463
Gcorr4723 T2438 T3997 T2438 T3997 -2.9390346872682149e-07
Rt13985 T2439 T2570 2888085.2220970201
Rt13986 T2439 T2571 4062158.6736646043
Gcorr4724 T2439 T3097 T2439 T3097 -1.3980996864761497e-07
Rt13987 T2439 T3120 2530070.5514872372
Rt13988 T2439 T3454 3105865.8848515823
Rt13989 T2439 T3945 1689800.1931198696
Rt13990 T2440 T3144 5783785.0646125553
Gcorr4725 T2440 T3145 T2440 T3145 -1.7472336373940189e-07
Rt13991 T2440 T3146 1501524.1514030374
Gcorr4726 T2440 T3147 T2440 T3147 -2.8422330622101112e-08
Rt13992 T2441 T2869 19824904.408481408
Gcorr4727 T2441 T2871 T2441 T2871 -1.1457731176004917e-07
Gcorr4728 T2441 T2881 T2441 T2881 -4.0230197039174564e-07
Gcorr4729 T2441 T3220 T2441 T3220 -1.5627033309252128e-07
Rt13993 T2441 T3803 722152.19041824725
Gcorr4730 T2441 T3935 T2441 T3935 -2.724974896839695e-07
Rt13994 T2442 T2581 3867172.1075231419
Rt13995 T2442 T2652 2876478.1044675424
Rt13996 T2442 T3039 1767431.5960985611
Rt13997 T2442 T3572 1076967.0821850838
Rt13998 T2442 T3589 1198566.9256372903
Gcorr4731 T2442 T3894 T2442 T3894 -2.08735844495998e-07
Rt13999 T2443 T2548 16608348.350734452
Rt14000 T2444 T2474 2161978.8798686443
Gcorr4732 T2444 T3167 T2444 T3167 -5.3425259581772632e-08
Gcorr4733 T2444 T3325 T2444 T3325 -5.8497089620589878e-07
Rt14001 T2444 T3798 70196.196706986972
Gcorr4734 T2444 T4037 T2444 T4037 -3.0324770562395777e-07
Rt14002 T2445 T2462 217024956.30896997
Gcorr4735 T2445 T2473 T2445 T2473 -2.3308383987551837e-07
Gcorr4736 T2445 T2538 T2445 T2538 -1.728205679729729e-09
Rt14003 T2445 T2910 799675.38247890328
Rt14004 T2445 T3370 2309968.2562093018
Gcorr4737 T2445 T3446 T2445 T3446 -1.1137615142356292e-07
Rt14005 T2445 T3855 510885.77305915114
Rt14006 T2446 T2721 2279998.3851337479
Gcorr4738 T2446 T2875 T2446 T2875 -1.1377286573482052e-07
Rt14007 T2446 T3639 2225662.7407921194
Rt14008 T2446 T3729 7523448.0709953802
Rt14009 T2446 T3730 20004176.659896467
Gcorr4739 T2447 T2642 T2447 T2642 -3.9210616689614087e-08
Gcorr4740 T2447 T3414 T2447 T3414 -5.5442600236199221e-08
Rt14010 T2447 T3416 2095786.4658892548
Rt14011 T2447 T3417 2376779.4837442348
Gcorr4741 T2447 T3418 T2447 T3418 -1.3746831219190134e-07
Rt14012 T2448 T2618 5424951.5433869539
Rt14013 T2448 T2799 3017472.8719020584
Rt14014 T2448 T3611 3748040.5566677931
Rt14015 T2448 T3677 17313681.139561631
Gcorr4742 T2448 T4029 T2448 T4029 -9.8921515551127895e-08
Rt14016 T2449 T2450 7610192.1327295536
Rt14017 T2449 T2653 1882903.8909394473
Gcorr4743 T2449 T3035 T2449 T3035 -1.2908141840636194e-07
Rt14018 T2449 T3084 545925.29723889474
Rt14019 T2449 T3208 711823.86535404006
Rt14020 T2449 T3837 7102177.1633131253
Rt14021 T2450 T2657 13023644.868262852
Rt14022 T2450 T3035 713684.90042829711
Rt14023 T2450 T3208 1649104.1023720221
Rt14024 T2450 T3430 563769.65068794263
Gcorr4744 T2450 T3951 T2450 T3951 -6.3666695987986988e-08
Rt14025 T2451 T2586 10505904.702571569
Rt14026 T2451 T2919 3823182.1730807205
Gcorr4745 T2451 T2922 T2451 T2922 -2.1264411222944054e-07
Rt14027 T2451 T2961 361049.56168440654
Gcorr4746 T2451 T3514 T2451 T3514 -9.1005946610044064e-07
Rt14028 T2452 T2804 2017084.2973322342
Gcorr4747 T2452 T2805 T2452 T2805 -1.0366868291720912e-07
Rt14029 T2452 T2806 1736048.611837358
Gcorr4748 T2452 T2835 T2452 T2835 -4.6058016448472358e-07
Rt14030 T2453 T2676 2077895.1923381535
Gcorr4749 T2453 T2835 T2453 T2835 -4.8272099096262866e-07
Gcorr4750 T2453 T3224 T2453 T3224 -1.482882678025863e-07
Gcorr4751 T2453 T3922 T2453 T3922 -1.1140353097813566e-07
Rt14031 T2453 T3931 1868286.5337742136
Rt14032 T2453 T3977 803981.90594024654
Rt14033 T2454 T3343 845415.22947638738
Gcorr4752 T2454 T3739 T2454 T3739 -4.5578268656033191e-07
Gcorr4753 T2454 T3742 T2454 T3742 -2.9122871168097857e-07
Gcorr4754 T2454 T4039 T2454 T4039 -3.3062362620769428e-08
Gcorr4755 T2455 T3317 T2455 T3317 -1.4930173545944111e-07
Rt14034 T2455 T3318 1079092.9205442243
Rt14035 T2455 T3319 4751842.804265203
Gcorr4756 T2455 T3320 T2455 T3320 -6.8891870161793375e-08
Rt14036 T2456 T2621 2326564.4936284488
Gcorr4757 T2456 T2684 T2456 T2684 -1.069062686164307e-07
Rt14037 T2456 T2993 2144493.127268739
Rt14038 T2456 T3037 12392339.738021171
Rt14039 T2456 T3159 895760.22103035729
Gcorr4758 T2457 T3188 T2457 T3188 -1.7115525711861141e-07
Rt14040 T2457 T3285 977604.92662814481
Gcorr4759 T2457 T3336 T2457 T3336 -8.2459397814367461e-08
Rt14041 T2457 T3499 9215464.4879852161
Gcorr4760 T2457 T4016 T2457 T4016 -4.6351565565421619e-07
Rt14042 T2458 T2560 2816521.6682821726
Gcorr4761 T2458 T2729 T2458 T2729 -6.851582048744189e-08
Gcorr4762 T2458 T2968 T2458 T2968 -1.083054081305825e-07
Rt14043 T2458 T2973 5596391.2860073606
Rt14044 T2458 T2976 2270874.7346240971
Rt14045 T2458 T3028 26774657.545265954
Rt14046 T2459 T2726 2323314.9241553722
Rt14047 T2460 T2582 6609923.2537568118
Rt14048 T2460 T2819 9612416.7004280947
Rt14049 T2460 T3760 1381235.7932074084
Rt14050 T2461 T2547 3533454.818419043
Gcorr4763 T2461 T2632 T2461 T2632 -3.8006605876344344e-08
Gcorr4764 T2461 T3065 T2461 T3065 -5.099167097603918e-08
Rt14051 T2461 T3101 1009623.5481593811
Rt14052 T2461 T3962 2220784.0808326355
Gcorr4765 T2462 T2538 T2462 T2538 -1.010467711053208e-07
Rt14053 T2462 T2678 1000856.0259687739
Rt14054 T2462 T3246 1547282.233333579
Rt14055 T2462 T3370 4030693.3068538778
Gcorr4766 T2462 T3855 T2462 T3855 -2.6554733716974431e-07
Gcorr4767 T2462 T3970 T2462 T3970 -3.9507257120520978e-07
Gcorr4768 T2462 T4072 T2462 T4072 -2.5926392270176785e-07
Rt14056 T2462 T4166 498018.51860047068
Rt14057 T2463 T2707 1241063.3520914807
Rt14058 T2463 T2942 2124784.456699837
Gcorr4769 T2463 T3462 T2463 T3462 -1.3533832061149404e-07
Rt14059 T2463 T4150 867275.79226432485
Rt14060 T2464 T2465 3943308.5234061712
Rt14061 T2464 T2705 3140218.2564820875
Gcorr4770 T2464 T3474 T2464 T3474 -1.1982509724034002e-07
Rt14062 T2464 T3475 4174138.150047048
Rt14063 T2464 T3476 3191311.2076841216
Rt14064 T2464 T3477 10271394.026689915
Rt14065 T2465 T2503 3485681.0567002688
Gcorr4771 T2465 T3405 T2465 T3405 -1.6998672062887179e-07
Rt14066 T2465 T3475 2994048.1786641851
Gcorr4772 T2465 T3477 T2465 T3477 -1.6857777096035251e-07
Rt14067 T2465 T3823 4565672.8574746763
Rt14068 T2465 T4052 1548038.6389089294
Rt14069 T2466 T2467 3129519.6864935006
Gcorr4773 T2466 T3151 T2466 T3151 -6.7578171293857629e-08
Gcorr4774 T2466 T3152 T2466 T3152 -7.0154670647065576e-07
Rt14070 T2466 T3153 720477.76581272145
Gcorr4775 T2466 T3154 T2466 T3154 -1.1237302766152475e-07
Rt14071 T2467 T2468 4559461.9048118433
Rt14072 T2467 T3151 3005123.4607647811
Rt14073 T2467 T3154 1417658.9928521749
Gcorr4776 T2467 T3438 T2467 T3438 -1.3730786961323672e-07
Rt14074 T2467 T3882 3838978.8533004858
Rt14075 T2468 T2469 3174557.3824691204
Rt14076 T2468 T2595 4371726.7824008688
Rt14077 T2468 T3437 6516107.7528443998
Rt14078 T2468 T3438 975692.97490438027
Rt14079 T2468 T3882 18119979.098285209
Rt14080 T2468 T4170 4536019.336136017
Rt14081 T2469 T2568 3878317.1965191495
Rt14082 T2469 T2593 2966520.9507845398
Rt14083 T2469 T2733 3181376.6499934755
Rt14084 T2469 T2930 3546496.1663437784
Rt14085 T2469 T3437 800055.01974624256
Rt14086 T2469 T3461 5015228.5939858304
Gcorr4777 T2469 T4141 T2469 T4141 -4.1273375012707247e-08
Gcorr4778 T2469 T4170 T2469 T4170 -2.4782074560405192e-07
Gcorr4779 T2470 T3797 T2470 T3797 -3.9027546860944131e-07
Rt14087 T2471 T3273 4395615.006646974
Rt14088 T2471 T3274 17488507.497405861
Rt14089 T2471 T3346 7009282.9007175295
Rt14090 T2472 T2473 660627.93143874477
Gcorr4780 T2472 T3364 T2472 T3364 -2.0776449271683891e-06
Rt14091 T2472 T3365 221269.73250547459
Gcorr4781 T2472 T3367 T2472 T3367 -2.8356931629727479e-07
Rt14092 T2472 T3500 2150622.7320347894
Gcorr4782 T2472 T3621 T2472 T3621 -1.0705334863673072e-06
Gcorr4783 T2473 T3365 T2473 T3365 -1.0793640468303324e-06
Rt14093 T2473 T3424 3277001.3094406677
Gcorr4784 T2473 T3500 T2473 T3500 -6.0448116831458626e-09
Rt14094 T2473 T3621 343634.93326269789
Gcorr4785 T2473 T3855 T2473 T3855 -1.1870854238371504e-07
Gcorr4786 T2474 T2475 T2474 T2475 -1.8259023999378357e-07
Gcorr4787 T2474 T2906 T2474 T2906 -4.857411197691031e-07
Rt14095 T2474 T3325 898569.3773116786
Rt14096 T2474 T3681 664821.72649395152
Rt14097 T2474 T3798 3565412.0952500757
Gcorr4788 T2474 T4003 T2474 T4003 -7.0192197399672758e-08
Rt14098 T2475 T2575 2832235.4466908346
Rt14099 T2475 T2647 3232425.0020544329
Rt14100 T2475 T2687 3071329.3321610894
Rt14101 T2475 T3269 3820113.7417705138
Gcorr4789 T2475 T3271 T2475 T3271 -1.0353393882831882e-07
Rt14102 T2475 T3681 1458088.0156273805
Rt14103 T2475 T3985 1211248.4341334687
Rt14104 T2476 T2477 4671543.9279957032
Rt14105 T2476 T2520 45203730.85287305
Gcorr4790 T2476 T3180 T2476 T3180 -1.0707186971685831e-07
Rt14106 T2476 T3182 1008522.7104854248
Gcorr4791 T2476 T3193 T2476 T3193 -1.8258316055340056e-09
Rt14107 T2476 T4059 19949560.801225975
Rt14108 T2477 T2520 2097132.4780201479
Gcorr4792 T2477 T3193 T2477 T3193 -1.1316753816609332e-07
Gcorr4793 T2477 T3508 T2477 T3508 -6.2598854137851558e-08
Rt14109 T2477 T3828 2026261.1516852984
Rt14110 T2477 T4059 1024972.5046910426
Rt14111 T2478 T2681 8129031.5528287888
Rt14112 T2478 T2985 1662299.3757165538
Rt14113 T2478 T3053 26150995.733913131
Rt14114 T2478 T3930 1973696.3213047027
Rt14115 T2479 T2535 4126040.2866746876
Rt14116 T2480 T2547 3211747.8804493579
Gcorr4794 T2480 T3006 T2480 T3006 -4.5936238783814432e-07
Rt14117 T2480 T3017 724136.34461130481
Rt14118 T2480 T3018 1925515.9617803192
Rt14119 T2480 T3056 2369907.2863025288
Gcorr4795 T2480 T3201 T2480 T3201 -7.6009083335344464e-07
Rt14120 T2481 T2482 2441472.4140130202
Gcorr4796 T2481 T2516 T2481 T2516 -9.7551510881401794e-08
Rt14121 T2481 T3218 1985606.6999856189
Rt14122 T2481 T3578 3009860.7619120162
Gcorr4797 T2481 T3583 T2481 T3583 -2.2501673574386611e-08
Rt14123 T2482 T2516 5526015.3181701517
Rt14124 T2482 T2527 2714527.3775524092
Rt14125 T2482 T2558 4932694.4973905804
Rt14126 T2482 T3394 665280.96687602787
Gcorr4798 T2482 T3396 T2482 T3396 -7.583407011632538e-07
Gcorr4799 T2482 T3578 T2482 T3578 -1.4056743419594961e-07
Rt14127 T2482 T3583 3077178.7661191388
Rt14128 T2482 T4105 2456959.3955863318
Gcorr4800 T2483 T3032 T2483 T3032 -1.0708318903018116e-07
Rt14129 T2483 T3133 1848841.1974109618
Rt14130 T2483 T3134 16515555.783641843
Gcorr4801 T2483 T3953 T2483 T3953 -3.0618034313586368e-08
Gcorr4802 T2484 T2975 T2484 T2975 -2.0931315185421021e-07
Rt14131 T2484 T3040 2826150.7948532454
Rt14132 T2484 T3051 1350639.2227568389
Rt14133 T2484 T3068 58503629.222540542
Rt14134 T2485 T2549 3048471.2132571535
Rt14135 T2485 T3313 3109746.1191908657
Rt14136 T2485 T3322 24427351.968732767
Rt14137 T2485 T3590 1829605.9250336217
Gcorr4803 T2486 T3388 T2486 T3388 -4.1113164893808878e-07
Rt14138 T2486 T3389 903990.74576881272
Gcorr4804 T2486 T3390 T2486 T3390 -1.754772778645912e-07
Gcorr4805 T2486 T3395 T2486 T3395 -9.19267496774355e-08
Gcorr4806 T2487 T2558 T2487 T2558 -1.2571221111103718e-07
Rt14139 T2487 T2690 2293750.9234778956
Rt14140 T2487 T2994 2609519.1482845787
Gcorr4807 T2487 T3387 T2487 T3387 -8.9204901074500024e-08
Rt14141 T2487 T3388 696687.67345360387
Gcorr4808 T2487 T3391 T2487 T3391 -6.3824376555544093e-07
Rt14142 T2487 T3967 3239526.5337532558
Rt14143 T2488 T3280 5575701.6016228693
Gcorr4809 T2488 T3281 T2488 T3281 -6.3781700490765204e-08
Rt14144 T2488 T3288 1921375.3220271538
Gcorr4810 T2488 T3294 T2488 T3294 -1.7775758979029504e-07
Rt14145 T2489 T2622 6915500.4671234088
Gcorr4811 T2489 T3064 T2489 T3064 -9.5717202583119293e-08
Rt14146 T2489 T3168 1781537.0545864892
Gcorr4812 T2489 T3287 T2489 T3287 -5.8951035078095013e-08
Gcorr4813 T2490 T2533 T2490 T2533 -1.7405425959834158e-07
Gcorr4814 T2490 T3070 T2490 T3070 -5.3019060942560404e-07
Rt14147 T2490 T3397 1473128.2022946682
Rt14148 T2490 T3515 2164074.0973422411
Rt14149 T2490 T3897 2114853.16657861
Rt14150 T2490 T4112 689702.15981132782
Rt14151 T2491 T2492 3830165.4326401884
Rt14152 T2491 T2709 2066081.4726608705
Gcorr4815 T2491 T2721 T2491 T2721 -5.6808812933592338e-08
Rt14153 T2491 T3637 1535002.1084200775
Rt14154 T2491 T3829 14460559.605588248
Rt14155 T2491 T4032 2000492.6747144256
Gcorr4816 T2491 T4153 T2491 T4153 -2.1909553215095044e-07
Rt14156 T2492 T3038 1353846.7021769546
Rt14157 T2492 T3829 1398460.7114783784
Gcorr4817 T2492 T3960 T2492 T3960 -4.0792518871786729e-07
Gcorr4818 T2492 T4032 T2492 T4032 -4.4927639252835607e-08
Rt14158 T2492 T4146 4002230.5715613202
Gcorr4819 T2493 T2952 T2493 T2952 -1.1853194531079398e-07
Gcorr4820 T2493 T2953 T2493 T2953 -4.6405711590212133e-07
Rt14159 T2493 T2979 365673.15521211846
Gcorr4821 T2493 T3035 T2493 T3035 -4.7467873071729028e-07
Rt14160 T2493 T3286 3290434.2040750319
Rt14161 T2494 T2702 2515203.0105905905
Rt14162 T2494 T3081 54109003.042927295
Rt14163 T2494 T3082 3430543.8783924566
Rt14164 T2494 T3171 1327363.2164323097
Rt14165 T2496 T2674 7650620.7051764457
Gcorr4822 T2496 T3075 T2496 T3075 -1.4098766060746649e-07
Rt14166 T2496 T3076 2699410.8280057618
Rt14167 T2496 T3077 4904387.4199909493
Rt14168 T2496 T3333 4765434.0579606788
Rt14169 T2497 T3030 2253275.66933779
Rt14170 T2497 T3132 1022191.4017379584
Rt14171 T2497 T3135 16493046.945240812
Gcorr4823 T2497 T3517 T2497 T3517 -6.0953499425774275e-07
Gcorr4824 T2498 T2506 T2498 T2506 -1.1264060430092803e-07
Rt14172 T2498 T3138 8598004.5429555532
Gcorr4825 T2498 T3172 T2498 T3172 -5.2573898713312238e-08
Rt14173 T2498 T3550 38258148.767940514
Rt14174 T2498 T3551 829759.55210031359
Rt14175 T2498 T3905 1275925.5856655291
Rt14176 T2499 T2588 18918946.431938168
Rt14177 T2500 T3240 2237843.6968708928
Rt14178 T2500 T3241 20196094.822300635
Rt14179 T2500 T3242 2095158.8873218845
Gcorr4826 T2500 T4072 T2500 T4072 -3.6145591738331885e-07
Rt14180 T2501 T2643 19752910.284447093
Rt14181 T2501 T2886 441685.57676512725
Gcorr4827 T2501 T3642 T2501 T3642 -1.9533937872894462e-06
Rt14182 T2502 T2604 3037079.2090617437
Rt14183 T2502 T2683 8879513.1688632853
Rt14184 T2502 T3175 3640940.7620114475
Gcorr4828 T2502 T3491 T2502 T3491 -1.1274449646127968e-07
Rt14185 T2502 T3497 2274247.2270099754
Gcorr4829 T2502 T3948 T2502 T3948 -9.5880494177665651e-08
Gcorr4830 T2503 T2507 T2503 T2507 -3.539519310224209e-08
Rt14186 T2503 T3351 5283407.5877492307
Rt14187 T2503 T3405 2390382.6344295125
Rt14188 T2503 T3823 62284941.204279661
Rt14189 T2504 T2614 31577322.884354874
Gcorr4831 T2504 T3582 T2504 T3582 -5.9162224098841521e-08
Rt14190 T2504 T3620 18838737.475785594
Rt14191 T2504 T3853 3587265.0448997584
Rt14192 T2504 T4091 7352839.3979235636
Rt14193 T2505 T2573 18460989.414539527
Rt14194 T2505 T3012 5660519.705992029
Rt14195 T2505 T3481 996190.86474887584
Rt14196 T2505 T3482 1228598.5181559683
Gcorr4832 T2505 T3585 T2505 T3585 -4.2213105696944101e-07
Gcorr4833 T2505 T3817 T2505 T3817 -3.7660415311659192e-07
Rt14197 T2506 T2621 2816865.5291786632
Gcorr4834 T2506 T3037 T2506 T3037 -4.9619886719727337e-08
Rt14198 T2506 T3138 661277.87372464989
Gcorr4835 T2506 T3881 T2506 T3881 -7.6167921781266262e-07
Rt14199 T2506 T3968 846500.47031882417
Rt14200 T2507 T2532 11188659.206681617
Gcorr4836 T2507 T3349 T2507 T3349 -3.0014756672807173e-08
Rt14201 T2507 T3350 1478377.5740496176
Rt14202 T2507 T3351 2748906.0582794142
Rt14203 T2507 T3401 3855868.4900747007
Gcorr4837 T2507 T3866 T2507 T3866 -1.9458706212489539e-07
Rt14204 T2509 T2534 10871636.617922114
Gcorr4838 T2509 T2710 T2509 T2710 -6.6975396233165773e-09
Rt14205 T2509 T3353 3415333.5066192262
Rt14206 T2509 T3453 21327543.409612268
Rt14207 T2509 T3568 4098460.0282993834
Rt14208 T2509 T4180 45445550.622198567
Gcorr4839 T2510 T3000 T2510 T3000 -2.0055462972020664e-07
Rt14209 T2510 T3113 838461.1870780118
Gcorr4840 T2510 T3114 T2510 T3114 -7.4290747030637137e-09
Gcorr4841 T2510 T3115 T2510 T3115 -2.356389040939989e-07
Rt14210 T2511 T2920 2245286.0630104011
Rt14211 T2511 T2922 938447.26729515253
Rt14212 T2511 T2923 489380.16263195698
Rt14213 T2512 T2732 11394023.180097971
Rt14214 T2512 T3141 2932932.6876544394
Rt14215 T2512 T3505 6754254.5099487826
Gcorr4842 T2512 T3506 T2512 T3506 -4.4987463341152316e-08
Gcorr4843 T2513 T2900 T2513 T2900 -3.3488828851903467e-08
Rt14216 T2513 T3596 13687021.331921719
Rt14217 T2513 T4020 901323.04345657409
Gcorr4844 T2513 T4021 T2513 T4021 -2.0899056087082498e-07
Gcorr4845 T2513 T4194 T2513 T4194 -5.4020049413906272e-07
Rt14218 T2514 T2693 1546414.5381589658
Gcorr4846 T2514 T2944 T2514 T2944 -4.7831621433763452e-07
Rt14219 T2514 T3776 217485.47090625108
Gcorr4847 T2514 T3822 T2514 T3822 -3.7976485177459811e-07
Gcorr4848 T2515 T2779 T2515 T2779 -1.562305060363146e-07
Gcorr4849 T2515 T3238 T2515 T3238 -2.3040067454976955e-07
Gcorr4850 T2515 T3241 T2515 T3241 -3.9065328724410196e-07
Rt14220 T2515 T3622 694654.64509361528
Rt14221 T2515 T3796 2609347.3717445261
Gcorr4851 T2515 T3974 T2515 T3974 -6.3115115029660958e-07
Rt14222 T2516 T2947 19055648.626280237
Gcorr4852 T2516 T3233 T2516 T3233 -8.2226958890200481e-07
Rt14223 T2516 T3578 25249788.165414486
Rt14224 T2516 T4104 572567.96408876264
Rt14225 T2516 T4105 2090167.6376825802
Rt14226 T2517 T2738 23407759.022965334
Rt14227 T2517 T3878 9089666.4505693465
Rt14228 T2518 T2549 3227253.9621795625
Gcorr4853 T2518 T3304 T2518 T3304 -1.6825785743340498e-07
Rt14229 T2518 T3305 992531.12992632121
Gcorr4854 T2518 T3322 T2518 T3322 -3.6548747590005432e-08
Rt14230 T2518 T3715 4220995.8353700535
Gcorr4855 T2519 T2662 T2519 T2662 -1.1577463514200922e-07
Rt14231 T2519 T2995 11919252.297654646
Rt14232 T2519 T3007 1309486.5393880655
Rt14233 T2519 T3061 2119316.6098496965
Gcorr4856 T2519 T4048 T2519 T4048 -3.4963957899399407e-07
Gcorr4857 T2520 T3192 T2520 T3192 -5.9343988748385048e-07
Rt14234 T2520 T3193 346701.6410050324
Gcorr4858 T2520 T3194 T2520 T3194 -5.4516012263117154e-07
Gcorr4859 T2520 T3206 T2520 T3206 -2.600024829876409e-07
Gcorr4860 T2520 T3828 T2520 T3828 -4.6007876609177665e-07
Rt14235 T2521 T2820 634996.47096319031
Rt14236 T2521 T2941 9204765.5721704271
Rt14237 T2521 T2986 1292232.0932297525
Rt14238 T2521 T3525 1097024.4494645842
Rt14239 T2522 T2677 25544418.991997037
Rt14240 T2522 T2711 6923502.5476350766
Rt14241 T2523 T3375 2073022.6671592034
Gcorr4861 T2523 T3376 T2523 T3376 -1.4105477218705032e-07
Rt14242 T2523 T3377 4617896.6186603848
Rt14243 T2524 T3378 1939466.2280426456
Rt14244 T2524 T3379 7082341.0477771377
Rt14245 T2524 T3381 4259233.1543431534
Rt14246 T2524 T3382 8348719.7414049907
Rt14247 T2525 T2537 9077022.4058732446
Rt14248 T2525 T3302 396492.23129955842
Gcorr4862 T2525 T3303 T2525 T3303 -1.0930921452409078e-06
Rt14249 T2525 T3304 1206611.4513330003
Gcorr4863 T2525 T3862 T2525 T3862 -5.445407359428883e-08
Gcorr4864 T2525 T4186 T2525 T4186 -6.7891618933724335e-07
Rt14250 T2526 T2665 1516553.9785846802
Gcorr4865 T2526 T2878 T2526 T2878 -8.11932213148628e-07
Gcorr4866 T2526 T2898 T2526 T2898 -1.9836336317095836e-07
Rt14251 T2526 T2925 273846.86594439327
Rt14252 T2526 T2927 13576729.174227199
Rt14253 T2527 T3392 2020895.4040630544
Rt14254 T2527 T3394 25217620.371312093
Rt14255 T2527 T3583 8455021.4686382208
Gcorr4867 T2527 T3702 T2527 T3702 -1.6106575450115043e-07
Rt14256 T2528 T2667 5753555.8035457153
Gcorr4868 T2528 T2916 T2528 T2916 -1.7057479252431413e-07
Rt14257 T2528 T2984 1251536.457100383
Rt14258 T2528 T3020 4352380.0336089171
Rt14259 T2528 T3027 2570836.2977430597
Gcorr4869 T2528 T3703 T2528 T3703 -4.2300846882131674e-07
Rt14260 T2529 T2935 1312415.07131056
Gcorr4870 T2529 T2936 T2529 T2936 -4.115272243364062e-07
Rt14261 T2529 T2999 1208411.8503631731
Rt14262 T2529 T3001 33423415.051152054
Rt14263 T2530 T2764 13147633.464876154
Rt14264 T2530 T3667 8979605.0422658511
Gcorr4871 T2530 T3700 T2530 T3700 -1.7678391798346935e-07
Rt14265 T2530 T4069 2836033.8435744205
Rt14266 T2531 T3022 1934081.0585594606
Rt14267 T2531 T3079 3227339.5583121739
Gcorr4872 T2531 T3184 T2531 T3184 -3.909235287467726e-08
Rt14268 T2532 T2697 10144477.469935009
Rt14269 T2532 T3347 8099082.3460831819
Rt14270 T2532 T3348 2233924.7976088868
Rt14271 T2532 T3349 4723761.3934838353
Gcorr4873 T2532 T3350 T2532 T3350 -1.545615987081745e-07
Gcorr4874 T2533 T3070 T2533 T3070 -5.1435056843611253e-07
Rt14272 T2533 T3897 242922.02195350415
Gcorr4875 T2534 T2791 T2534 T2791 -1.3836634043162182e-06
Rt14273 T2534 T3568 4797141.2455287473
Gcorr4876 T2534 T3857 T2534 T3857 -2.2114834563510474e-07
Rt14274 T2534 T4173 508791.45107454545
Rt14275 T2536 T2627 2117138.3853730937
Gcorr4877 T2536 T2708 T2536 T2708 -1.5392671750907064e-08
Gcorr4878 T2536 T2762 T2536 T2762 -2.9082084357417451e-07
Gcorr4879 T2536 T3522 T2536 T3522 -2.2576298735703449e-07
Gcorr4880 T2536 T3617 T2536 T3617 -1.6746672713815555e-06
Gcorr4881 T2536 T3628 T2536 T3628 -4.8042781557570117e-07
Rt14276 T2536 T3928 326937.50539970375
Rt14277 T2537 T3300 1926881.1444539961
Gcorr4882 T2537 T3302 T2537 T3302 -8.4076618193788112e-08
Rt14278 T2537 T3601 246076411.69041196
Rt14279 T2537 T4186 1007796.1791167014
Gcorr4883 T2538 T3251 T2538 T3251 -4.1458664563089199e-08
Rt14280 T2538 T3370 486294.8746732992
Gcorr4884 T2538 T3446 T2538 T3446 -6.5918271145230801e-07
Rt14281 T2538 T3705 1442540.8149533153
Rt14282 T2539 T2620 3451583.7652485957
Rt14283 T2539 T3147 35833369.780914128
Gcorr4885 T2539 T3148 T2539 T3148 -9.3114782259633609e-07
Rt14284 T2539 T3198 348351.08707537217
Gcorr4886 T2539 T3455 T2539 T3455 -2.8379789040417681e-07
Gcorr4887 T2539 T3456 T2539 T3456 -4.1663958341041698e-07
Gcorr4888 T2540 T3046 T2540 T3046 -2.0531732859113491e-07
Rt14285 T2540 T3166 1415764.4711415435
Rt14286 T2540 T3958 1226348.9974848572
Rt14287 T2540 T4130 1316804.1314374625
Rt14288 T2541 T2600 5639336.9424080057
Rt14289 T2541 T2840 1359382.2086362327
Rt14290 T2541 T3690 1267323736.3944955
Rt14291 T2541 T3753 721332.35440232826
Gcorr4889 T2542 T2831 T2542 T2831 -1.412402863151864e-07
Gcorr4890 T2542 T3308 T2542 T3308 -1.2724189237185104e-07
Rt14292 T2542 T3757 1988064.5214758927
Rt14293 T2542 T3914 7737891.7731279824
Gcorr4891 T2543 T2936 T2543 T2936 -1.9136226898417082e-08
Rt14294 T2543 T3553 725102.79501940939
Gcorr4892 T2543 T4040 T2543 T4040 -4.0032463032547907e-07
Gcorr4893 T2543 T4138 T2543 T4138 -4.7963161740852214e-07
Gcorr4894 T2544 T2610 T2544 T2610 -3.5003488357658956e-08
Rt14295 T2544 T2669 3065586.4458594541
Rt14296 T2544 T2772 9453270.5127453227
Rt14297 T2544 T3513 6134850.1068848185
Rt14298 T2545 T2610 3223813.5119998259
Rt14299 T2545 T2771 5495979.2125751413
Rt14300 T2545 T3864 2521380.244160329
Gcorr4895 T2545 T3917 T2545 T3917 -1.1456244418360045e-07
Rt14301 T2546 T2658 2841956.5816414705
Rt14302 T2546 T2946 620763.06751978304
Rt14303 T2546 T3712 1483779.5000221024
Rt14304 T2546 T3856 1524842.969398956
Rt14305 T2547 T3018 2248559.2745367833
Gcorr4896 T2547 T3056 T2547 T3056 -1.0226483141502598e-07
Rt14306 T2547 T3065 1925891.075788609
Gcorr4897 T2547 T3101 T2547 T3101 -1.1825230023286711e-07
Gcorr4898 T2548 T2649 T2548 T2649 -1.5645266113438074e-08
Rt14307 T2549 T3322 920615.56058488111
Gcorr4899 T2549 T3590 T2549 T3590 -1.2648891432220063e-07
Rt14308 T2549 T3715 3047990.012840359
Rt14309 T2549 T3906 4130853.2719720327
Gcorr4900 T2550 T2581 T2550 T2581 -1.0862339970141168e-07
Rt14310 T2550 T3074 2934387.2063846234
Rt14311 T2550 T3485 763129.47084944218
Rt14312 T2550 T3787 1275929.955570684
Gcorr4901 T2550 T4057 T2550 T4057 -1.5400301627766098e-07
Rt14313 T2551 T2637 21844296.839988381
Rt14314 T2551 T2797 3394979.475562992
Rt14315 T2552 T2809 1067004.9299775853
Gcorr4902 T2552 T2811 T2552 T2811 -9.2886403169112022e-09
Rt14316 T2552 T2813 1434530.8869280235
Gcorr4903 T2552 T3731 T2552 T3731 -9.4895767370844385e-08
Rt14317 T2553 T2554 4310023.025110526
Rt14318 T2553 T3421 10217139.980500475
Rt14319 T2553 T3459 6861538.1961501529
Rt14320 T2553 T3494 3855658.1134434463
Gcorr4904 T2553 T4152 T2553 T4152 -1.178654064005889e-07
Rt14321 T2554 T2673 6315984.0280809589
Gcorr4905 T2554 T3420 T2554 T3420 -1.4896316011703685e-07
Rt14322 T2554 T3421 3230942.2583110817
Rt14323 T2554 T3458 1164588.8271951939
Gcorr4906 T2554 T3459 T2554 T3459 -1.3462714276104483e-07
Gcorr4907 T2555 T2615 T2555 T2615 -6.5705880823892888e-08
Rt14324 T2555 T2997 96049633.559503183
Rt14325 T2555 T3178 2099186.4336743839
Gcorr4908 T2555 T3754 T2555 T3754 -6.9239921222879496e-08
Rt14326 T2555 T4075 2367385.4523058091
Gcorr4909 T2555 T4183 T2555 T4183 -5.6223265103417067e-08
Rt14327 T2556 T2599 6292498.9873862229
Rt14328 T2556 T2928 680850.30638562178
Rt14329 T2556 T3496 869037.32303381409
Rt14330 T2556 T3987 2049067.4241787405
Rt14331 T2557 T3068 3416469.5111238039
Gcorr4910 T2557 T3123 T2557 T3123 -2.1244527871047093e-08
Rt14332 T2557 T3202 2906755.8316375786
Gcorr4911 T2558 T3391 T2558 T3391 -4.339505579390284e-07
Gcorr4912 T2558 T3394 T2558 T3394 -5.6555085725640594e-07
Rt14333 T2558 T3396 582481.32698069594
Rt14334 T2558 T3967 1549927.5840602422
Rt14335 T2558 T4007 2666862.5134004755
Rt14336 T2559 T2617 1744239.6368412666
Gcorr4913 T2559 T3276 T2559 T3276 -5.0685283760992512e-07
Rt14337 T2559 T3278 3033594.4706585221
Gcorr4914 T2559 T3355 T2559 T3355 -4.8321035889906287e-07
Rt14338 T2559 T3784 341068.54944573069
Rt14339 T2560 T2729 1186853.685604492
Gcorr4915 T2560 T2969 T2560 T2969 -1.3000034924941237e-07
Rt14340 T2560 T2973 1011114.9391453718
Gcorr4916 T2560 T3028 T2560 T3028 -4.8705148642973428e-07
Gcorr4917 T2560 T3933 T2560 T3933 -9.6166971940879808e-08
Rt14341 T2560 T4060 4196785.7326320652
Gcorr4918 T2561 T3114 T2561 T3114 -4.8975385021619822e-07
Rt14342 T2561 T3575 1452530.1332059524
Rt14343 T2561 T3576 735218.47037635464
Rt14344 T2561 T3680 10363931.369116319
Gcorr4919 T2562 T2654 T2562 T2654 -3.485436626097819e-08
Gcorr4920 T2562 T3670 T2562 T3670 -1.2742988499840851e-07
Rt14345 T2563 T2679 9983717.3351483177
Gcorr4921 T2563 T3041 T2563 T3041 -5.4219207579537952e-07
Gcorr4922 T2563 T3083 T2563 T3083 -1.7193088498093763e-08
Rt14346 T2563 T3384 324752.67197762156
Gcorr4923 T2563 T3610 T2563 T3610 -4.7361967273748181e-08
Gcorr4924 T2563 T4066 T2563 T4066 -5.9310186101014752e-07
Rt14347 T2564 T2629 3738308.3756175218
Gcorr4925 T2564 T2644 T2564 T2644 -3.4041941317689983e-08
Rt14348 T2564 T2963 16916282.737057257
Gcorr4926 T2564 T3708 T2564 T3708 -3.1054616621996863e-07
Gcorr4927 T2564 T3874 T2564 T3874 -4.492660137253953e-07
Rt14349 T2564 T4071 960646.2263002767
Rt14350 T2565 T3176 2913268.6622455823
Rt14351 T2565 T3469 23726507.627227273
Rt14352 T2565 T3470 4257526.9000287205
Rt14353 T2566 T2594 3105793.0751882717
Rt14354 T2566 T2926 1047249.476356252
Gcorr4928 T2566 T3687 T2566 T3687 -3.6131504879196955e-07
Gcorr4929 T2566 T3842 T2566 T3842 -1.2124906990856723e-07
Gcorr4930 T2566 T3890 T2566 T3890 -9.894729654559529e-08
Gcorr4931 T2568 T2593 T2568 T2593 -9.8444567598429118e-08
Rt14355 T2568 T2930 609258.91316328652
Rt14356 T2568 T3461 1176340.4655072943
Rt14357 T2568 T3462 8703768.0423916858
Rt14358 T2569 T2591 1144845.1822674347
Rt14359 T2569 T2652 17601193.521575633
Gcorr4932 T2569 T2974 T2569 T2974 -1.7876664212071064e-08
Rt14360 T2569 T2988 1161975.0354490322
Rt14361 T2569 T3894 1461473.2290297169
Gcorr4933 T2569 T3934 T2569 T3934 -5.1626943818340161e-07
Rt14362 T2570 T2571 20573993.057430658
Rt14363 T2570 T3097 3148601.5301482631
Rt14364 T2570 T3119 7370741.9717968386
Rt14365 T2570 T3120 7523646.361149665
Rt14366 T2571 T2572 26689966.169257276
Rt14367 T2571 T2640 3425191.664708145
Gcorr4934 T2571 T3095 T2571 T3095 -3.3557308199339655e-08
Rt14368 T2571 T3097 1452209.2740062857
Rt14369 T2571 T3130 1752214.6883044194
Gcorr4935 T2571 T3945 T2571 T3945 -3.5570242600536299e-08
Rt14370 T2572 T3130 998641.10815354483
Rt14371 T2572 T3495 10199308.565324077
Gcorr4936 T2572 T3946 T2572 T3946 -1.4569612819255481e-07
Rt14372 T2572 T3950 2865916.8327118647
Rt14373 T2573 T2584 2465727.9400547487
Rt14374 T2573 T3482 996426.15239517717
Gcorr4937 T2573 T3586 T2573 T3586 -1.4497377533600531e-07
Rt14375 T2573 T3771 9442531.8946738318
Gcorr4938 T2573 T3817 T2573 T3817 -1.0085730526163995e-07
Gcorr4939 T2573 T4092 T2573 T4092 -2.1547701826397345e-07
Rt14376 T2575 T2647 23203181.788689934
Gcorr4940 T2575 T2687 T2575 T2687 -7.6693427820528384e-08
Rt14377 T2575 T3269 2646603.467114618
Rt14378 T2575 T3270 4588290.9189160289
Rt14379 T2575 T3271 2825596.5441100858
Rt14380 T2576 T2693 5020128.853032928
Rt14381 T2576 T2944 730735.26020583219
Rt14382 T2576 T3495 292153.21599624236
Rt14383 T2576 T3591 15724293.204064352
Gcorr4941 T2576 T3950 T2576 T3950 -2.8279970013331451e-06
Gcorr4942 T2577 T2578 T2577 T2578 -2.6722879252738741e-08
Rt14384 T2577 T2624 2888137.7712019021
Rt14385 T2577 T3044 1404757.5888909581
Gcorr4943 T2577 T3045 T2577 T3045 -1.0282428181288769e-07
Rt14386 T2577 T3164 2006839.1288872825
Gcorr4944 T2577 T3165 T2577 T3165 -4.4958936575037735e-07
Rt14387 T2578 T2671 2867408.8083998729
Gcorr4945 T2578 T3044 T2578 T3044 -5.2706761606462782e-08
Gcorr4946 T2578 T3050 T2578 T3050 -3.825721846557161e-07
Gcorr4947 T2578 T3165 T2578 T3165 -1.3781088190740028e-07
Rt14388 T2578 T4090 758734.82113267772
Gcorr4948 T2580 T3007 T2580 T3007 -7.4387844841893355e-07
Rt14389 T2580 T3008 6086626.9084498119
Rt14390 T2580 T3071 854595.02331353386
Gcorr4949 T2581 T2855 T2581 T2855 -9.5516422420775178e-07
Gcorr4950 T2581 T3572 T2581 T3572 -8.085549871879356e-08
Rt14391 T2581 T3589 2942490.0495495992
Rt14392 T2581 T3787 356987.71379306557
Rt14393 T2582 T2689 23583140.333147913
Rt14394 T2582 T2819 6996422.9545177771
Gcorr4951 T2582 T3543 T2582 T3543 -1.9287897748777458e-07
Rt14395 T2583 T2651 781570.90453341359
Rt14396 T2583 T2894 5156366.0354380747
Gcorr4952 T2583 T2895 T2583 T2895 -1.0125811383058422e-07
Gcorr4953 T2583 T2902 T2583 T2902 -9.477373319189899e-08
Rt14397 T2583 T3792 629490.01389596763
Gcorr4954 T2583 T4026 T2583 T4026 -1.0419643188640165e-06
Gcorr4955 T2584 T3482 T2584 T3482 -4.1972763821386298e-07
Gcorr4956 T2584 T3484 T2584 T3484 -1.1084485641865107e-08
Gcorr4957 T2584 T3586 T2584 T3586 -3.9767717625465889e-07
Rt14398 T2584 T4092 785958.98850987002
Gcorr4958 T2585 T3279 T2585 T3279 -4.0195436104746176e-07
Gcorr4959 T2585 T3281 T2585 T3281 -5.3567660436130366e-07
Gcorr4960 T2585 T3290 T2585 T3290 -5.4207875499370123e-07
Gcorr4961 T2585 T3518 T2585 T3518 -4.2464741293610944e-07
Rt14399 T2585 T4006 357822.79410800716
Rt14400 T2586 T2961 1360859.6381558843
Gcorr4962 T2586 T2962 T2586 T2962 -4.6802452060010084e-09
Rt14401 T2586 T3021 2882564.152125054
Rt14402 T2587 T3259 6986987.6422491381
Rt14403 T2587 T3354 20155722.666530285
Gcorr4963 T2587 T3965 T2587 T3965 -1.915713979165012e-08
Rt14404 T2587 T3966 2817597.4476106293
Rt14405 T2588 T2691 28973820.504670262
Gcorr4964 T2589 T3173 T2589 T3173 -1.4211505355847276e-07
Gcorr4965 T2589 T3428 T2589 T3428 -2.6127114475514531e-07
Rt14406 T2589 T3429 911402.57220890175
Rt14407 T2589 T3717 8074733.8374887118
Gcorr4966 T2589 T3907 T2589 T3907 -4.3139153275057601e-07
Rt14408 T2590 T3060 2608845.6347079203
Rt14409 T2590 T3089 2580477.2693835478
Gcorr4967 T2590 T3090 T2590 T3090 -1.0503853950059458e-07
Rt14410 T2591 T2652 14570712.220950119
Gcorr4968 T2591 T2988 T2591 T2988 -4.7408705508019283e-07
Rt14411 T2591 T3571 5267098.6947090449
Gcorr4969 T2591 T3830 T2591 T3830 -2.7459109615266409e-08
Gcorr4970 T2591 T3894 T2591 T3894 -8.1426725063275519e-08
Rt14412 T2591 T3934 499997.4474762514
Rt14413 T2592 T2684 58081007.137438521
Rt14414 T2592 T2685 26952179.987694584
Rt14415 T2592 T3988 236603.10564183726
Gcorr4971 T2592 T4079 T2592 T4079 -1.9463263589227326e-07
Rt14416 T2593 T2733 16306602.840869252
Gcorr4972 T2593 T3110 T2593 T3110 -8.0320881755609174e-08
Rt14417 T2593 T3461 2451397.6751959193
Rt14418 T2593 T4113 6741185.3414397668
Rt14419 T2593 T4141 1424389.9258480696
Gcorr4973 T2594 T2737 T2594 T2737 -1.3509155394721201e-07
Gcorr4974 T2594 T2926 T2594 T2926 -2.2860307682346154e-07
Rt14420 T2594 T3842 1900531.7709716146
Gcorr4975 T2595 T3233 T2595 T3233 -1.8237240820842113e-08
Rt14421 T2595 T3438 3645209.1713990183
Rt14422 T2595 T3473 751883.01374330884
Gcorr4976 T2595 T4104 T2595 T4104 -3.2819262878370647e-07
Rt14423 T2595 T4170 2109839.3201221586
Rt14424 T2596 T2688 3438018.3672319436
Rt14425 T2596 T2770 7781037.0564093487
Gcorr4977 T2596 T3859 T2596 T3859 -4.2813207935122366e-08
Gcorr4978 T2598 T2880 T2598 T2880 -5.0083160461694774e-08
Rt14426 T2598 T2881 5116686.4388922611
Rt14427 T2598 T2897 3194398.2751048487
Gcorr4979 T2598 T2911 T2598 T2911 -1.0492278174990526e-07
Gcorr4980 T2599 T2656 T2599 T2656 -1.3800298606983069e-07
Gcorr4981 T2599 T2928 T2599 T2928 -3.8345325740347445e-08
Rt14428 T2599 T3436 1962684.8393802692
Rt14429 T2599 T3987 3001898.9171563666
Rt14430 T2599 T3998 1025585.6914767653
Rt14431 T2600 T2657 5151413.314268305
Rt14432 T2600 T2840 404175.94482202613
Rt14433 T2600 T3978 7030665.0561494119
Gcorr4982 T2601 T3250 T2601 T3250 -4.7868008104038698e-07
Rt14434 T2601 T3253 1064438.960178161
Rt14435 T2601 T3329 3584503.7637179685
Gcorr4983 T2601 T3330 T2601 T3330 -9.0320509498657135e-08
Rt14436 T2602 T2686 7010330.1907263994
Gcorr4984 T2602 T3090 T2602 T3090 -3.3095064767027659e-06
Rt14437 T2602 T3092 237269.01814928028
Gcorr4985 T2602 T3093 T2602 T3093 -3.1588328642535851e-07
Rt14438 T2603 T2903 8368686.4557450395
Gcorr4986 T2603 T2908 T2603 T2908 -1.0270989936977556e-06
Rt14439 T2603 T2909 761033.35876826989
Rt14440 T2603 T3831 8362148.5862537837
Gcorr4987 T2604 T3223 T2604 T3223 -4.5582068242318253e-07
Rt14441 T2604 T3225 4606464.2856123447
Gcorr4988 T2604 T3497 T2604 T3497 -4.3323134209415595e-08
Rt14442 T2604 T3948 1364495.0035523016
Rt14443 T2605 T2670 37769345.157569177
Rt14444 T2605 T3386 1440782.3502216728
Gcorr4989 T2605 T3602 T2605 T3602 -1.6488817405090698e-07
Gcorr4990 T2605 T3761 T2605 T3761 -1.3918703999190393e-07
Rt14445 T2605 T4135 4392943.7924389029
Rt14446 T2606 T2607 5190676.4266186608
Rt14447 T2606 T2705 819195.51870576513
Gcorr4991 T2606 T3477 T2606 T3477 -8.8583902400745268e-07
Rt14448 T2606 T3478 20410900.196250334
Rt14449 T2606 T3479 596959.62370315008
Gcorr4992 T2606 T3480 T2606 T3480 -1.208867476189806e-07
Gcorr4993 T2607 T3478 T2607 T3478 -1.2821490059925256e-07
Rt14450 T2607 T3480 1573496.9712113321
Rt14451 T2607 T3483 4356549.4823998474
Rt14452 T2607 T3484 14078700.58068059
Gcorr4994 T2607 T3585 T2607 T3585 -1.4876280867910383e-07
Gcorr4995 T2608 T3381 T2608 T3381 -4.4302231392384737e-08
Rt14453 T2608 T3464 3663612.5246344465
Rt14454 T2608 T3465 2562862.1544667017
Rt14455 T2609 T2688 65211732.728230841
Gcorr4996 T2610 T3864 T2610 T3864 -3.6294920168653659e-08
Rt14456 T2611 T2719 1813483.2828745688
Rt14457 T2611 T3177 3945112.2328987145
Rt14458 T2611 T3781 1753092.8820866642
Rt14459 T2611 T4107 121017.58110857256
Gcorr4997 T2612 T3367 T2612 T3367 -1.0505548655524798e-06
Rt14460 T2612 T3369 528420.1509790686
Gcorr4998 T2612 T3678 T2612 T3678 -6.9829225804755447e-08
Gcorr4999 T2612 T3825 T2612 T3825 -2.2917343965132163e-07
Rt14461 T2613 T2867 6992054.673907049
Rt14462 T2613 T2873 2632474.7852276955
Rt14463 T2613 T2905 1959624.768697228
Gcorr5000 T2613 T2931 T2613 T2931 -5.0836392825778483e-07
Gcorr5001 T2614 T2967 T2614 T2967 -1.2039746803132634e-07
Rt14464 T2614 T2970 6016939.8453621585
Gcorr5002 T2614 T3161 T2614 T3161 -7.9763031946326455e-08
Rt14465 T2614 T3620 2492013.5419727382
Rt14466 T2615 T2933 1970998.507659357
Rt14467 T2615 T2997 1008846.9137510336
Gcorr5003 T2615 T2998 T2615 T2998 -1.164397421269103e-07
Rt14468 T2615 T4184 2418473.5306864767
Rt14469 T2616 T2775 19137831.091069665
Rt14470 T2616 T3902 7479547.2598491218
Rt14471 T2616 T3972 6444546.8658145731
Gcorr5004 T2617 T2857 T2617 T2857 -5.5879035572165106e-08
Rt14472 T2617 T3355 258620.77182103277
Gcorr5005 T2617 T3784 T2617 T3784 -2.6902229030815128e-07
Gcorr5006 T2618 T3611 T2618 T3611 -9.1292964154940707e-08
Rt14473 T2618 T3612 2691370.0735606984
Rt14474 T2618 T3677 10698598.349627061
Gcorr5007 T2618 T3678 T2618 T3678 -1.0788491155043093e-08
Rt14475 T2619 T2932 3277670.746927612
Gcorr5008 T2619 T3455 T2619 T3455 -3.4723485674431766e-07
Rt14476 T2619 T3456 503102.95260669629
Rt14477 T2620 T3148 2099353.7460397216
Gcorr5009 T2620 T3198 T2620 T3198 -1.7278738118535953e-07
Gcorr5010 T2620 T3222 T2620 T3222 -1.0824338111055392e-07
Rt14478 T2620 T4045 2452353.8563124086
Rt14479 T2621 T2684 4042723.7166178096
Rt14480 T2621 T3037 944411.05460855621
Gcorr5011 T2621 T3159 T2621 T3159 -1.9261588663842424e-07
Rt14481 T2621 T3334 2493416.5927030793
Rt14482 T2621 T3968 8783804.869355699
Rt14483 T2622 T3031 5528759.6137270052
Rt14484 T2622 T3168 4557617.5258604484
Rt14485 T2622 T3749 6202342.9421746302
Gcorr5012 T2622 T4115 T2622 T4115 -9.4857729519712825e-08
Rt14486 T2623 T2676 3148315.0358250197
Rt14487 T2623 T2810 636090.96023825754
Gcorr5013 T2623 T2811 T2623 T2811 -1.0517482542948354e-07
Rt14488 T2623 T2812 3833583.8264946258
Rt14489 T2623 T2816 14893587.187129129
Gcorr5014 T2623 T3922 T2623 T3922 -1.825365691106033e-07
Rt14490 T2624 T2704 2974975.4638389554
Rt14491 T2624 T2992 3382564.120495345
Rt14492 T2624 T3044 6846843.5756745897
Rt14493 T2624 T3045 1967264.9150558244
Rt14494 T2625 T3024 2097440.4063247382
Gcorr5015 T2625 T3209 T2625 T3209 -8.6092325777913287e-08
Rt14495 T2625 T3509 3359212.4389936309
Rt14496 T2625 T3840 1309528.0199820243
Rt14497 T2626 T3668 7751916.5875411928
Gcorr5016 T2626 T3895 T2626 T3895 -1.0961801583321171e-07
Rt14498 T2626 T4095 3163880.1947396733
Rt14499 T2627 T3617 466333972.71054333
Rt14500 T2627 T3628 2255630.6295287395
Rt14501 T2627 T3650 3399258.745488748
Gcorr5017 T2627 T3928 T2627 T3928 -3.6145355779637242e-07
Rt14502 T2628 T2737 1509626.6465113468
Gcorr5018 T2628 T3717 T2628 T3717 -9.654090987482356e-09
Gcorr5019 T2628 T3718 T2628 T3718 -2.8673676166731817e-07
Rt14503 T2629 T2963 9145363.6025911588
Gcorr5020 T2629 T3605 T2629 T3605 -3.4365917566517219e-07
Gcorr5021 T2629 T3708 T2629 T3708 -2.2117961394427143e-07
Rt14504 T2629 T3875 1151325.922624422
Gcorr5022 T2629 T3932 T2629 T3932 -1.0194958923312266e-07
Rt14505 T2630 T2648 1602073.7760525011
Rt14506 T2630 T3049 3908340.817237142
Rt14507 T2630 T3087 714729.9505232753
Gcorr5023 T2630 T3793 T2630 T3793 -1.5220107004015634e-07
Gcorr5024 T2630 T4147 T2630 T4147 -7.8446367991372147e-07
Rt14508 T2632 T2675 3225796.200174924
Rt14509 T2632 T3101 1952591.2408829359
Gcorr5025 T2632 T3799 T2632 T3799 -1.5801375613073517e-06
Rt14510 T2632 T3810 325351.8587990636
Rt14511 T2632 T3938 11486870.920118842
Rt14512 T2633 T2662 911206.44028888375
Gcorr5026 T2633 T2939 T2633 T2939 -1.0274963041483943e-06
Rt14513 T2633 T3008 7573993.505449825
Rt14514 T2633 T3073 17573055.427958891
Gcorr5027 T2633 T3662 T2633 T3662 -5.4540282430106598e-07
Rt14515 T2633 T4015 382468.26731756504
Rt14516 T2634 T3015 1996900.7947940163
Gcorr5028 T2634 T3016 T2634 T3016 -1.5951813515238869e-07
Rt14517 T2634 T3055 3713415.7682539802
Rt14518 T2634 T3200 11003948.167829677
Rt14519 T2635 T2932 872113.63017801743
Gcorr5029 T2635 T3495 T2635 T3495 -1.8759422974727469e-07
Rt14520 T2635 T3946 868546.02725902235
Rt14521 T2636 T2783 2307752.0008209152
Rt14522 T2636 T4009 2860165.9156183666
Gcorr5030 T2636 T4140 T2636 T4140 -1.0545970414569184e-07
Rt14523 T2637 T2797 4090215.8054266083
Rt14524 T2637 T3360 13038290.977847371
Gcorr5031 T2637 T3724 T2637 T3724 -5.5332935264635412e-08
Rt14525 T2637 T3918 14129493.934837284
Rt14526 T2638 T2703 13378032.419645226
Gcorr5032 T2638 T3328 T2638 T3328 -1.2151348910144793e-07
Rt14527 T2638 T3331 3444415.4488009554
Gcorr5033 T2638 T3974 T2638 T3974 -5.1106953762764802e-07
Rt14528 T2638 T3995 11724202.442466596
Rt14529 T2638 T4098 1718577.7506218692
Rt14530 T2639 T2849 5501714.8409560081
Gcorr5034 T2639 T2851 T2639 T2851 -4.1407092534400416e-08
Gcorr5035 T2639 T2887 T2639 T2887 -1.3319873580341384e-07
Rt14531 T2639 T3791 2516520.7827772372
Gcorr5036 T2640 T3094 T2640 T3094 -1.5889039076517428e-07
Rt14532 T2640 T3095 1357123.6941245603
Rt14533 T2640 T3096 6384204.2003673799
Gcorr5037 T2640 T3097 T2640 T3097 -1.3854157695169284e-07
Rt14534 T2641 T2715 2711302.5266284207
Rt14535 T2641 T3088 16440536.00635661
Rt14536 T2641 T3118 6142969.9463956868
Rt14537 T2641 T3457 1770967.6728129413
Gcorr5038 T2642 T3002 T2642 T3002 -8.9930649143913169e-07
Rt14538 T2642 T3417 4002403.6996577675
Gcorr5039 T2642 T3434 T2642 T3434 -1.2668961824254881e-07
Rt14539 T2642 T3846 619416.29982346517
Rt14540 T2643 T2886 10668004.024488531
Rt14541 T2643 T3877 4265918.1438548332
Rt14542 T2643 T3929 42701457.423372678
Rt14543 T2645 T3345 950643.33361455135
Gcorr5040 T2645 T3699 T2645 T3699 -2.7624742845107934e-07
Gcorr5041 T2645 T3827 T2645 T3827 -6.0580647836048513e-07
Gcorr5042 T2645 T4002 T2645 T4002 -8.8596675281185552e-09
Rt14544 T2645 T4081 3164846.257466902
Gcorr5043 T2645 T4144 T2645 T4144 -9.7539802696431781e-08
Rt14545 T2646 T3777 8524178.2230023108
Rt14546 T2646 T4080 71462.194979069434
Rt14547 T2647 T3267 3061862.2289477889
Gcorr5044 T2647 T3268 T2647 T3268 -7.8778967003724132e-08
Rt14548 T2647 T3269 1514826.1022369443
Gcorr5045 T2647 T3681 T2647 T3681 -1.4599340702886534e-07
Rt14549 T2648 T2666 7213128.414514076
Gcorr5046 T2648 T3086 T2648 T3086 -2.9218860184778864e-07
Gcorr5047 T2648 T3087 T2648 T3087 -7.0335763126686837e-07
Rt14550 T2648 T3423 15576194.786618685
Rt14551 T2648 T4147 742597.0301941504
Rt14552 T2650 T2722 3404903.3900545621
Rt14553 T2650 T2744 5726750.8977302946
Rt14554 T2650 T3848 2960302.3622739143
Gcorr5048 T2650 T3943 T2650 T3943 -1.5519759955841442e-07
Rt14555 T2651 T2895 3696619.9483497846
Rt14556 T2651 T2916 5114971.390028757
Gcorr5049 T2651 T3792 T2651 T3792 -9.574458927471366e-07
Rt14557 T2651 T4026 1014165.0167472987
Gcorr5050 T2652 T3571 T2652 T3571 -7.6293078928906092e-08
Rt14558 T2652 T3572 1397650.5514853203
Rt14559 T2652 T3894 833484.8434942048
Gcorr5051 T2653 T3208 T2653 T3208 -3.8101626485263756e-07
Rt14560 T2653 T3837 371870.30164377129
Gcorr5052 T2654 T2834 T2654 T2834 -3.0305821744172853e-07
Gcorr5053 T2654 T3359 T2654 T3359 -9.0755941286543232e-08
Rt14561 T2654 T3805 965309.07845211099
Rt14562 T2655 T2929 1786440.1571458313
Gcorr5054 T2655 T3763 T2655 T3763 -2.324850073896826e-07
Rt14563 T2655 T3982 12345988.556322105
Gcorr5055 T2655 T4088 T2655 T4088 -1.0348212460824692e-07
Gcorr5056 T2656 T3319 T2656 T3319 -4.1844256162490354e-07
Rt14564 T2656 T3321 1685313.4332452957
Rt14565 T2656 T3323 875821.55669765756
Rt14566 T2656 T3998 1704653.3090539696
Gcorr5057 T2656 T4108 T2656 T4108 -2.3731965888198683e-07
Rt14567 T2657 T2840 942854.68219932157
Rt14568 T2657 T3430 885553.15532383381
Rt14569 T2657 T3951 924563.79618082603
Gcorr5058 T2657 T3978 T2657 T3978 -2.9004423008443078e-07
Gcorr5059 T2657 T4106 T2657 T4106 -5.8675504420146246e-07
Rt14570 T2658 T3712 446526.04597766447
Rt14571 T2658 T4108 980315.3990925604
Gcorr5060 T2659 T3012 T2659 T3012 -4.3993025984218817e-07
Rt14572 T2659 T3372 3057939.6445555938
Rt14573 T2659 T4124 1739205.5225469817
Gcorr5061 T2660 T2746 T2660 T2746 -1.190946262434667e-08
Gcorr5062 T2660 T3332 T2660 T3332 -8.8598244054688903e-08
Gcorr5063 T2660 T3450 T2660 T3450 -1.2423138578232857e-07
Rt14574 T2660 T3901 4005624.7772613885
Rt14575 T2660 T4169 3897272.18548303
Rt14576 T2661 T3140 505260.47233207751
Gcorr5064 T2661 T3725 T2661 T3725 -1.7349870021260711e-06
Rt14577 T2661 T3726 1863281.4293052582
Rt14578 T2661 T3727 9794165.2031514328
Rt14579 T2662 T2939 561070.34841539536
Rt14580 T2662 T3007 3794976.884451576
Rt14581 T2662 T3008 2989838.2459849087
Gcorr5065 T2662 T4015 T2662 T4015 -1.0243472732328785e-06
Gcorr5066 T2663 T3100 T2663 T3100 -1.8699484402957675e-07
Rt14582 T2663 T3205 1199187.5798206399
Gcorr5067 T2663 T3426 T2663 T3426 -1.1569191912771465e-07
Rt14583 T2663 T3442 4085790.0602787738
Gcorr5068 T2663 T3890 T2663 T3890 -3.3550371058110888e-07
Gcorr5069 T2664 T3503 T2664 T3503 -4.9260737111462454e-08
Rt14584 T2664 T3694 6736462.1182161067
Gcorr5070 T2664 T3892 T2664 T3892 -3.0700204793928973e-08
Rt14585 T2664 T3937 3336107.2324798587
Rt14586 T2665 T2878 501179.60756215086
Rt14587 T2665 T2925 6233987.2316175457
Rt14588 T2665 T3512 979756.6439346415
Gcorr5071 T2665 T4012 T2665 T4012 -1.7216387276124512e-07
Rt14589 T2666 T3086 2058678.7456636678
Gcorr5072 T2666 T3207 T2666 T3207 -1.850921474850454e-07
Rt14590 T2666 T3422 4959234.3931145072
Gcorr5073 T2666 T3423 T2666 T3423 -1.1667795973996269e-07
Gcorr5074 T2667 T2896 T2667 T2896 -2.2447849772383538e-08
Rt14591 T2667 T2984 2949465.9629673241
Rt14592 T2667 T3219 8768822.3999948613
Gcorr5075 T2668 T3311 T2668 T3311 -7.8201336233177028e-08
Rt14593 T2668 T3312 3078828.6081174612
Rt14594 T2668 T3785 4846710.4806995289
Rt14595 T2669 T2772 27709624.571072008
Rt14596 T2669 T3452 4678737.5572386254
Rt14597 T2669 T3513 8738728.6302563045
Gcorr5076 T2669 T3832 T2669 T3832 -5.4088196971181928e-08
Rt14598 T2670 T2690 2833018.5266384631
Gcorr5077 T2670 T3386 T2670 T3386 -1.2397391305231961e-07
Gcorr5078 T2670 T3387 T2670 T3387 -5.497176870793348e-07
Gcorr5079 T2670 T3393 T2670 T3393 -5.2768521341211444e-07
Rt14599 T2670 T3723 3233479.4874717784
Rt14600 T2670 T3783 474955.24769365817
Gcorr5080 T2670 T4041 T2670 T4041 -6.0811280676287273e-07
Rt14601 T2671 T3165 2705078.2824113118
Gcorr5081 T2671 T3684 T2671 T3684 -1.2684414286190333e-07
Rt14602 T2671 T3736 4609995.9597554281
Gcorr5082 T2671 T4090 T2671 T4090 -1.0647406936843555e-07
Rt14603 T2672 T3131 2000386.8207647647
Gcorr5083 T2672 T3617 T2672 T3617 -2.7145347910405083e-07
Rt14604 T2672 T3618 7827075.4402129995
Rt14605 T2672 T4035 25624280.346943066
Gcorr5084 T2673 T3418 T2673 T3418 -1.0350173549221631e-07
Rt14606 T2673 T3419 2601228.7111127647
Rt14607 T2673 T3420 4307674.2358096065
Gcorr5085 T2673 T3421 T2673 T3421 -7.6054318827377868e-08
Gcorr5086 T2674 T3043 T2674 T3043 -1.1685034923422582e-07
Rt14608 T2674 T3076 2509501.8397322255
Gcorr5087 T2674 T3738 T2674 T3738 -1.3474154768217172e-07
Rt14609 T2674 T3955 4170668.8080412303
Gcorr5088 T2675 T3006 T2675 T3006 -4.1907184491345968e-07
Rt14610 T2675 T3136 1487884.1818738964
Gcorr5089 T2675 T3810 T2675 T3810 -9.0886529635548479e-07
Rt14611 T2675 T3938 540737.93481874559
Rt14612 T2676 T2808 3466045.9658334819
Gcorr5090 T2676 T2810 T2676 T2810 -4.7275262522086964e-08
Rt14613 T2676 T3922 803916.83910527278
Gcorr5091 T2676 T3977 T2676 T3977 -1.1539498608451271e-07
Rt14614 T2677 T2853 4311013.0114935171
Rt14615 T2677 T3615 11501618.810606722
Gcorr5092 T2677 T4152 T2677 T4152 -8.5197757644080013e-08
Gcorr5093 T2678 T3244 T2678 T3244 -5.7334894458436799e-07
Gcorr5094 T2678 T3361 T2678 T3361 -4.4951651602138285e-07
Gcorr5095 T2678 T3366 T2678 T3366 -3.4722429334839536e-07
Rt14616 T2678 T3970 212645.78897719405
Gcorr5096 T2678 T4072 T2678 T4072 -2.0124758243961816e-06
Gcorr5097 T2678 T4166 T2678 T4166 -6.1466502321012641e-07
Rt14617 T2679 T3083 978414.75177241326
Rt14618 T2679 T3371 2009010.3804815032
Rt14619 T2679 T3610 1813921.7742704055
Gcorr5098 T2679 T3824 T2679 T3824 -1.7329028628885472e-07
Gcorr5099 T2680 T2847 T2680 T2847 -3.8302968484574554e-07
Rt14620 T2680 T2898 3090097.888175488
Rt14621 T2680 T3748 460605.9597261413
Rt14622 T2681 T3053 1853085.4767250463
Rt14623 T2682 T3004 411152.72442536306
Gcorr5100 T2682 T4135 T2682 T4135 -7.3558410436085481e-07
Gcorr5101 T2683 T3125 T2683 T3125 -5.018913037130639e-08
Gcorr5102 T2683 T3174 T2683 T3174 -6.6923572984048262e-07
Rt14624 T2683 T3175 700290.32682449732
Rt14625 T2683 T3487 9710080.0779815651
Rt14626 T2684 T2685 6722666.8580628633
Rt14627 T2684 T3159 3123803.9257245422
Rt14628 T2684 T3334 784102.72640086769
Rt14629 T2684 T3709 1994448.9416716897
Rt14630 T2684 T3988 7600417.162018232
Rt14631 T2685 T3709 325632.98767595261
Gcorr5103 T2685 T3710 T2685 T3710 -8.2302811736342905e-07
Rt14632 T2685 T3988 4667030.971653468
Rt14633 T2686 T3092 14359386.859157369
Rt14634 T2686 T3094 9507048.975761164
Rt14635 T2686 T3204 3303604.7281618523
Gcorr5104 T2686 T3811 T2686 T3811 -1.2224053543230507e-07
Rt14636 T2687 T3271 1178224.1087809871
Rt14637 T2687 T3523 30635976.192093529
Rt14638 T2687 T3985 7501522.6581062181
Gcorr5105 T2687 T4083 T2687 T4083 -2.781532223055454e-07
Rt14639 T2687 T4175 842535.62144004973
Gcorr5106 T2688 T3562 T2688 T3562 -4.9337024070686932e-08
Rt14640 T2688 T3859 3089101.2311448683
Gcorr5107 T2689 T2785 T2689 T2785 -2.6843409750619675e-07
Gcorr5108 T2690 T2994 T2690 T2994 -3.4158564752942012e-07
Gcorr5109 T2690 T3385 T2690 T3385 -3.5843720344797719e-07
Rt14641 T2690 T3387 442143.01172196219
Gcorr5110 T2690 T3783 T2690 T3783 -7.7411224333362899e-07
Rt14642 T2692 T2734 10546472.512871278
Rt14643 T2692 T2777 750891.18664468906
Rt14644 T2692 T3447 12183357.49406388
Gcorr5111 T2692 T3566 T2692 T3566 -3.535914104257418e-07
Rt14645 T2692 T3606 12687881.460262418
Gcorr5112 T2692 T4055 T2692 T4055 -8.7660702015093646e-07
Rt14646 T2693 T2944 700896.09792827582
Gcorr5113 T2693 T3776 T2693 T3776 -4.2505551598834637e-07
Gcorr5114 T2694 T3050 T2694 T3050 -4.7174607542353761e-08
Rt14647 T2694 T3229 3948664.9128116085
Rt14648 T2694 T3230 2977860.5880610528
Gcorr5115 T2694 T3841 T2694 T3841 -1.0318219245794263e-07
Gcorr5116 T2695 T2982 T2695 T2982 -7.6501548185113539e-08
Rt14649 T2695 T3606 16395722.468792198
Rt14650 T2695 T3892 4253562.8796371948
Gcorr5117 T2697 T3274 T2697 T3274 -1.3515824093127041e-08
Rt14651 T2697 T3348 2310519.1659584795
Rt14652 T2697 T3786 4480909.3391307555
Gcorr5118 T2697 T4043 T2697 T4043 -7.7408078891565512e-08
Gcorr5119 T2698 T2816 T2698 T2816 -5.2634630176070692e-07
Rt14653 T2698 T2817 273253.84720378258
Gcorr5120 T2698 T2820 T2698 T2820 -3.7751355474334936e-07
Gcorr5121 T2698 T2821 T2698 T2821 -7.8845233278134982e-07
Rt14654 T2699 T2731 7275561.9213108802
Gcorr5122 T2699 T3169 T2699 T3169 -2.2263465649790506e-07
Gcorr5123 T2699 T3439 T2699 T3439 -7.9520165648144148e-08
Rt14655 T2699 T3944 869662.35979234159
Rt14656 T2699 T4004 1366811.2122426482
Gcorr5124 T2701 T3209 T2701 T3209 -4.4152941152692982e-07
Rt14657 T2701 T3210 483542.07378880936
Gcorr5125 T2701 T3502 T2701 T3502 -6.9935199816133624e-07
Gcorr5126 T2701 T3734 T2701 T3734 -3.5366685897000651e-07
Rt14658 T2702 T2981 9451498.7372134477
Gcorr5127 T2702 T3080 T2702 T3080 -1.6966654667913606e-07
Rt14659 T2702 T3081 1189620.0054194923
Gcorr5128 T2702 T3082 T2702 T3082 -1.1161607152335932e-07
Gcorr5129 T2703 T2780 T2703 T2780 -2.9878360355057828e-08
Rt14660 T2703 T3795 1192302.213001265
Gcorr5130 T2703 T3796 T2703 T3796 -3.4116818301412528e-07
Gcorr5131 T2703 T3974 T2703 T3974 -3.8220716314721397e-07
Rt14661 T2703 T4098 4861994.6438837415
Gcorr5132 T2704 T2937 T2704 T2937 -4.8127335789672654e-07
Gcorr5133 T2704 T2991 T2704 T2991 -1.8339205707214661e-07
Rt14662 T2704 T2992 538460.98826557095
Gcorr5134 T2704 T3044 T2704 T3044 -1.1584415577698827e-07
Gcorr5135 T2705 T3476 T2705 T3476 -7.6767916763213984e-08
Rt14663 T2705 T3477 972239.61233847425
Rt14664 T2705 T3478 3094439.7921282505
Gcorr5136 T2705 T3479 T2705 T3479 -8.6927485682858429e-07
Rt14665 T2706 T2713 3775575.8116053422
Rt14666 T2706 T3380 3998811.1809760272
Gcorr5137 T2706 T3770 T2706 T3770 -8.9254937283485513e-08
Rt14667 T2706 T3772 5115092.1907290295
Rt14668 T2707 T2942 395340.16804756515
Rt14669 T2707 T3799 2555948.3676118702
Gcorr5138 T2708 T3098 T2708 T3098 -3.2093082915906832e-08
Rt14670 T2708 T3149 38860174.08211349
Rt14671 T2708 T3522 2795378.8130883644
Gcorr5139 T2708 T4103 T2708 T4103 -7.9743146853253215e-09
Gcorr5140 T2709 T3185 T2709 T3185 -5.5753113136741485e-07
Gcorr5141 T2709 T3636 T2709 T3636 -1.240330179737131e-07
Gcorr5142 T2709 T3637 T2709 T3637 -3.4212418339334412e-08
Rt14672 T2709 T4153 833414.30883529759
Rt14673 T2710 T3293 3025731.8241092074
Rt14674 T2710 T3297 8714053.2050632201
Rt14675 T2710 T3353 6159539.3103619693
Gcorr5143 T2712 T3226 T2712 T3226 -1.2400484776488796e-07
Rt14676 T2712 T3227 3206421.5879627941
Rt14677 T2712 T3566 53777436.212664105
Rt14678 T2712 T3609 6128058.0460933177
Rt14679 T2713 T3374 1385823.8755846655
Gcorr5144 T2713 T3376 T2713 T3376 -2.8756579724828344e-07
Rt14680 T2713 T3380 6861133.2552432371
Gcorr5145 T2713 T3772 T2713 T3772 -1.8260169400513009e-07
Rt14681 T2714 T2941 2207868.7521225745
Rt14682 T2714 T3013 1601013.4123506364
Rt14683 T2714 T3034 18213600.382505026
Rt14684 T2715 T3118 5372782.9498022124
Gcorr5146 T2715 T3457 T2715 T3457 -1.2278450921425263e-07
Rt14685 T2715 T3536 3442055.7341791685
Gcorr5147 T2717 T3261 T2717 T3261 -4.6469850048359545e-07
Rt14686 T2717 T3262 832735.48288597912
Rt14687 T2717 T3263 6897022.7557930751
Rt14688 T2717 T3267 6640160.1548070228
Gcorr5148 T2717 T4144 T2717 T4144 -3.5169070091983436e-07
Rt14689 T2718 T3145 23465634.286019575
Gcorr5149 T2718 T3700 T2718 T3700 -1.9474668293281542e-07
Rt14690 T2718 T3861 3360899.0114941122
Rt14691 T2718 T4051 4680923.6562231872
Rt14692 T2719 T2858 4101660.1444577142
Rt14693 T2719 T3781 372581.80061407387
Gcorr5150 T2719 T4107 T2719 T4107 -6.0797259121640722e-07
Rt14694 T2721 T3635 9220575.1080007479
Rt14695 T2721 T3637 9704694.1445974037
Gcorr5151 T2721 T3639 T2721 T3639 -2.223997468716036e-08
Rt14696 T2721 T3730 4248546.3361202572
Rt14697 T2722 T2744 17719289.960094452
Gcorr5152 T2722 T3342 T2722 T3342 -9.6965587820374789e-08
Gcorr5153 T2722 T3646 T2722 T3646 -1.544004065225941e-07
Rt14698 T2722 T3943 4283617.5908835651
Rt14699 T2722 T4132 4189983.7988599497
Rt14700 T2724 T3066 6664239.2238757778
Rt14701 T2724 T3103 4650429.3085538708
Rt14702 T2724 T3163 1780667.0545549623
Gcorr5154 T2724 T4161 T2724 T4161 -1.3591410572929795e-07
Gcorr5155 T2724 T4177 T2724 T4177 -3.6615683747729423e-07
Gcorr5156 T2725 T3150 T2725 T3150 -1.5598000947112261e-07
Rt14703 T2725 T3335 97098412.648661464
Gcorr5157 T2725 T3668 T2725 T3668 -5.3592322035963863e-07
Rt14704 T2725 T4086 1092761.3949964349
Rt14705 T2727 T2729 4488736.3831742788
Gcorr5158 T2727 T3029 T2727 T3029 -2.0171324124964484e-08
Rt14706 T2727 T3179 713042.71112144378
Rt14707 T2727 T3180 10092459.634785188
Gcorr5159 T2727 T3183 T2727 T3183 -3.3780939952380403e-07
Gcorr5160 T2727 T3508 T2727 T3508 -2.5536285584786543e-07
Gcorr5161 T2728 T2996 T2728 T2996 -1.00972998192033e-06
Gcorr5162 T2728 T3375 T2728 T3375 -3.6129723347091332e-07
Gcorr5163 T2728 T3382 T2728 T3382 -4.858505283574445e-07
Rt14708 T2728 T3963 351940.59256575379
Gcorr5164 T2728 T3984 T2728 T3984 -8.6528178707129445e-08
Gcorr5165 T2729 T2973 T2729 T2973 -5.0797238622959806e-07
Rt14709 T2729 T3028 2131293.9883440845
Gcorr5166 T2729 T3179 T2729 T3179 -1.8558959344540096e-06
Rt14710 T2729 T3183 486884.62552723225
Rt14711 T2729 T3933 1559873.1914806922
Gcorr5167 T2730 T3531 T2730 T3531 -4.4214924395341621e-08
Gcorr5168 T2730 T3834 T2730 T3834 -3.766660669300126e-07
Rt14712 T2730 T3885 1366245.330826411
Gcorr5169 T2731 T3027 T2731 T3027 -1.5936647741508615e-07
Rt14713 T2731 T3439 11556550.413957505
Rt14714 T2731 T3912 2607701.2811479615
Rt14715 T2731 T4004 12521229.194737528
Rt14716 T2731 T4044 870852.73510125116
Rt14717 T2732 T3141 5270737.3342342395
Rt14718 T2732 T4078 4797480.0100115146
Gcorr5170 T2732 T4143 T2732 T4143 -5.971615125824254e-08
Rt14719 T2733 T3127 3586935.7778795944
Gcorr5171 T2733 T3129 T2733 T3129 -9.9889481894190448e-08
Rt14720 T2733 T3437 2927343.0178874782
Rt14721 T2733 T4141 6129607.9222243261
Rt14722 T2734 T2777 17192965.078286454
Rt14723 T2734 T3964 3752226.7569855903
Rt14724 T2735 T3534 2142778.3295965292
Rt14725 T2735 T3701 1702291.3056928534
Rt14726 T2735 T3876 2530221.8549618805
Rt14727 T2735 T3884 571428.45389471808
Gcorr5172 T2735 T4384 T2735 T4384 -3.7175341355644413e-07
Rt14728 T2735 T4385 929089.59601674124
Gcorr5173 T2735 T4386 T2735 T4386 -2.1760663169215915e-07
Rt14729 T2735 T4388 11691046.062992934
Gcorr5174 T2735 T4770 T2735 T4770 -1.5384077685697305e-07
Rt14730 T2736 T3691 1485330.4875585148
Rt14731 T2736 T4156 1121070.7008662182
Rt14732 T2736 T4163 1020299.8738370547
Gcorr5175 T2736 T4191 T2736 T4191 -2.5653195735336837e-08
Rt14733 T2736 T4524 8322576.6384681305
Rt14734 T2736 T4526 22249878.706038792
Rt14735 T2736 T5718 4758723.6567336656
Gcorr5176 T2736 T5767 T2736 T5767 -3.0110888106144109e-08
Rt14736 T2737 T3428 11153377.78525619
Rt14737 T2737 T3717 1456253.97528902
Rt14738 T2737 T3718 1140418.6006252784
Rt14739 T2737 T3842 1499511.8536978541
Gcorr5177 T2737 T5360 T2737 T5360 -1.2751848664304111e-07
Rt14740 T2737 T5361 17337992.199363802
Gcorr5178 T2737 T5551 T2737 T5551 -1.2825946670945618e-08
Gcorr5179 T2737 T5948 T2737 T5948 -1.3509155394694824e-07
Rt14741 T2737 T5982 1509626.6465115896
Gcorr5180 T2738 T3539 T2738 T3539 -5.2607555153575045e-09
Rt14742 T2738 T3878 1203175.7867004238
Rt14743 T2738 T4050 898495.19834114541
Rt14744 T2738 T4111 1976998.1269703191
Rt14745 T2738 T4319 2523412.5950855529
Gcorr5181 T2738 T5220 T2738 T5220 -1.1020785320188742e-07
Gcorr5182 T2738 T5727 T2738 T5727 -5.1867677469635569e-08
Rt14746 T2738 T5871 23407759.022778243
Rt14747 T2739 T3547 268216308.74474338
Rt14748 T2739 T3704 1724208.1528495341
Rt14749 T2739 T3908 5240329.2394569051
Rt14750 T2739 T4145 4736087.0426214654
Rt14751 T2739 T4158 1149570.1990886524
Rt14752 T2739 T4537 12927045.009452779
Rt14753 T2739 T4540 4541575.2598705171
Rt14754 T2739 T5440 11858307.037104016
Rt14755 T2740 T3527 20495946.620045032
Rt14756 T2740 T3693 2790908.5151864942
Rt14757 T2740 T3898 2696380.3302273047
Rt14758 T2740 T4054 1198353.492849123
Rt14759 T2740 T4371 2700519.7221358628
Gcorr5183 T2740 T4372 T2740 T4372 -1.0411215632726986e-07
Rt14760 T2740 T4373 8562428.6813079175
Rt14761 T2741 T3443 19899043.385804668
Rt14762 T2741 T3834 3821549.3378733145
Rt14763 T2741 T3874 913970.4699261043
Rt14764 T2741 T3885 1221647.4531218132
Rt14765 T2741 T4841 3587380.5500363302
Gcorr5184 T2741 T5270 T2741 T5270 -1.1224784725418968e-07
Rt14766 T2741 T5593 6828318.7395381089
Rt14767 T2742 T3629 1601021.9767319604
Rt14768 T2742 T3647 2034344.8246034987
Rt14769 T2742 T3711 4091944.9450426884
Rt14770 T2742 T4160 1003353.0362021583
Rt14771 T2742 T4257 2491477.4337419784
Gcorr5185 T2742 T4907 T2742 T4907 -1.2387951560196944e-07
Rt14772 T2742 T5489 8892385.2336142492
Rt14773 T2743 T3642 3323532.6017424711
Rt14774 T2743 T3643 1646392.7697429184
Rt14775 T2743 T3758 1457840.5256917258
Rt14776 T2743 T3980 6654141.0589444805
Rt14777 T2743 T4993 18627449.675807536
Rt14778 T2743 T5066 2011600.5921522756
Rt14779 T2743 T5236 13232028.878544604
Gcorr5186 T2743 T5375 T2743 T5375 -1.7139756541691445e-07
Rt14780 T2744 T3646 2378093.6946254792
Rt14781 T2744 T3848 2869720.1107291044
Rt14782 T2744 T3943 1871086.5457239917
Rt14783 T2744 T4132 2474356.7201108513
Rt14784 T2744 T5311 7356582.0188526455
Rt14785 T2744 T6004 5726750.8977276376
Rt14786 T2744 T6077 17719289.960094679
Rt14787 T2745 T3042 21892310.535429522
Rt14788 T2745 T3043 1746682.0885756377
Rt14789 T2745 T3075 1795723.8032176711
Rt14790 T2745 T4056 2278028.9474099139
Rt14791 T2745 T4403 3424185.6617634916
Gcorr5187 T2745 T4404 T2745 T4404 -8.2124966963224822e-08
Rt14792 T2745 T4415 3034472.8567784568
Gcorr5188 T2745 T5125 T2745 T5125 -1.4897015040703189e-07
Rt14793 T2746 T3813 4808687.9507288188
Rt14794 T2746 T3901 1735532.8827212926
Rt14795 T2746 T4127 1000770.2820705257
Rt14796 T2746 T4169 1013977.1637670983
Gcorr5189 T2746 T5215 T2746 T5215 -2.1878073715162083e-07
Rt14797 T2746 T5525 1755646.2101808295
Gcorr5190 T2746 T6014 T2746 T6014 -1.1909462623961028e-08
Rt14798 T2747 T3618 2162342.6072388925
Rt14799 T2747 T3627 1980256.599605029
Rt14800 T2747 T3650 1670021.8191557855
Rt14801 T2747 T3893 2627216.0175839043
Rt14802 T2747 T4452 7066436.42696336
Rt14803 T2747 T4453 9431847.00186361
Rt14804 T2747 T4454 3544253.5836459626
Gcorr5191 T2747 T5778 T2747 T5778 -1.0009663369629462e-07
Rt14805 T2748 T3632 1828270.1613906308
Rt14806 T2748 T3633 3548741.6712279776
Rt14807 T2748 T3634 1935960.0365294029
Rt14808 T2748 T3648 3524268.8116111946
Gcorr5192 T2748 T4421 T2748 T4421 -4.1666018835009398e-07
Rt14809 T2748 T4609 2961736.7985151736
Rt14810 T2748 T4610 2382332.2294449676
Rt14811 T2748 T4699 10724219.495381622
Rt14812 T2749 T3489 11450040.424110567
Rt14813 T2749 T3630 1427184.1216540628
Rt14814 T2749 T3644 5059054.5396337816
Rt14815 T2749 T4070 1109342.1411049783
Rt14816 T2749 T4896 4159415.932245716
Rt14817 T2749 T5001 10578699.406582545
Rt14818 T2749 T5393 9455927.3803860825
Rt14819 T2750 T3503 3265471.3978689518
Rt14820 T2750 T3683 6839303.8837430784
Rt14821 T2750 T3694 3801855.3867657217
Rt14822 T2750 T3873 1503800.0784222553
Rt14823 T2750 T4005 1557989.082292839
Gcorr5193 T2750 T4508 T2750 T4508 -1.6595781689926344e-07
Rt14824 T2750 T4510 3722648.6005690522
Rt14825 T2750 T4513 17511706.711329777
Rt14826 T2750 T5480 3491120.3403275791
Rt14827 T2751 T3588 4695318.5112467529
Rt14828 T2751 T3599 24968242.666365236
Rt14829 T2751 T3913 1026709.3431798267
Rt14830 T2751 T3971 987329.85004100681
Rt14831 T2751 T4097 523641340.19338852
Rt14832 T2751 T4359 1960522.7599174706
Rt14833 T2751 T4620 9531434.2124012746
Gcorr5194 T2751 T5267 T2751 T5267 -1.1659922837948138e-07
Rt14834 T2752 T2966 1654622.8168968025
Rt14835 T2752 T2967 1641813.4415503256
Rt14836 T2752 T3620 5499355.9864868531
Rt14837 T2752 T3853 1372787.523327834
Rt14838 T2752 T4611 3319428.8658785992
Gcorr5195 T2752 T4695 T2752 T4695 -1.2346488205211912e-07
Gcorr5196 T2752 T5477 T2752 T5477 -8.5007585496545622e-08
Rt14839 T2752 T5478 2819671.6773057766
Rt14840 T2753 T3516 2128301.599438217
Gcorr5197 T2753 T3524 T2753 T3524 -2.42959251664112e-08
Rt14841 T2753 T3870 3217586.7063335977
Rt14842 T2753 T3976 2372764.9596581906
Rt14843 T2753 T4189 1144778.5453323571
Rt14844 T2753 T4464 3271815.8509755568
Rt14845 T2753 T5327 31096122.941125713
Rt14846 T2753 T5545 7861399.9699045848
Rt14847 T2754 T3686 1189652.721972459
Rt14848 T2754 T3687 941312.22754869191
Rt14849 T2754 T3732 3956835.6108498662
Rt14850 T2754 T3820 3290124.8918518964
Rt14851 T2754 T4335 1337096.9314710074
Gcorr5198 T2754 T4337 T2754 T4337 -1.5075531280690121e-07
Rt14852 T2754 T4338 13761337.167349787
Gcorr5199 T2754 T5413 T2754 T5413 -2.7724706847908726e-07
Rt14853 T2755 T3505 2631416.9326508902
Rt14854 T2755 T3836 1572112.8806295146
Rt14855 T2755 T3865 809429.41663811053
Rt14856 T2755 T3869 2345080.9056695933
Rt14857 T2755 T4551 1622415.7824296881
Gcorr5200 T2755 T5540 T2755 T5540 -1.3357782562401765e-07
Gcorr5201 T2755 T5768 T2755 T5768 -1.5518703319744832e-07
Rt14858 T2756 T3448 14178131.546039071
Rt14859 T2756 T3449 2767808.9891231428
Rt14860 T2756 T3891 1025732.5384682252
Rt14861 T2756 T3923 1097707.298559095
Rt14862 T2756 T4322 9882248.0058214497
Gcorr5202 T2756 T4324 T2756 T4324 -9.3915373154507314e-08
Rt14863 T2756 T5382 2788815.3555254238
Rt14864 T2757 T3432 9699352.0381025411
Rt14865 T2757 T3608 1665575.983537093
Rt14866 T2757 T3684 1431883.2730385747
Rt14867 T2757 T3808 1217913.531108744
Gcorr5203 T2757 T4516 T2757 T4516 -1.1848766727903861e-07
Rt14868 T2757 T4517 5098923.8097445322
Rt14869 T2757 T4518 1976145.8142185318
Gcorr5204 T2757 T4519 T2757 T4519 -1.2127457652916298e-07
Rt14870 T2758 T3682 1244798.2517049545
Rt14871 T2758 T3743 6892408.2802338684
Rt14872 T2758 T3909 717098.50997558609
Rt14873 T2758 T4017 2213595.88928357
Gcorr5205 T2758 T4393 T2758 T4393 -3.5757423163631983e-07
Rt14874 T2758 T4394 1194481.0253063918
Rt14875 T2758 T5051 21306586.290643193
Gcorr5206 T2758 T5437 T2758 T5437 -1.4926439341488677e-07
Rt14876 T2759 T3625 2116211.5822913526
Rt14877 T2759 T3826 3955344.9048711183
Rt14878 T2759 T3835 1059340.6345674538
Rt14879 T2759 T4036 3307968.9678408597
Gcorr5207 T2759 T4363 T2759 T4363 -5.8279499696807762e-08
Rt14880 T2759 T4365 3192307.5795547259
Rt14881 T2759 T5302 13329153.223008247
Rt14882 T2760 T3626 42147710.514663287
Rt14883 T2760 T3932 1178800.5414337581
Rt14884 T2760 T3940 1126809.1930221955
Rt14885 T2760 T4148 998610.16431632522
Gcorr5208 T2760 T4482 T2760 T4482 -1.0028176198607489e-07
Gcorr5209 T2760 T4483 T2760 T4483 -7.2711177913207823e-09
Rt14886 T2760 T4484 2471817.7450314714
Rt14887 T2761 T2801 1480462.225049698
Rt14888 T2761 T2802 1621673.0190481448
Rt14889 T2761 T3445 58988831.683389574
Rt14890 T2761 T3880 1095349.5813773072
Rt14891 T2761 T4922 8685493.5189984627
Rt14892 T2761 T5202 27488398.518082008
Rt14893 T2761 T5203 2976710.2519529271
Gcorr5210 T2761 T5398 T2761 T5398 -1.5336458175631647e-07
Rt14894 T2762 T3522 20305181.826326165
Rt14895 T2762 T3628 3816349.8441872066
Rt14896 T2762 T3649 1571681.5562655455
Rt14897 T2762 T3928 957342.89683016972
Rt14898 T2762 T4103 7690212.7364009321
Rt14899 T2762 T4450 3160217.9356418257
Rt14900 T2762 T5396 2851620.6481568948
Rt14901 T2762 T5466 8935518.570882678
Gcorr5211 T2762 T5889 T2762 T5889 -2.9082084357302345e-07
Rt14902 T2763 T3573 1786627.1505008016
Rt14903 T2763 T3574 5136815.9799369341
Rt14904 T2763 T3907 1153701.6429357268
Rt14905 T2763 T3911 1601973.8663146633
Rt14906 T2763 T4311 6619787.6229451885
Gcorr5212 T2763 T4313 T2763 T4313 -5.2514111784698114e-08
Rt14907 T2763 T4314 3310489.568527
Rt14908 T2764 T3667 2343285.8019762239
Rt14909 T2764 T3700 3319879.5116999904
Rt14910 T2764 T4051 4297494.8193551581
Rt14911 T2764 T4069 2651913.8472679858
Rt14912 T2764 T4171 2266029.3334873156
Gcorr5213 T2764 T4412 T2764 T4412 -2.2812725374492377e-07
Rt14913 T2764 T4951 21190970.758545663
Rt14914 T2764 T5491 1959911.2224799255
Rt14915 T2764 T5884 13147633.464849634
Rt14916 T2765 T3542 2766255.6581922472
Rt14917 T2765 T3623 1722713.1042562851
Rt14918 T2765 T3675 3642203.3318167781
Rt14919 T2765 T3872 884293.98225725756
Rt14920 T2765 T4649 1925498.3816931481
Gcorr5214 T2765 T4651 T2765 T4651 -2.5219014112299905e-07
Rt14921 T2765 T5373 11335672.591420678
Rt14922 T2765 T5665 12818684.745085934
Rt14923 T2766 T3467 2153588.3447457999
Rt14924 T2766 T3557 688329.2068042215
Rt14925 T2766 T3655 1248361.4600491957
Rt14926 T2766 T3811 2569546.2707710676
Gcorr5215 T2766 T4933 T2766 T4933 -5.2002158602052769e-07
Gcorr5216 T2766 T5050 T2766 T5050 -1.9272928455763567e-07
Rt14927 T2766 T5473 10368764.409364985
Gcorr5217 T2766 T5474 T2766 T5474 -9.3984321129603111e-08
Rt14928 T2766 T5606 858581.89641483629
Rt14929 T2767 T3425 1736631946.3529589
Rt14930 T2767 T3594 1648218.9546081687
Rt14931 T2767 T3654 3530800.1163252662
Rt14932 T2767 T3747 1565650.6245768771
Rt14933 T2767 T4172 6496694.9623882314
Rt14934 T2767 T4641 1837540.5415637994
Rt14935 T2767 T4643 12776855.347141474
Rt14936 T2767 T4644 3357402.3766709398
Gcorr5218 T2767 T5451 T2767 T5451 -4.2755243557301168e-07
Gcorr5219 T2768 T3356 T2768 T3356 -3.3250915415249505e-08
Rt14937 T2768 T3468 5428478.1737705898
Rt14938 T2768 T3619 1479313.5117887289
Rt14939 T2768 T3659 3382671.0680632209
Rt14940 T2768 T4114 1937782.7702430477
Rt14941 T2768 T4817 1988461.5652688958
Gcorr5220 T2768 T5354 T2768 T5354 -4.3093876833490899e-07
Rt14942 T2768 T5481 3788940.7833054983
Rt14943 T2768 T5603 5025426.9448460797
Rt14944 T2769 T3652 1946452.360971848
Rt14945 T2769 T3755 4036975.9805188333
Rt14946 T2769 T3903 1086879.8192439568
Rt14947 T2769 T4021 2582930.2448250474
Rt14948 T2769 T4741 1415635.5851749822
Gcorr5221 T2769 T4747 T2769 T4747 -1.991320992707414e-07
Rt14949 T2769 T4880 13240579.938904505
Gcorr5222 T2769 T5588 T2769 T5588 -1.8903623165611449e-07
Rt14950 T2770 T3859 1843841.1077510391
Rt14951 T2770 T4086 2120258.8024105877
Rt14952 T2770 T4095 983768.25600405864
Gcorr5223 T2770 T5148 T2770 T5148 -7.7217282858756743e-08
Rt14953 T2770 T5372 3982043.2613857505
Rt14954 T2770 T5950 7781037.0564022791
Rt14955 T2771 T3510 8483892.9496149682
Rt14956 T2771 T3562 2084595.5032818124
Rt14957 T2771 T3864 2777918.0800881432
Rt14958 T2771 T3917 1221936.3659692623
Rt14959 T2771 T4638 5748095.1746758278
Rt14960 T2771 T5228 6955890.6001629848
Gcorr5224 T2771 T5442 T2771 T5442 -5.9318951001447577e-08
Rt14961 T2771 T5898 5495979.2125756079
Rt14962 T2772 T3452 13307381.760236818
Rt14963 T2772 T3513 2437502.0422130646
Rt14964 T2772 T3653 1457833.9250491955
Rt14965 T2772 T3832 1470535.9072756672
Gcorr5225 T2772 T4577 T2772 T4577 -1.3090556771330178e-07
Gcorr5226 T2772 T4579 T2772 T4579 -6.3231764419052314e-07
Rt14966 T2772 T4585 910599.2153226434
Rt14967 T2772 T5897 9453270.5127340034
Rt14968 T2772 T6023 27709624.571217507
Rt14969 T2773 T3435 3979319.9536162121
Rt14970 T2773 T3548 1182430.5501398609
Rt14971 T2773 T3658 3101034.2517649932
Rt14972 T2773 T3696 1617678.4069791881
Rt14973 T2773 T4606 1828037.2503121155
Gcorr5227 T2773 T4636 T2773 T4636 -1.9200895621931169e-07
Rt14974 T2773 T4680 19067647.735784568
Rt14975 T2773 T5469 14665538.931042742
Gcorr5228 T2774 T3357 T2774 T3357 -5.3462905502706365e-09
Rt14976 T2774 T3488 549759.8900214656
Rt14977 T2774 T3656 1625733.8431430608
Rt14978 T2774 T3697 3061766.2351599657
Rt14979 T2774 T4118 4503681.5669449624
Rt14980 T2774 T4758 7558150.5825236728
Rt14981 T2774 T4759 991587.91810209025
Rt14982 T2774 T4940 4806249.1829884993
Gcorr5229 T2774 T4941 T2774 T4941 -8.0995419302826659e-07
Rt14983 T2775 T3657 4168944.1631253846
Rt14984 T2775 T3764 5004492.4139567977
Rt14985 T2775 T3902 1662228.4182520881
Rt14986 T2775 T3972 1517733.8383400643
Rt14987 T2775 T5520 3579249.9101283015
Rt14988 T2775 T5563 16922396.421799291
Rt14989 T2775 T5970 19137831.091189943
Rt14990 T2776 T3533 5524146.5525031015
Rt14991 T2776 T3535 2360820.176273298
Rt14992 T2776 T3593 3961161.9075313509
Rt14993 T2776 T3651 1712125.3685048504
Gcorr5230 T2776 T4377 T2776 T4377 -1.0784477821720005e-07
Rt14994 T2776 T4378 2447743.5272022886
Rt14995 T2776 T4379 6178594.7616120083
Rt14996 T2776 T4381 38091727.311589338
Rt14997 T2777 T3447 19833471.318028402
Rt14998 T2777 T3566 1556318.2342742276
Rt14999 T2777 T3606 3643753.9509746432
Rt15000 T2777 T3964 1908673.2548687807
Rt15001 T2777 T4055 333016.0572736499
Rt15002 T2777 T4821 2929032.7447990989
Gcorr5231 T2777 T5320 T2777 T5320 -2.6481447605498433e-07
Gcorr5232 T2777 T5488 T2777 T5488 -9.8264671906552804e-07
Rt15003 T2777 T6046 750891.18664469151
Rt15004 T2777 T6089 17192965.078291714
Rt15005 T2778 T3499 23485006.554062724
Rt15006 T2778 T3800 1413916.5365380978
Rt15007 T2778 T3801 2867798.4858621103
Rt15008 T2778 T3889 7171170.8522724314
Rt15009 T2778 T4139 1135289.055339674
Gcorr5233 T2778 T4328 T2778 T4328 -3.5098544330017438e-07
Rt15010 T2778 T4329 1401123.5147878053
Rt15011 T2778 T5365 13597719.52290073
Rt15012 T2778 T5553 11025773.615753356
Rt15013 T2779 T3237 2878841.40638792
Rt15014 T2779 T3238 1894666.7162713658
Rt15015 T2779 T3622 4868876.5509161241
Rt15016 T2779 T3796 550277.59659615043
Gcorr5234 T2779 T5500 T2779 T5500 -5.0722897229296397e-07
Rt15017 T2779 T5526 659952.68751822016
Gcorr5235 T2779 T5538 T2779 T5538 -4.9677830184944562e-07
Gcorr5236 T2779 T5869 T2779 T5869 -1.5623050603630065e-07
Rt15018 T2780 T3339 5692331.7924676174
Rt15019 T2780 T3795 1701520.3321088196
Rt15020 T2780 T3995 3595814.8982001641
Rt15021 T2780 T4098 1489267.2015084242
Gcorr5237 T2780 T4495 T2780 T4495 -3.3858977588824152e-07
Rt15022 T2780 T4498 1479536.6114563087
Rt15023 T2780 T5505 137284514.87379944
Gcorr5238 T2780 T6057 T2780 T6057 -2.9878360354951096e-08
Rt15024 T2781 T3713 1447231.8406683882
Rt15025 T2781 T3714 3316254.5431393008
Rt15026 T2781 T3744 2384875.9641269906
Rt15027 T2781 T3858 2765602.3268038183
Rt15028 T2781 T4499 3146502.8828948336
Rt15029 T2781 T4602 12993752.623012524
Gcorr5239 T2781 T4634 T2781 T4634 -1.0993066361006624e-07
Rt15030 T2781 T5432 15166885.98183869
Rt15031 T2782 T3255 2335779.6884452971
Rt15032 T2782 T3256 1877722.8179892793
Rt15033 T2782 T3257 1225283.9615167931
Rt15034 T2782 T3587 3847903.0767821362
Rt15035 T2782 T4655 1289033.9909983152
Gcorr5240 T2782 T4656 T2782 T4656 -2.5193166756060999e-07
Rt15036 T2782 T4657 12718770.396364065
Gcorr5241 T2782 T4659 T2782 T4659 -2.0001273318995915e-07
Rt15037 T2783 T3340 1422257.2337584849
Gcorr5242 T2783 T3451 T2783 T3451 -4.9629595213985816e-08
Gcorr5243 T2783 T3947 T2783 T3947 -2.4543365690719115e-08
Rt15038 T2783 T4009 3774849.2181867133
Rt15039 T2783 T4140 993694.53955849167
Gcorr5244 T2783 T4426 T2783 T4426 -2.4267906312690659e-07
Rt15040 T2783 T4588 8891481.9345120061
Rt15041 T2783 T5696 10836605.400063531
Rt15042 T2783 T5990 2307752.0008207308
Rt15043 T2784 T3812 1490332.6929078875
Rt15044 T2784 T3815 1418647.0130515653
Rt15045 T2784 T3850 6901424.6388253262
Rt15046 T2784 T4178 1237400.4475836912
Rt15047 T2784 T4591 11738771.191634245
Gcorr5245 T2784 T4691 T2784 T4691 -8.4032547765455343e-08
Rt15048 T2784 T5450 3331330.7850716175
Rt15049 T2785 T3532 3336269.3271877873
Rt15050 T2785 T3543 3480236.9862383036
Rt15051 T2785 T3660 1388180.506967328
Rt15052 T2785 T3936 1386399.1602115377
Rt15053 T2785 T4595 2281439.0318806404
Rt15054 T2785 T5312 4385818.904909323
Gcorr5246 T2785 T5494 T2785 T5494 -8.6999908795028389e-08
Rt15055 T2785 T5495 9385120.161624115
Gcorr5247 T2785 T6043 T2785 T6043 -2.6843409750660349e-07
Rt15056 T2786 T3544 1479350.629922081
Rt15057 T2786 T3580 2834223.8880096497
Rt15058 T2786 T3661 1195267.2893697396
Rt15059 T2786 T3991 2739033.1435946869
Gcorr5248 T2786 T4800 T2786 T4800 -9.5178052324027263e-08
Rt15060 T2786 T4803 3977694.9235527776
Gcorr5249 T2786 T5331 T2786 T5331 -1.3924969067881206e-07
Rt15061 T2786 T5394 2526429.5220808387
Rt15062 T2787 T3845 2217952.1701467372
Rt15063 T2787 T3983 511972.72933736868
Rt15064 T2787 T4067 1808455.0742268935
Rt15065 T2787 T4531 3380641.9118043804
Gcorr5250 T2787 T4532 T2787 T4532 -1.2014439134450959e-07
Rt15066 T2787 T4533 1697698.4006787704
Gcorr5251 T2787 T4534 T2787 T4534 -4.8148083308683707e-07
Rt15067 T2788 T3713 446690.24368047394
Rt15068 T2788 T3739 3656713.1212047874
Rt15069 T2788 T3941 3464825.1498866063
Rt15070 T2788 T4134 1295149.3481952599
Gcorr5252 T2788 T5015 T2788 T5015 -1.2136000554204938e-07
Rt15071 T2788 T5431 859857.39423590107
Gcorr5253 T2788 T5432 T2788 T5432 -7.1435521152977278e-07
Rt15072 T2789 T3560 1687834.7174539939
Rt15073 T2789 T3561 1803428.8957438646
Rt15074 T2789 T3742 1731758.936623828
Rt15075 T2789 T4039 2806408.0884176972
Rt15076 T2789 T4603 3676943.9067223226
Gcorr5254 T2789 T4678 T2789 T4678 -1.2126192495982169e-07
Gcorr5255 T2789 T4727 T2789 T4727 -1.2744200912591522e-07
Rt15077 T2789 T5552 3014476.1662212205
Rt15078 T2790 T3453 3230475.8129652562
Rt15079 T2790 T3492 6130782.4605801916
Rt15080 T2790 T3815 3263459.7552963709
Rt15081 T2790 T3857 1245396.1954203616
Rt15082 T2790 T4022 2231420.242565522
Rt15083 T2790 T4757 1572632.8521845934
Rt15084 T2790 T5127 37868782.607159682
Rt15085 T2790 T5179 27070788.499876726
Gcorr5256 T2790 T5445 T2790 T5445 -1.8733575356795209e-07
Rt15086 T2791 T3558 1609231.5549968544
Rt15087 T2791 T3852 1884334.6674392154
Rt15088 T2791 T4173 329368.06060825288
Rt15089 T2791 T4180 1972580.7475697875
Gcorr5257 T2791 T4598 T2791 T4598 -1.3972961371641292e-07
Rt15090 T2791 T4709 15689734.786570197
Rt15091 T2791 T4883 592915.41422001831
Rt15092 T2791 T4884 8773719.2234013509
Gcorr5258 T2791 T5888 T2791 T5888 -1.3836634043042943e-06
Rt15093 T2792 T3663 3789200.8411788382
Rt15094 T2792 T3797 1433594.775592658
Rt15095 T2792 T3827 2083299.9975950846
Rt15096 T2792 T4002 3269390.6587014771
Rt15097 T2792 T5424 14969025.339525435
Rt15098 T2792 T5633 25480018.399665318
Rt15099 T2792 T5736 4282480.409244515
Rt15100 T2793 T3529 8727521.0754719302
Rt15101 T2793 T3663 3353671.0659619672
Rt15102 T2793 T3782 505251.80525246123
Rt15103 T2793 T4019 2398094.0413599261
Rt15104 T2793 T5092 1259971.2083178579
Gcorr5259 T2793 T5094 T2793 T5094 -6.6474439127619526e-07
Gcorr5260 T2793 T5096 T2793 T5096 -8.9877754523993031e-08
Rt15105 T2793 T5499 3143662.5537969186
Rt15106 T2794 T3530 11203412.330508148
Rt15107 T2794 T3685 1515585.5962392562
Rt15108 T2794 T3910 1229465.2650820231
Rt15109 T2794 T4195 1512254.1467451949
Gcorr5261 T2794 T5087 T2794 T5087 -1.0607516752379375e-07
Rt15110 T2794 T5088 4578108.2107172916
Rt15111 T2794 T5089 4201069.0632057032
Gcorr5262 T2794 T5090 T2794 T5090 -2.831279135196901e-09
Gcorr5263 T2795 T3460 T2795 T3460 -2.8440796223250268e-09
Gcorr5264 T2795 T3506 T2795 T3506 -7.6945546296354687e-08
Rt15112 T2795 T3854 1400904.4767252812
Rt15113 T2795 T3996 1015442.0719215936
Rt15114 T2795 T4034 2929173.5375157809
Rt15115 T2795 T4543 6466894.3236557683
Rt15116 T2795 T4544 14071102.249773068
Rt15117 T2795 T4545 5055863.9425661685
Gcorr5265 T2796 T3430 T2796 T3430 -1.190256268736492e-06
Rt15118 T2796 T3978 892358.07515331591
Rt15119 T2796 T3979 301764.35817716183
Rt15120 T2796 T4066 632704.75841054542
Rt15121 T2796 T4213 3505993.8526557358
Gcorr5266 T2796 T5115 T2796 T5115 -5.5984408356164939e-07
Rt15122 T2796 T5616 212148.21576589081
Gcorr5267 T2797 T3360 T2797 T3360 -7.7304724614090199e-08
Rt15123 T2797 T3664 2023535.6024640724
Rt15124 T2797 T3724 1243803.5197289176
Rt15125 T2797 T3918 1361228.187933225
Gcorr5268 T2797 T4599 T2797 T4599 -8.4294698538990614e-08
Rt15126 T2797 T5346 11387619.765655441
Gcorr5269 T2797 T5726 T2797 T5726 -1.3703715543174195e-07
Rt15127 T2797 T5904 3394979.4755659034
Rt15128 T2797 T5991 4090215.8054254833
Rt15129 T2798 T3664 3056974.3274602741
Rt15130 T2798 T3666 4538900.477836811
Rt15131 T2798 T3814 1412474.5821445656
Rt15132 T2798 T4030 702449.81627592025
Gcorr5270 T2798 T5173 T2798 T5173 -2.7733480079849818e-07
Rt15133 T2798 T5345 1371565.1836439557
Gcorr5271 T2798 T5704 T2798 T5704 -1.3160418440805465e-07
Rt15134 T2799 T3611 3180919.2858934342
Rt15135 T2799 T3677 5817515.0044251354
Rt15136 T2799 T3816 1559579.9960831169
Rt15137 T2799 T4029 1288497.3949664957
Gcorr5272 T2799 T5175 T2799 T5175 -1.0639395826851663e-07
Rt15138 T2799 T5684 10510177.983077923
Rt15139 T2799 T5802 3017472.8718999396
Gcorr5273 T2800 T3471 T2800 T3471 -4.2690677247819772e-08
Rt15140 T2800 T3750 2532123.4991087061
Rt15141 T2800 T3868 1396491.5230490067
Rt15142 T2800 T3961 993716.51913881791
Rt15143 T2800 T4398 10177179.864480922
Rt15144 T2800 T4399 6794010.6560017364
Rt15145 T2800 T4400 3722312.2685165252
Gcorr5274 T2800 T4401 T2800 T4401 -1.2438759860993057e-07
Rt15146 T2801 T2802 3848453.5778966709
Rt15147 T2801 T2803 1783086.5520814599
Rt15148 T2801 T3058 5440205.622167266
Rt15149 T2801 T3994 1405662.0488681805
Rt15150 T2801 T4716 10714524.848932784
Rt15151 T2801 T4922 5746354.8597508846
Rt15152 T2801 T5398 9581281.9032286108
Rt15153 T2802 T2803 1474688.0539574823
Rt15154 T2802 T2804 1746015.0932828542
Rt15155 T2802 T3445 5763784.0234783413
Rt15156 T2802 T3737 1809640.4794552175
Gcorr5275 T2802 T4784 T2802 T4784 -1.2355214869208217e-07
Rt15157 T2802 T4922 2917340.5233214204
Rt15158 T2802 T4923 5427914.3716868795
Rt15159 T2802 T5202 12387120.609176811
Rt15160 T2803 T2804 3351448.3291689879
Rt15161 T2803 T2805 1888855.1822589643
Rt15162 T2803 T3058 1823087.0510219382
Rt15163 T2803 T3729 3190581.4848416261
Rt15164 T2803 T4716 10889793.762134066
Rt15165 T2803 T4723 21673439.156622436
Rt15166 T2803 T4784 2163276.0484981928
Gcorr5276 T2803 T4922 T2803 T4922 -1.3186092073263487e-07
Rt15167 T2804 T2805 1711763.299185524
Rt15168 T2804 T2806 3769670.8685276895
Rt15169 T2804 T2835 1630143.290595554
Rt15170 T2804 T3737 2014776.2675985626
Rt15171 T2804 T4784 8731948.3933995124
Rt15172 T2804 T4923 7077692.1819772171
Gcorr5277 T2804 T5260 T2804 T5260 -2.0453875309198879e-07
Rt15173 T2804 T5806 2017084.2973303956
Rt15174 T2805 T2806 1478810.1689027802
Rt15175 T2805 T2807 3534705.5901614972
Rt15176 T2805 T2875 5995013.1717682164
Rt15177 T2805 T3729 779461.2365451497
Gcorr5278 T2805 T4723 T2805 T4723 -3.1625333401033535e-07
Rt15178 T2805 T4784 14144329.94421313
Rt15179 T2805 T4786 1039493.8467981805
Gcorr5279 T2805 T5806 T2805 T5806 -1.0366868291760383e-07
Rt15180 T2806 T2807 1720000.6140059887
Rt15181 T2806 T2808 8135347.0673486628
Rt15182 T2806 T2835 1141049.5259589551
Rt15183 T2806 T3977 1613654.7093767109
Gcorr5280 T2806 T4786 T2806 T4786 -9.1523547130144088e-08
Rt15184 T2806 T5159 1982209.6325375838
Gcorr5281 T2806 T5260 T2806 T5260 -2.6708423306335588e-07
Rt15185 T2806 T5806 1736048.611838992
Rt15186 T2807 T2808 554307.64807113225
Rt15187 T2807 T2809 1441804.1219323
Rt15188 T2807 T2875 636873.64990275854
Gcorr5282 T2807 T3731 T2807 T3731 -2.8967840895931928e-09
Rt15189 T2807 T4786 3521418.183288923
Gcorr5283 T2807 T4857 T2807 T4857 -4.9759526292538029e-07
Rt15190 T2807 T4887 530237.38786855387
Gcorr5284 T2807 T5159 T2807 T5159 -4.0469540297166902e-08
Gcorr5285 T2807 T5160 T2807 T5160 -5.8903660360460767e-07
Rt15191 T2808 T2809 6562847.1116744746
Rt15192 T2808 T2810 3106553.9870988918
Rt15193 T2808 T3922 9727912.1501707155
Rt15194 T2808 T3977 1255868.8672849219
Gcorr5286 T2808 T4887 T2808 T4887 -6.0846096479921141e-07
Rt15195 T2808 T5159 1857123.425063964
Rt15196 T2808 T5160 1098406.9392168135
Rt15197 T2808 T6030 3466045.9658423662
Rt15198 T2809 T2810 11612407.994699132
Rt15199 T2809 T2811 1376719.3995768067
Rt15200 T2809 T2813 72212152.424901336
Rt15201 T2809 T3731 3649947.9764492894
Gcorr5287 T2809 T4887 T2809 T4887 -8.4671739373846278e-09
Rt15202 T2809 T5160 1263540.8446536195
Rt15203 T2809 T5905 1067004.9299759043
Rt15204 T2810 T2811 1207372.1681434885
Rt15205 T2810 T2812 18686158.400836635
Gcorr5288 T2810 T2816 T2810 T2816 -6.117496292259105e-08
Rt15206 T2810 T3922 1093797.9614496552
Rt15207 T2810 T5160 2191302.0120157492
Rt15208 T2810 T5977 636090.96023824601
Gcorr5289 T2810 T6030 T2810 T6030 -4.7275262522650261e-08
Rt15209 T2811 T2812 1774886.4591530908
Rt15210 T2811 T2813 1286576.472004428
Rt15211 T2811 T2814 7531355.1946216468
Rt15212 T2811 T3969 9735567.9970637616
Gcorr5290 T2811 T5160 T2811 T5160 -1.6200433746277401e-08
Rt15213 T2811 T5322 406690.37336244102
Gcorr5291 T2811 T5905 T2811 T5905 -9.288640316948872e-09
Gcorr5292 T2811 T5977 T2811 T5977 -1.051748254302639e-07
Rt15214 T2812 T2816 4044803.529825198
Gcorr5293 T2812 T2817 T2812 T2817 -3.1358596783190367e-08
Rt15215 T2812 T3552 1851766.4516677696
Rt15216 T2812 T3969 1814602.7150504843
Rt15217 T2812 T4285 18249245.863847587
Rt15218 T2812 T5322 3188426.6574238436
Rt15219 T2812 T5429 400120.62069233326
Rt15220 T2812 T5977 3833583.8264958914
Rt15221 T2813 T2814 2327245.3848562702
Gcorr5294 T2813 T2815 T2813 T2815 -1.2912738314781133e-07
Rt15222 T2813 T3038 2535267.762797711
Rt15223 T2813 T3731 1171161.5788569683
Rt15224 T2813 T4295 500931.41175157187
Gcorr5295 T2813 T5322 T2813 T5322 -6.2357061378436814e-08
Rt15225 T2813 T5347 27847727.118552547
Gcorr5296 T2813 T5627 T2813 T5627 -1.2379494236697666e-07
Rt15226 T2813 T5905 1434530.8869294571
Rt15227 T2814 T2815 1538363.5221865166
Rt15228 T2814 T2836 1747963.6570663005
Rt15229 T2814 T3969 2401586.9842567798
Gcorr5297 T2814 T4008 T2814 T4008 -1.285348815092181e-07
Gcorr5298 T2814 T4281 T2814 T4281 -2.1163979427880886e-07
Rt15230 T2814 T4283 503920.82868281921
Rt15231 T2814 T4295 1312687.562147279
Rt15232 T2814 T5322 2614176.9971305798
Gcorr5299 T2815 T2836 T2815 T2836 -3.1628088769574684e-07
Gcorr5300 T2815 T2837 T2815 T2837 -4.5936400537458208e-07
Rt15233 T2815 T3038 5257804.5888591381
Rt15234 T2815 T3960 627910.44321527681
Rt15235 T2815 T4281 557707.8092458474
Rt15236 T2815 T4295 883258.73302949255
Rt15237 T2815 T5211 3966166.047542728
Rt15238 T2816 T2817 990018.98096854589
Gcorr5301 T2816 T2820 T2816 T2820 -3.4605135282240402e-07
Rt15239 T2816 T2941 860072.85694815579
Gcorr5302 T2816 T3224 T2816 T3224 -4.2971918974395283e-07
Rt15240 T2816 T3922 2279420.3226326355
Gcorr5303 T2816 T4787 T2816 T4787 -6.1908014437684083e-07
Rt15241 T2816 T5064 515593.38701937406
Rt15242 T2816 T5180 544210.82217868418
Rt15243 T2816 T5429 1073185.1830379798
Rt15244 T2816 T5977 14893587.186953219
Gcorr5304 T2816 T6052 T2816 T6052 -5.2634630176113965e-07
Rt15245 T2817 T2820 1136384.2020407992
Rt15246 T2817 T2821 838550.81973766326
Gcorr5305 T2817 T2827 T2817 T2827 -5.2969371218437318e-07
Rt15247 T2817 T3552 552090.97483383142
Gcorr5306 T2817 T4285 T2817 T4285 -1.2278644780206884e-06
Rt15248 T2817 T4287 617682.08400005405
Gcorr5307 T2817 T5180 T2817 T5180 -5.3337085704315824e-07
Rt15249 T2817 T5429 617318.23637647717
Gcorr5308 T2817 T5764 T2817 T5764 -6.0939954655241899e-07
Rt15250 T2817 T6052 273253.84720381419
Rt15251 T2818 T3544 1276524.7213714828
Rt15252 T2818 T3584 31880526.219946951
Rt15253 T2818 T3665 2724195.2495006737
Rt15254 T2818 T3759 1004568.8258244171
Rt15255 T2818 T4934 1672262.8478078435
Gcorr5309 T2818 T5331 T2818 T5331 -1.5609518626104429e-07
Rt15256 T2818 T5332 8057619.9996253215
Gcorr5310 T2818 T5333 T2818 T5333 -1.4674938559157923e-07
Rt15257 T2819 T3466 2892528.1693754639
Rt15258 T2819 T3543 2301485.8391904198
Rt15259 T2819 T3760 1254187.5411207404
Rt15260 T2819 T3780 2455182.8365313504
Gcorr5311 T2819 T4944 T2819 T4944 -1.5999281864793552e-07
Rt15261 T2819 T5003 3089563.9146836167
Rt15262 T2819 T5814 9612416.7004787065
Rt15263 T2819 T5936 6996422.9544936586
Gcorr5312 T2820 T2821 T2820 T2821 -4.4815706442523648e-07
Rt15264 T2820 T2941 2794337.9983796002
Gcorr5313 T2820 T2986 T2820 T2986 -3.0835990111444315e-07
Rt15265 T2820 T3525 4843868.746773148
Rt15266 T2820 T5180 587126.26409570163
Rt15267 T2820 T5764 731318.65888597956
Rt15268 T2820 T5875 634996.47096398624
Gcorr5314 T2820 T6052 T2820 T6052 -3.7751355474248433e-07
Rt15269 T2821 T2827 2867577.9537650025
Gcorr5315 T2821 T2828 T2821 T2828 -5.8353775111165773e-07
Rt15270 T2821 T2829 6164476.7293261765
Rt15271 T2821 T3525 11406960.53695032
Rt15272 T2821 T4287 2508479.8012181786
Rt15273 T2821 T4289 414374.99088503374
Rt15274 T2821 T5452 3368938.6903000106
Rt15275 T2821 T5764 319201.45759664895
Gcorr5316 T2821 T6052 T2821 T6052 -7.8845233278156719e-07
Rt15276 T2822 T2823 1170084.9708903348
Rt15277 T2822 T2848 3772727.5151239997
Rt15278 T2822 T3564 5185155.6134103918
Rt15279 T2822 T3763 1059749.661512204
Gcorr5317 T2822 T4912 T2822 T4912 -1.8058552455985333e-07
Rt15280 T2822 T5151 8941975.9132895153
Rt15281 T2822 T5152 1705928.2877355136
Gcorr5318 T2822 T5701 T2822 T5701 -1.5122530046110309e-07
Rt15282 T2823 T2848 1827368.0282322383
Rt15283 T2823 T2849 1808322.2170126848
Rt15284 T2823 T2850 1273606.9688167833
Gcorr5319 T2823 T3407 T2823 T3407 -8.0285432774632925e-09
Rt15285 T2823 T4164 4281581.0714554144
Rt15286 T2823 T4912 1262513.544363556
Gcorr5320 T2823 T5152 T2823 T5152 -1.604549748815538e-07
Rt15287 T2823 T5188 21776865.956783578
Gcorr5321 T2823 T5547 T2823 T5547 -1.950163957085392e-07
Rt15288 T2824 T3762 3122580.5092794467
Rt15289 T2824 T3956 5568505.3720657304
Rt15290 T2824 T4061 1197988.2628663001
Rt15291 T2824 T4193 1061712.1457833615
Rt15292 T2824 T4669 2912953.1029278003
Gcorr5322 T2824 T4671 T2824 T4671 -1.1146398612736076e-07
Rt15293 T2824 T4682 17327840.125221275
Rt15294 T2825 T3685 2459132.7753135036
Rt15295 T2825 T3741 535490.79822983651
Rt15296 T2825 T4119 988688.04567513661
Gcorr5323 T2825 T5082 T2825 T5082 -4.1957902290249555e-07
Rt15297 T2825 T5085 574200.12861546921
Gcorr5324 T2825 T5587 T2825 T5587 -4.6723914118276118e-07
Gcorr5325 T2825 T5779 T2825 T5779 -5.7269543966637555e-07
Rt15298 T2826 T3611 3771638.9693986336
Rt15299 T2826 T3612 5469841.3382181916
Rt15300 T2826 T3740 3491787.9801881169
Rt15301 T2826 T3957 1369185.9437741016
Gcorr5326 T2826 T4791 T2826 T4791 -6.3784323212408537e-08
Rt15302 T2826 T4793 8477176.74089632
Rt15303 T2826 T4794 3201210.5004350324
Rt15304 T2827 T2828 21376150.085030027
Gcorr5327 T2827 T2855 T2827 T2855 -5.8289423794718731e-07
Rt15305 T2827 T3057 3686465.2589686327
Rt15306 T2827 T3552 9459908.929674685
Rt15307 T2827 T4286 3160721.2877719831
Rt15308 T2827 T4287 346877.50226369221
Rt15309 T2827 T4288 500680.68385518005
Rt15310 T2827 T4289 3822430.7753031179
Rt15311 T2828 T2829 2988443.2631225102
Rt15312 T2828 T2830 10441626666.910765
Rt15313 T2828 T2855 7447597.7557909265
Gcorr5328 T2828 T3993 T2828 T3993 -1.9032083198451923e-07
Rt15314 T2828 T4288 1580818.2501643468
Rt15315 T2828 T4289 435199.61798536684
Rt15316 T2828 T4290 440733.74510699959
Rt15317 T2828 T4291 37576510.606241383
Gcorr5329 T2829 T2830 T2829 T2830 -5.2114083174357006e-07
Rt15318 T2829 T2847 32529317.228172973
Rt15319 T2829 T2878 941936.21603439911
Gcorr5330 T2829 T3525 T2829 T3525 -8.1911558128535831e-07
Gcorr5331 T2829 T4012 T2829 T4012 -9.2407334984229439e-07
Rt15320 T2829 T4289 2422133.8433396532
Rt15321 T2829 T4291 297707.69176020281
Rt15322 T2829 T4294 5982359.4283852018
Rt15323 T2829 T5452 389398.02827614971
Rt15324 T2830 T2847 235316.66957838027
Gcorr5332 T2830 T2860 T2830 T2860 -5.6270524762305055e-07
Gcorr5333 T2830 T2874 T2830 T2874 -4.8997748538195789e-07
Rt15325 T2830 T3993 1017623.4144701378
Rt15326 T2830 T4290 1665518.0116051957
Rt15327 T2830 T4291 582865.40168079082
Rt15328 T2830 T4292 204327.74298218021
Gcorr5334 T2830 T4293 T2830 T4293 -1.9678426192423151e-06
Rt15329 T2831 T3669 3318734.3039958584
Rt15330 T2831 T3676 1993735.4192771714
Rt15331 T2831 T3757 1730815.37851919
Rt15332 T2831 T3914 1597985.6552459286
Rt15333 T2831 T4632 2982035.6128161633
Rt15334 T2831 T4705 13479926.009099225
Rt15335 T2831 T4706 7786169.2193988012
Gcorr5335 T2831 T5895 T2831 T5895 -1.4124028631508442e-07
Rt15336 T2832 T3579 5031321.5496985996
Rt15337 T2832 T3670 1659528.8495875129
Rt15338 T2832 T3785 4300199.3265080405
Rt15339 T2832 T4065 1399515.8156426887
Rt15340 T2832 T4870 11885523.107195022
Rt15341 T2832 T5455 5599000.9164258633
Rt15342 T2832 T5456 7773580.1414553123
Rt15343 T2833 T3558 4136619.2080269861
Rt15344 T2833 T3559 1398354.1395071985
Rt15345 T2833 T3563 2025071.2640565848
Rt15346 T2833 T3672 1765861.9831337139
Gcorr5336 T2833 T4470 T2833 T4470 -2.6560967661680505e-07
Rt15347 T2833 T4471 8411172.3418824747
Rt15348 T2833 T4472 1411704.6147002245
Gcorr5337 T2833 T4597 T2833 T4597 -1.2898640313811578e-07
Rt15349 T2834 T3560 4251308.8832382727
Rt15350 T2834 T3607 811761.33455971512
Rt15351 T2834 T3805 1093725.3116454592
Rt15352 T2834 T3959 2420917.9533887724
Rt15353 T2834 T4653 2625089.3228599164
Gcorr5338 T2834 T4679 T2834 T4679 -4.348964981847937e-07
Rt15354 T2834 T5516 4086877.0523549677
Rt15355 T2834 T5630 1928931.0836331483
Gcorr5339 T2834 T6008 T2834 T6008 -3.030582174420026e-07
Rt15356 T2835 T3737 2662721.0171893602
Rt15357 T2835 T3738 991239.40249614266
Rt15358 T2835 T3931 905464.957584408
Rt15359 T2835 T3977 729259.37156679365
Rt15360 T2835 T5260 480266.9297065768
Gcorr5340 T2835 T5710 T2835 T5710 -4.4509060222674933e-07
Gcorr5341 T2835 T5806 T2835 T5806 -4.6058016448434606e-07
Gcorr5342 T2835 T5807 T2835 T5807 -4.8272099096277668e-07
Rt15361 T2836 T2837 9944933.3509207349
Rt15362 T2836 T2917 1278240.6438921769
Gcorr5343 T2836 T2921 T2836 T2921 -2.9884853215311981e-07
Rt15363 T2836 T4008 2203095.0818167282
Gcorr5344 T2836 T4125 T2836 T4125 -6.1067351479192349e-07
Gcorr5345 T2836 T4280 T2836 T4280 -9.1397448916111652e-08
Rt15364 T2836 T4281 457339.26858238725
Rt15365 T2836 T4282 519290.24980206531
Rt15366 T2836 T4283 2905521.5657021604
Gcorr5346 T2837 T2917 T2837 T2917 -3.5180931652260602e-07
Rt15367 T2837 T2918 4539357.6043711482
Gcorr5347 T2837 T2919 T2837 T2919 -4.0896279579062818e-07
Gcorr5348 T2837 T3514 T2837 T3514 -4.5270495053321416e-07
Rt15368 T2837 T3960 483703.51108362275
Rt15369 T2837 T4279 338515.8582951912
Rt15370 T2837 T4280 1135519.4556437421
Rt15371 T2837 T4281 643747.92924826778
Gcorr5349 T2837 T5211 T2837 T5211 -5.0808046153247224e-07
Rt15372 T2838 T3398 712370.80488685577
Rt15373 T2838 T3519 7388723.8187053073
Rt15374 T2838 T3528 3340446.9962464338
Rt15375 T2838 T3716 1300500.1506562212
Gcorr5350 T2838 T4781 T2838 T4781 -7.7745559766853512e-08
Rt15376 T2838 T4783 1638241.8088340203
Gcorr5351 T2838 T4943 T2838 T4943 -4.6921262511776781e-07
Rt15377 T2838 T5666 2817367.9634217587
Rt15378 T2839 T3399 3843984.6788807851
Rt15379 T2839 T3538 9224234.7246472146
Rt15380 T2839 T3746 1303735.7274074301
Rt15381 T2839 T3981 1386981.4351225239
Rt15382 T2839 T4965 17162432.237881724
Rt15383 T2839 T4966 11374934.483827889
Rt15384 T2839 T5374 4583039.8298918875
Gcorr5352 T2840 T3430 T2840 T3430 -6.4081913642686515e-07
Rt15385 T2840 T3690 13705042.925590532
Gcorr5353 T2840 T3753 T2840 T3753 -4.2912942348004338e-07
Gcorr5354 T2840 T3951 T2840 T3951 -5.2931921586970197e-07
Rt15386 T2840 T3978 3212680.076940516
Rt15387 T2840 T4106 784230.89003411995
Rt15388 T2840 T5240 1503012.1071962514
Rt15389 T2840 T5894 1359382.2086314708
Rt15390 T2840 T5954 404175.94482132111
Rt15391 T2840 T6011 942854.68220197875
Rt15392 T2841 T3597 1627404.9981904929
Rt15393 T2841 T3598 3586386.5008764979
Rt15394 T2841 T3802 1805172.6479513983
Rt15395 T2841 T4182 1021184.4434378467
Gcorr5355 T2841 T4354 T2841 T4354 -6.147830104041076e-08
Rt15396 T2841 T4355 5499052.7705172412
Rt15397 T2841 T4369 3798715.1826474098
Rt15398 T2842 T3695 2965936.5649775588
Rt15399 T2842 T3752 661947.42009383708
Rt15400 T2842 T3860 3139332.5329172444
Rt15401 T2842 T4131 708896.06069635786
Gcorr5356 T2842 T4775 T2842 T4775 -4.0078984441513497e-07
Rt15402 T2842 T4778 801599.04897446209
Gcorr5357 T2842 T5509 T2842 T5509 -2.0307471336831894e-07
Gcorr5358 T2842 T5511 T2842 T5511 -3.0077675066398319e-07
Rt15403 T2843 T3752 2827132.8914922005
Rt15404 T2843 T3774 965491.78364517714
Rt15405 T2843 T3819 5556515.711053839
Rt15406 T2843 T4137 2181457.6203039736
Gcorr5359 T2843 T4774 T2843 T4774 -4.2572134052831077e-07
Rt15407 T2843 T4776 853885.62717982475
Gcorr5360 T2843 T4810 T2843 T4810 -4.1873761147975032e-07
Rt15408 T2844 T3721 6138699.236523197
Rt15409 T2844 T3745 3893088.7766644247
Rt15410 T2844 T3775 3007947.4221223793
Rt15411 T2844 T4084 1238630.1030987643
Rt15412 T2844 T4971 10685133.568358064
Rt15413 T2844 T4972 2396455.8586302111
Gcorr5361 T2844 T4973 T2844 T4973 -1.5790420386424469e-07
Rt15414 T2845 T3722 2302252.8106492041
Rt15415 T2845 T3773 1644072.4225985999
Rt15416 T2845 T3775 2803593.2432096908
Rt15417 T2845 T3975 2792816.2099767425
Rt15418 T2845 T4974 11126923.61388514
Rt15419 T2845 T4976 6021918.6928823572
Rt15420 T2845 T5530 12079410.648441754
Rt15421 T2846 T3766 535180.621476701
Rt15422 T2846 T3767 1995902.748478852
Rt15423 T2846 T3788 3330746.0913704694
Rt15424 T2846 T3919 1230323.5047591829
Gcorr5362 T2846 T4812 T2846 T4812 -2.3252287060092414e-07
Gcorr5363 T2846 T4814 T2846 T4814 -1.2937156856199108e-07
Gcorr5364 T2846 T5156 T2846 T5156 -4.2628653676551341e-07
Rt15425 T2846 T5399 889768.93894241354
Rt15426 T2847 T2860 3104565.2959078331
Gcorr5365 T2847 T2878 T2847 T2878 -3.4846949885737535e-07
Rt15427 T2847 T2898 1606881.5917227764
Rt15428 T2847 T3748 1983556.3140378608
Gcorr5366 T2847 T3900 T2847 T3900 -3.7953267270804047e-07
Rt15429 T2847 T4291 1764309.4127447458
Gcorr5367 T2847 T4292 T2847 T4292 -2.0112655104736415e-06
Rt15430 T2847 T4293 150706.71781006266
Rt15431 T2847 T4294 847390.16013108613
Rt15432 T2847 T5770 104082713.19864511
Gcorr5368 T2847 T6034 T2847 T6034 -3.8302968484578662e-07
Rt15433 T2848 T2849 3732486.1120604821
Rt15434 T2848 T2887 1782795.9659405651
Rt15435 T2848 T2980 4103968.6794777731
Rt15436 T2848 T3564 1790078.2678358178
Rt15437 T2848 T5152 7166148.47735197
Rt15438 T2848 T5188 6017720.5332358293
Rt15439 T2848 T5189 6482140.7034997102
Rt15440 T2849 T2850 3664686.6359953349
Rt15441 T2849 T2851 2001015.5599277145
Rt15442 T2849 T2887 1854443.3418591833
Rt15443 T2849 T3791 3856839.2875837763
Rt15444 T2849 T5188 5734568.0527972309
Rt15445 T2849 T5547 9466463.6718265302
Rt15446 T2849 T5993 5501714.8409518013
Rt15447 T2850 T2851 1799587.2026796362
Rt15448 T2850 T2852 3546088.9033418642
Rt15449 T2850 T3033 3230064.7320721969
Rt15450 T2850 T4164 1013419.8237506442
Rt15451 T2850 T4910 14775116.550444106
Gcorr5369 T2850 T4912 T2850 T4912 -1.690959349537138e-07
Rt15452 T2850 T4913 12154366.208444649
Rt15453 T2850 T5547 2210888.8642547252
Rt15454 T2851 T2852 955645.1209829452
Rt15455 T2851 T2889 4762913.95918079
Rt15456 T2851 T3791 1902396.6411519737
Rt15457 T2851 T4038 3348728.1936641419
Gcorr5370 T2851 T4913 T2851 T4913 -1.9423030982205235e-07
Rt15458 T2851 T4917 1582543.4222632383
Rt15459 T2851 T5547 10165618.359852726
Gcorr5371 T2851 T5993 T2851 T5993 -4.1407092534288787e-08
Rt15460 T2852 T2889 668673.4619791836
Rt15461 T2852 T2890 2399088.7674690611
Rt15462 T2852 T3033 4564855.9617331587
Rt15463 T2852 T4040 989908.18350871396
Rt15464 T2852 T4913 792435.05691112799
Gcorr5372 T2852 T4914 T2852 T4914 -1.0520374175403872e-07
Gcorr5373 T2852 T4915 T2852 T4915 -1.7947914582011965e-07
Gcorr5374 T2852 T4917 T2852 T4917 -4.3805501815990084e-07
Rt15465 T2853 T3615 3108363.8186813607
Rt15466 T2853 T3789 1396113.9345825801
Rt15467 T2853 T4152 870295.37458122778
Rt15468 T2853 T5248 6654485.334105459
Gcorr5375 T2853 T5581 T2853 T5581 -1.1444152793706116e-07
Rt15469 T2853 T6031 4311013.0114932265
Rt15470 T2854 T3600 2428350.9978351514
Rt15471 T2854 T3615 1684447.0719184552
Rt15472 T2854 T3818 1163969.0628964321
Rt15473 T2854 T4063 2184245.8752378561
Gcorr5376 T2854 T4851 T2854 T4851 -1.1305865834472498e-07
Rt15474 T2854 T4853 3622570.9199297824
Gcorr5377 T2854 T5184 T2854 T5184 -1.0783767880195802e-07
Rt15475 T2854 T5362 3037927.7921237783
Rt15476 T2855 T3057 3876960.3394361665
Gcorr5378 T2855 T3486 T2855 T3486 -6.7708169864986299e-07
Gcorr5379 T2855 T3572 T2855 T3572 -4.6060061652575689e-07
Rt15477 T2855 T3787 611800.31610993796
Rt15478 T2855 T3993 2662337.3603578419
Rt15479 T2855 T4288 350109.68469014933
Gcorr5380 T2855 T4290 T2855 T4290 -8.0976269291078471e-08
Rt15480 T2855 T5358 613744.34367466427
Rt15481 T2855 T5359 448685.93253398774
Gcorr5381 T2855 T5935 T2855 T5935 -9.5516422420887304e-07
Rt15482 T2856 T3409 1961849.5646679357
Rt15483 T2856 T3410 3544179.3428146159
Rt15484 T2856 T3411 1695105.7003508201
Rt15485 T2856 T3592 1801610.8720348177
Rt15486 T2856 T4847 2307173.0282854536
Gcorr5382 T2856 T4849 T2856 T4849 -9.71420834899513e-08
Rt15487 T2856 T5397 4384941.4932429725
Gcorr5383 T2856 T5449 T2856 T5449 -1.343187777690095e-07
Gcorr5384 T2857 T3355 T2857 T3355 -3.1121291596186063e-07
Rt15488 T2857 T3777 39492340.358865157
Rt15489 T2857 T3784 1551618.9710706447
Rt15490 T2857 T3886 1352230.2095911712
Rt15491 T2857 T4232 262667.93241876311
Rt15492 T2857 T5625 1827835.7474493871
Gcorr5385 T2857 T5711 T2857 T5711 -9.2030806195800397e-08
Gcorr5386 T2857 T5971 T2857 T5971 -5.587903557216688e-08
Gcorr5387 T2858 T3496 T2858 T3496 -2.1612579930484919e-07
Rt15493 T2858 T3706 5562663.7130112881
Rt15494 T2858 T3781 2036822.1838753694
Rt15495 T2858 T3986 1126854.5788223515
Rt15496 T2858 T4233 243172.24143495262
Gcorr5388 T2858 T5411 T2858 T5411 -1.1030665422516216e-07
Rt15497 T2858 T5435 3161063.519010928
Rt15498 T2858 T6074 4101660.1444583912
Rt15499 T2859 T3474 932729.55431905296
Rt15500 T2859 T3673 726272.66835319309
Rt15501 T2859 T3849 1354724.359288729
Rt15502 T2859 T3992 616188.02387955168
Gcorr5389 T2859 T5076 T2859 T5076 -4.4276633864929416e-07
Gcorr5390 T2859 T5077 T2859 T5077 -4.163743232310442e-07
Rt15503 T2859 T5078 482998.2587236531
Gcorr5391 T2859 T5081 T2859 T5081 -3.3912698103915092e-07
Gcorr5392 T2859 T5529 T2859 T5529 -4.5421148992914759e-07
Rt15504 T2860 T2874 6323352.8401494296
Rt15505 T2860 T2904 5315903.6821008436
Gcorr5393 T2860 T3662 T2860 T3662 -2.1679888062461705e-07
Rt15506 T2860 T3900 1857605.524469251
Rt15507 T2860 T4292 618225.72422451165
Rt15508 T2860 T4293 2230901.6736468179
Rt15509 T2860 T4296 378604.42732292769
Rt15510 T2860 T4298 1248207415.0836725
Rt15511 T2861 T3545 3299845.9125111331
Rt15512 T2861 T3604 2192459.141204861
Rt15513 T2861 T3671 1850344.2393047861
Rt15514 T2861 T3949 2594521.6432981715
Rt15515 T2861 T5069 3888962.067008588
Rt15516 T2861 T5070 11033585.032894008
Rt15517 T2861 T5418 2319141.2021765457
Gcorr5394 T2861 T5707 T2861 T5707 -4.0437109821219464e-07
Rt15518 T2862 T2863 1556923.9216807764
Rt15519 T2862 T2864 3727168.720036163
Rt15520 T2862 T3595 1734568.6467428342
Rt15521 T2862 T3764 1762799.2780056465
Rt15522 T2862 T4246 3730259.5516818017
Gcorr5395 T2862 T4247 T2862 T4247 -6.6315224184722719e-08
Rt15523 T2862 T4248 2758618.3362342957
Gcorr5396 T2862 T4694 T2862 T4694 -1.5526652323378144e-07
Rt15524 T2863 T2864 1543611.8662184007
Rt15525 T2863 T2865 3645212.7921285918
Rt15526 T2863 T2866 1831065.6855660202
Rt15527 T2863 T3556 1772658.6293080347
Rt15528 T2863 T4245 3798640.6724517364
Gcorr5397 T2863 T4246 T2863 T4246 -1.2212705053135982e-07
Rt15529 T2863 T4247 2588395.2840161994
Gcorr5398 T2863 T4746 T2863 T4746 -9.5297434465310491e-08
Rt15530 T2864 T2865 1487186.6644603529
Rt15531 T2864 T2877 3194396.4774711193
Rt15532 T2864 T2899 1607130.2271261187
Rt15533 T2864 T3595 3374944.5039589559
Rt15534 T2864 T4244 11131814.562102033
Gcorr5399 T2864 T4245 T2864 T4245 -8.8305395759293886e-08
Rt15535 T2864 T4246 2169614.0162351015
Rt15536 T2865 T2866 1645086.283824475
Rt15537 T2865 T2867 1644310.4927012171
Rt15538 T2865 T2877 1261239.3036192798
Rt15539 T2865 T3806 3163409.1975767105
Rt15540 T2865 T4243 5601465.9087510649
Gcorr5400 T2865 T4244 T2865 T4244 -1.2642506715615539e-07
Rt15541 T2865 T4245 1948138.4638782321
Gcorr5401 T2865 T5595 T2865 T5595 -1.035633095589073e-07
Rt15542 T2866 T2867 3458685.7515971055
Rt15543 T2866 T2873 1588396.1107877064
Rt15544 T2866 T3199 1767583.9794136235
Rt15545 T2866 T3556 3169503.6196275242
Gcorr5402 T2866 T4245 T2866 T4245 -8.7205105694261863e-08
Rt15546 T2866 T4746 2863683.4495139294
Gcorr5403 T2866 T5314 T2866 T5314 -1.4888760763983496e-07
Rt15547 T2866 T5595 2756119.6357586333
Rt15548 T2867 T2873 1808278.2444293953
Rt15549 T2867 T2905 1511079.2858386098
Rt15550 T2867 T2949 1996376.2957710689
Rt15551 T2867 T3806 2935137.5552740288
Rt15552 T2867 T4243 3788929.3718270706
Gcorr5404 T2867 T4898 T2867 T4898 -1.5510259329124983e-07
Rt15553 T2867 T5595 3577262.5501310858
Rt15554 T2867 T5967 6992054.6739070956
Rt15555 T2868 T2869 1158800.7127093717
Rt15556 T2868 T2870 3066802.3067718651
Rt15557 T2868 T3596 1229363.8873293798
Rt15558 T2868 T3755 747998.20659838873
Gcorr5405 T2868 T4672 T2868 T4672 -1.7125376010960618e-07
Gcorr5406 T2868 T4673 T2868 T4673 -4.2295494804557531e-07
Rt15559 T2868 T4674 599604.26066674269
Gcorr5407 T2868 T4675 T2868 T4675 -1.8345733008193517e-07
Gcorr5408 T2868 T4676 T2868 T4676 -4.732560051544239e-07
Rt15560 T2869 T2870 1947854.6211543791
Rt15561 T2869 T2871 2004924.8231199391
Rt15562 T2869 T3220 1751742.7090131773
Rt15563 T2869 T3803 4061691.5418708543
Rt15564 T2869 T4673 2574381.5101504605
Gcorr5409 T2869 T4674 T2869 T4674 -1.5704306903319363e-07
Rt15565 T2869 T5585 7180698.6452685976
Rt15566 T2869 T5795 19824904.408334088
Rt15567 T2870 T2871 1937235.9627219704
Rt15568 T2870 T2879 1174492.729617337
Rt15569 T2870 T2900 4003553.5423079864
Rt15570 T2870 T3596 2034537.2939302735
Rt15571 T2870 T4674 20696180.693875052
Rt15572 T2870 T4677 2211649.6814394048
Rt15573 T2870 T5585 6438440.9532205369
Gcorr5410 T2870 T5586 T2870 T5586 -1.846584513502157e-07
Rt15574 T2871 T2879 2951084.3187964358
Rt15575 T2871 T2880 1946245.7990828266
Rt15576 T2871 T2881 5479028.6986867124
Rt15577 T2871 T3803 1267154.1238605056
Rt15578 T2871 T5585 5930944.535011813
Rt15579 T2871 T5586 20222028.031331066
Rt15580 T2871 T5713 2646945.6779332133
Gcorr5411 T2871 T5795 T2871 T5795 -1.1457731175944519e-07
Rt15581 T2872 T3671 3599453.6601823596
Rt15582 T2872 T3673 3123955.893529498
Rt15583 T2872 T3674 1448504.5759186561
Rt15584 T2872 T4025 1356483.2116577721
Rt15585 T2872 T5073 3921661.3868508302
Gcorr5412 T2872 T5074 T2872 T5074 -1.6818952606742621e-07
Rt15586 T2872 T5075 1365511.3154096885
Gcorr5413 T2872 T5107 T2872 T5107 -4.3303083922922171e-07
Rt15587 T2873 T2905 3619153.6820455096
Rt15588 T2873 T2931 1605338.7541294675
Rt15589 T2873 T3199 5044425.6730193142
Rt15590 T2873 T4064 1288110.8088677595
Rt15591 T2873 T5314 2330308.9862388358
Gcorr5414 T2873 T5426 T2873 T5426 -1.8990256049175913e-07
Gcorr5415 T2873 T5595 T2873 T5595 -8.0512346258463036e-08
Rt15592 T2873 T5967 2632474.7852269784
Gcorr5416 T2874 T2904 T2874 T2904 -5.787434598711402e-07
Rt15593 T2874 T2937 4573907.5092544332
Gcorr5417 T2874 T3958 T2874 T3958 -7.209791500938643e-07
Rt15594 T2874 T3993 46522361.471646003
Rt15595 T2874 T4130 1084075.1752944081
Rt15596 T2874 T4292 823064.1939562097
Rt15597 T2874 T4298 417731.67176793277
Rt15598 T2874 T5386 678785.5237369847
Rt15599 T2874 T5751 4484928.1948229792
Rt15600 T2875 T3639 33161410.278773557
Rt15601 T2875 T3729 947364.47010060074
Rt15602 T2875 T3730 1638059.1574142375
Rt15603 T2875 T3731 430467.59863481123
Gcorr5418 T2875 T4786 T2875 T4786 -1.5990332146413027e-07
Rt15604 T2875 T4857 456382.59847951197
Gcorr5419 T2875 T4887 T2875 T4887 -2.4384910232760876e-07
Gcorr5420 T2875 T5347 T2875 T5347 -8.2206067365214612e-07
Gcorr5421 T2875 T5800 T2875 T5800 -1.1377286573468114e-07
Rt15605 T2876 T3546 13737434.749616358
Rt15606 T2876 T3765 1256740.5027903037
Rt15607 T2876 T3789 4749535.7769409483
Rt15608 T2876 T4167 1077648.185862215
Rt15609 T2876 T4980 12746958.804346742
Rt15610 T2876 T4985 3356534.9145382638
Rt15611 T2876 T5063 2646074.7489412907
Gcorr5422 T2876 T5186 T2876 T5186 -4.2725411091693397e-07
Rt15612 T2877 T2899 3446262.0741554326
Rt15613 T2877 T2912 1302419.4505175988
Rt15614 T2877 T3541 1755732.8935158132
Rt15615 T2877 T3806 2067840.4258730903
Gcorr5423 T2877 T4241 T2877 T4241 -1.2041714025525408e-07
Rt15616 T2877 T4243 367636480.4252767
Rt15617 T2877 T4244 1541618.5070620328
Rt15618 T2878 T2898 1338909.2887645399
Rt15619 T2878 T2925 1083168.1939577681
Gcorr5424 T2878 T3512 T2878 T3512 -4.7912147341510328e-07
Rt15620 T2878 T4012 382329.79477230069
Rt15621 T2878 T4294 265722.64721987583
Gcorr5425 T2878 T5452 T2878 T5452 -4.1777710815410305e-07
Gcorr5426 T2878 T5765 T2878 T5765 -3.5252398063228248e-08
Rt15622 T2878 T5770 4920298.3358528763
Gcorr5427 T2878 T5880 T2878 T5880 -8.1193221314881191e-07
Rt15623 T2878 T6019 501179.60756225651
Rt15624 T2879 T2880 3305924.5698153619
Rt15625 T2879 T2900 1229551.6048992777
Rt15626 T2879 T2914 3124725.3190008076
Rt15627 T2879 T4042 2438134.8883890435
Gcorr5428 T2879 T4677 T2879 T4677 -4.0825204140884e-07
Rt15628 T2879 T5586 1100447.7080275307
Rt15629 T2880 T2881 1943740.9628475718
Rt15630 T2880 T2897 1874100.1966266229
Rt15631 T2880 T2990 8343405.9174546404
Rt15632 T2880 T4042 1290905.3550263788
Rt15633 T2880 T5286 2649253.0619282299
Rt15634 T2880 T5586 20310945.926138859
Rt15635 T2880 T5713 4823472.1738321939
Gcorr5429 T2880 T5952 T2880 T5952 -5.0083160461663275e-08
Rt15636 T2881 T2897 3889350.3369854894
Rt15637 T2881 T2911 1961315.1872801601
Rt15638 T2881 T3085 5899327.0223152535
Rt15639 T2881 T3803 704965.52894059883
Rt15640 T2881 T5290 1949693.931195335
Rt15641 T2881 T5713 3164258.0840992513
Gcorr5430 T2881 T5795 T2881 T5795 -4.0230197039161075e-07
Rt15642 T2881 T5952 5116686.438883598
Rt15643 T2882 T3440 11117012.484887248
Rt15644 T2882 T3629 1706734.8539238377
Rt15645 T2882 T3899 1279965.0690806694
Rt15646 T2882 T3916 1243418.5947877204
Gcorr5431 T2882 T4258 T2882 T4258 -1.3194326075421701e-07
Rt15647 T2882 T4260 2832197.3829251113
Rt15648 T2882 T4261 10231482.311760126
Rt15649 T2882 T4262 8633586.5482897684
Rt15650 T2883 T3555 745608.05595847988
Rt15651 T2883 T3630 3172581.8219570699
Rt15652 T2883 T3641 1362300.6201390231
Rt15653 T2883 T3751 1554192.028839895
Rt15654 T2883 T4902 4461398.849616061
Gcorr5432 T2883 T4903 T2883 T4903 -1.2405174947791364e-07
Rt15655 T2883 T4904 710120.72325760406
Gcorr5433 T2883 T4905 T2883 T4905 -5.4687058842851433e-07
Gcorr5434 T2883 T5116 T2883 T5116 -5.2301534085980649e-07
Rt15656 T2884 T3631 881258.66931677749
Rt15657 T2884 T3644 3053983.4050054424
Rt15658 T2884 T3645 1545901.4705218389
Rt15659 T2884 T3838 832281.40548106027
Gcorr5435 T2884 T4891 T2884 T4891 -5.2193379633047024e-07
Gcorr5436 T2884 T5142 T2884 T5142 -5.4461237270074319e-07
Rt15660 T2884 T5273 512495.39464399242
Gcorr5437 T2884 T5738 T2884 T5738 -4.6499504706622292e-07
Rt15661 T2885 T3501 10940540.340348452
Rt15662 T2885 T3516 21512858.424459819
Rt15663 T2885 T3627 3684746.6862761187
Rt15664 T2885 T3870 1406501.6383417663
Rt15665 T2885 T3999 1667123.8217320552
Rt15666 T2885 T4455 14738443.612969562
Rt15667 T2885 T4459 2978688.401167836
Rt15668 T2885 T5384 8060550.9668377042
Rt15669 T2886 T3642 252537.12344527902
Rt15670 T2886 T3756 3401531.0508548501
Rt15671 T2886 T3877 1918656.2821857363
Rt15672 T2886 T3929 1612188.5158002279
Rt15673 T2886 T5178 8180703.9944856428
Gcorr5438 T2886 T5234 T2886 T5234 -1.2236488605333749e-07
Gcorr5439 T2886 T5599 T2886 T5599 -1.9559389577454847e-06
Rt15674 T2886 T5855 441685.57676822075
Rt15675 T2886 T5997 10668004.024465155
Rt15676 T2887 T2980 744213.02532033727
Rt15677 T2887 T2981 1310598.5662510262
Rt15678 T2887 T3791 1510483.798706356
Rt15679 T2887 T4027 3146036.258368948
Rt15680 T2887 T5188 16088429.788378194
Gcorr5440 T2887 T5189 T2887 T5189 -1.4843084274476827e-07
Rt15681 T2887 T5190 883456.96688108938
Gcorr5441 T2887 T5191 T2887 T5191 -4.2135039628276586e-07
Gcorr5442 T2887 T5993 T2887 T5993 -1.3319873580338271e-07
Rt15682 T2888 T3531 589839.20968824613
Rt15683 T2888 T3686 2807292.2391971895
Rt15684 T2888 T3719 1270726.1340570843
Rt15685 T2888 T3733 2966406.118621082
Gcorr5443 T2888 T5264 T2888 T5264 -4.3791839413479808e-07
Rt15686 T2888 T5325 573759.56095254084
Gcorr5444 T2888 T5604 T2888 T5604 -4.5422466023760229e-07
Gcorr5445 T2888 T5626 T2888 T5626 -4.5328088447371622e-07
Rt15687 T2889 T2890 3745633.7590691368
Rt15688 T2889 T2934 1065144.7380490245
Rt15689 T2889 T2943 2456750.518067189
Rt15690 T2889 T4038 1156287.9300547261
Gcorr5446 T2889 T4913 T2889 T4913 -4.4852052879031287e-07
Rt15691 T2889 T4915 975213.01771072799
Rt15692 T2889 T4917 3343924.5653162585
Gcorr5447 T2889 T4918 T2889 T4918 -2.3614847107454789e-07
Rt15693 T2889 T5679 12425236.343964795
Rt15694 T2890 T2934 1931887.8474155194
Rt15695 T2890 T2935 6404299.3325440176
Rt15696 T2890 T2936 826472.39461445354
Rt15697 T2890 T4040 2631392.1970970668
Rt15698 T2890 T4914 1933812.857930077
Rt15699 T2890 T4915 4753890.4730800129
Rt15700 T2890 T4916 1560604.5652786028
Gcorr5448 T2890 T4954 T2890 T4954 -4.7714848636317e-07
Rt15701 T2891 T2892 1579397.2688035087
Rt15702 T2891 T2893 3335506.0406972594
Rt15703 T2891 T3565 2140718.9312591287
Rt15704 T2891 T3762 1401986.7189500586
Gcorr5449 T2891 T4665 T2891 T4665 -8.0977501245990347e-08
Rt15705 T2891 T4667 2941778.1297796187
Rt15706 T2891 T4683 3751169.037312049
Gcorr5450 T2891 T5531 T2891 T5531 -1.5016683621766543e-07
Rt15707 T2892 T2893 1728152.4302633577
Rt15708 T2892 T2894 3633882.8664982636
Rt15709 T2892 T2901 1714642.7230590184
Rt15710 T2892 T3526 1870846.3397408342
Gcorr5451 T2892 T4664 T2892 T4664 -1.0114593346245435e-07
Rt15711 T2892 T4665 2674381.5918241069
Gcorr5452 T2892 T4683 T2892 T4683 -1.045703604272542e-07
Rt15712 T2892 T5574 3881766.4972274848
Rt15713 T2893 T2894 1780269.9241170806
Rt15714 T2893 T2895 3275254.3244512901
Rt15715 T2893 T2896 1768579.5609813191
Rt15716 T2893 T3565 1904383.8760459884
Rt15717 T2893 T4683 2417976.9204809042
Gcorr5453 T2893 T5532 T2893 T5532 -9.3740632703330083e-08
Rt15718 T2893 T5533 4325100.8143399954
Gcorr5454 T2893 T5574 T2893 T5574 -8.0318681219882818e-08
Rt15719 T2894 T2895 1745610.6130242681
Rt15720 T2894 T2901 1762467.1313171219
Rt15721 T2894 T2902 1743543.4031614081
Rt15722 T2894 T3792 3421867.1561049679
Gcorr5455 T2894 T4710 T2894 T4710 -5.7594182733989701e-08
Gcorr5456 T2894 T5533 T2894 T5533 -7.8994452969418538e-08
Rt15723 T2894 T5574 2472602.1168223293
Rt15724 T2894 T5937 5156366.0354139116
Rt15725 T2895 T2896 1634885.6224450637
Rt15726 T2895 T2916 2045414.027735539
Rt15727 T2895 T3792 1702125.8843509769
Rt15728 T2895 T4026 3334753.2899568565
Rt15729 T2895 T5533 2281603.3796550101
Gcorr5457 T2895 T5534 T2895 T5534 -1.1645401164532587e-07
Gcorr5458 T2895 T5937 T2895 T5937 -1.0125811383033731e-07
Rt15730 T2895 T6005 3696619.9483368644
Rt15731 T2896 T2916 3390409.1118653999
Rt15732 T2896 T2984 2169197.0566816116
Rt15733 T2896 T3219 2332589.6926842658
Rt15734 T2896 T3565 3113256.2841832321
Rt15735 T2896 T5532 2121017.2908721091
Gcorr5459 T2896 T5533 T2896 T5533 -1.0251895660965339e-07
Rt15736 T2896 T5534 4127519.0314237247
Gcorr5460 T2896 T6021 T2896 T6021 -2.2447849772477804e-08
Rt15737 T2897 T2911 1896958.0047295378
Rt15738 T2897 T2987 8688768.1536637004
Rt15739 T2897 T2990 5966939.1879416835
Rt15740 T2897 T4049 473038.54327829526
Rt15741 T2897 T5283 2181260.0858955514
Gcorr5461 T2897 T5284 T2897 T5284 -4.946683950455111e-07
Rt15742 T2897 T5286 2100972.533667847
Rt15743 T2897 T5952 3194398.2751081479
Rt15744 T2898 T2925 1690555.9988891799
Rt15745 T2898 T2927 24665816.764973074
Rt15746 T2898 T2933 10580793.621551121
Rt15747 T2898 T3748 3459819.3388537313
Gcorr5462 T2898 T4294 T2898 T4294 -6.5899812905904873e-07
Rt15748 T2898 T5024 2339452.8960536476
Rt15749 T2898 T5349 2716897.4322493263
Rt15750 T2898 T5770 232832.86766758288
Gcorr5463 T2898 T5880 T2898 T5880 -1.9836336317178562e-07
Rt15751 T2898 T6034 3090097.8881659787
Rt15752 T2899 T2912 1531866.6570283966
Rt15753 T2899 T2913 2054122.1034010833
Rt15754 T2899 T3595 1770927.7456434509
Rt15755 T2899 T4018 2017753.5600043857
Rt15756 T2899 T4244 3360520.2187920348
Gcorr5464 T2899 T4246 T2899 T4246 -1.4763544607604592e-07
Gcorr5465 T2899 T5219 T2899 T5219 -9.3372290973666454e-08
Rt15757 T2899 T5651 2143710.7605581349
Rt15758 T2900 T2914 1629418.6420972974
Rt15759 T2900 T2915 6779961.3477183292
Rt15760 T2900 T3596 2399941.3333228682
Rt15761 T2900 T4020 1162763.3961248484
Rt15762 T2900 T4677 2637296.4917897792
Rt15763 T2900 T5579 3040176.6030736929
Gcorr5466 T2900 T5586 T2900 T5586 -1.5105350407807497e-07
Gcorr5467 T2900 T5867 T2900 T5867 -3.3488828852743181e-08
Rt15764 T2901 T2902 3165479.99914185
Rt15765 T2901 T2903 1724371.7971256394
Rt15766 T2901 T3197 1955026.6634750201
Rt15767 T2901 T3526 3222928.3821152323
Rt15768 T2901 T4664 2223935.3239342156
Gcorr5468 T2901 T4684 T2901 T4684 -8.0296528388414888e-08
Rt15769 T2901 T4710 4756732.8644473068
Gcorr5469 T2901 T5574 T2901 T5574 -9.9485998924295614e-08
Rt15770 T2902 T2903 1566506.4701847376
Rt15771 T2902 T2908 1638124.2807299586
Rt15772 T2902 T2948 5678396.908134372
Rt15773 T2902 T3792 1574573.7878504083
Rt15774 T2902 T4710 1893572.3105942239
Gcorr5470 T2902 T4711 T2902 T4711 -6.1143833622873511e-08
Rt15775 T2902 T4828 6228463.1815182623
Gcorr5471 T2902 T5937 T2902 T5937 -9.477373319189007e-08
Rt15776 T2903 T2908 1721515.0899456199
Rt15777 T2903 T2909 5848114.2260419494
Rt15778 T2903 T3197 3636458.8002935145
Rt15779 T2903 T3831 1577455.7065615924
Rt15780 T2903 T4684 1930029.8603163278
Gcorr5472 T2903 T4710 T2903 T4710 -1.3072466969208801e-07
Rt15781 T2903 T4711 17065438.300814085
Rt15782 T2903 T5957 8368686.4557279358
Rt15783 T2904 T2937 577638539.38118362
Gcorr5473 T2904 T2938 T2904 T2938 -3.4230553280116547e-07
Rt15784 T2904 T2939 3124603.0502652694
Rt15785 T2904 T3662 2869370.1333650714
Gcorr5474 T2904 T4015 T2904 T4015 -2.7829436330315122e-07
Rt15786 T2904 T4296 9823537.6286259405
Rt15787 T2904 T4298 534423.32732761931
Rt15788 T2904 T5120 671153.45849710936
Rt15789 T2904 T5693 795934.34824666171
Rt15790 T2905 T2931 556984.02563730848
Rt15791 T2905 T2949 3924654.9545698012
Rt15792 T2905 T2960 1360558.5878265975
Gcorr5475 T2905 T3905 T2905 T3905 -1.3058188978913805e-07
Rt15793 T2905 T4898 1557094.6051796339
Rt15794 T2905 T5198 34928391.937409252
Gcorr5476 T2905 T5426 T2905 T5426 -3.0662645527400144e-07
Rt15795 T2905 T5967 1959624.7686983978
Rt15796 T2906 T3681 820353.81774531153
Rt15797 T2906 T3798 1026661.8415170513
Rt15798 T2906 T3985 2102503.1339427037
Rt15799 T2906 T4175 818170.08353472932
Rt15800 T2906 T4223 306255.45952996321
Gcorr5477 T2906 T5828 T2906 T5828 -4.8574111976880865e-07
Rt15801 T2907 T3691 3266797.3136840654
Rt15802 T2907 T3808 3959721.8314888417
Rt15803 T2907 T4185 968300.06293782208
Rt15804 T2907 T4191 2570130.5552538023
Rt15805 T2907 T4520 4269911.53538239
Gcorr5478 T2907 T4521 T2907 T4521 -1.3666722795547425e-07
Rt15806 T2907 T4522 2872661.9707997809
Gcorr5479 T2907 T4592 T2907 T4592 -8.2650404293620793e-08
Rt15807 T2908 T2909 436094.42651657498
Rt15808 T2908 T2948 1202910.1884950788
Rt15809 T2908 T2952 1440841.5642771383
Gcorr5480 T2908 T4014 T2908 T4014 -9.50897262847288e-08
Rt15810 T2908 T4711 568516.67330251436
Gcorr5481 T2908 T4828 T2908 T4828 -1.0776546019202778e-07
Rt15811 T2908 T4829 3029070.2866104785
Gcorr5482 T2908 T5150 T2908 T5150 -1.1337876868526185e-07
Gcorr5483 T2908 T5957 T2908 T5957 -1.0270989937008301e-06
Rt15812 T2909 T2952 4236771.6519109961
Rt15813 T2909 T2953 2276215.3365904647
Rt15814 T2909 T2954 16035263.185993347
Rt15815 T2909 T3831 1345139.7872445181
Gcorr5484 T2909 T4711 T2909 T4711 -1.0383033628147999e-06
Rt15816 T2909 T5150 3142569.2755132206
Rt15817 T2909 T5681 3434907.3074366017
Rt15818 T2909 T5957 761033.35876738175
Gcorr5485 T2910 T3424 T2910 T3424 -1.9549666687351157e-07
Rt15819 T2910 T3446 934524.60225534067
Rt15820 T2910 T3621 25049077.842173804
Rt15821 T2910 T3855 862570.1734955078
Gcorr5486 T2910 T4229 T2910 T4229 -6.6828790199337808e-07
Rt15822 T2910 T5214 453813.73823077546
Rt15823 T2910 T5799 799675.38247909723
Rt15824 T2911 T2987 4859834.931482669
Rt15825 T2911 T3085 1979555.0894276542
Rt15826 T2911 T3156 1880308.253756423
Rt15827 T2911 T3915 1975369.0004307404
Rt15828 T2911 T5283 1525485.5493361105
Rt15829 T2911 T5285 5913551.994199845
Rt15830 T2911 T5290 10207513.84962436
Gcorr5487 T2911 T5952 T2911 T5952 -1.0492278174988721e-07
Rt15831 T2912 T2913 4015461.7421032405
Rt15832 T2912 T3005 7060448.9605828309
Rt15833 T2912 T3541 4971651.3000229588
Rt15834 T2912 T4096 1262303.9773848928
Rt15835 T2912 T4241 5325437.9907670813
Gcorr5488 T2912 T4244 T2912 T4244 -8.0764744315462697e-08
Rt15836 T2912 T5219 1720501.9569335415
Rt15837 T2913 T3005 1741314.983469211
Rt15838 T2913 T3006 1397543.9354929638
Rt15839 T2913 T3017 6701425.841935995
Gcorr5489 T2913 T3326 T2913 T3326 -7.0681490250562947e-08
Rt15840 T2913 T4018 1368341.6301413325
Rt15841 T2913 T5219 2201337.0793515956
Gcorr5490 T2913 T5623 T2913 T5623 -1.5025343072963269e-07
Gcorr5491 T2913 T5651 T2913 T5651 -1.3218610503565834e-07
Rt15842 T2913 T5695 1279158.9077765048
Rt15843 T2914 T2915 1632218.9738083093
Rt15844 T2914 T3010 1162244.4167557603
Rt15845 T2914 T3725 13823619.799055245
Rt15846 T2914 T4042 1254432.9461708365
Rt15847 T2914 T5288 1616167.0973137573
Gcorr5492 T2914 T5571 T2914 T5571 -1.8962295861794803e-07
Rt15848 T2914 T5579 3817056.4288431271
Rt15849 T2914 T5586 76652720.417567
Rt15850 T2915 T3010 4321327.3845865969
Rt15851 T2915 T3011 1231031.168606682
Rt15852 T2915 T4020 14293455.99291488
Rt15853 T2915 T4194 397123.68348147231
Gcorr5493 T2915 T5154 T2915 T5154 -2.1572797538527341e-07
Rt15854 T2915 T5571 2298905.0601466056
Rt15855 T2915 T5579 1787359.9547812319
Gcorr5494 T2915 T5618 T2915 T5618 -9.6645343893130018e-08
Rt15856 T2916 T2984 1248427.5780259529
Rt15857 T2916 T3020 1678385.0877113123
Rt15858 T2916 T3054 2514808.6039484036
Rt15859 T2916 T4026 1147545.4461318206
Gcorr5495 T2916 T5038 T2916 T5038 -1.8919797710145996e-07
Rt15860 T2916 T5534 1476820.7262905438
Rt15861 T2916 T5640 5543850.5296733649
Gcorr5496 T2916 T5882 T2916 T5882 -1.7057479252357673e-07
Rt15862 T2916 T6005 5114971.3900372311
Gcorr5497 T2917 T2918 T2917 T2918 -2.7682984724371779e-07
Rt15863 T2917 T3828 1483707.9431399573
Rt15864 T2917 T4122 655259.21516049409
Rt15865 T2917 T4125 196872.16560498485
Rt15866 T2917 T4280 242051.58544179404
Gcorr5498 T2917 T4282 T2917 T4282 -4.417525542453244e-07
Gcorr5499 T2917 T5337 T2917 T5337 -4.4004122860398179e-07
Gcorr5500 T2917 T5338 T2917 T5338 -1.0911477652808557e-07
Rt15867 T2918 T2919 1959752.5480249922
Gcorr5501 T2918 T2920 T2918 T2920 -1.648006722680972e-07
Gcorr5502 T2918 T2945 T2918 T2945 -2.904892522153938e-07
Rt15868 T2918 T4121 1425517.1869679405
Rt15869 T2918 T4122 1042041.4299056762
Rt15870 T2918 T4276 286025.03036114079
Rt15871 T2918 T4279 5543219.0888055786
Rt15872 T2918 T4280 1736232.119100987
Gcorr5503 T2919 T2920 T2919 T2920 -1.2773472038412537e-08
Gcorr5504 T2919 T2922 T2919 T2922 -4.2528624011625636e-08
Gcorr5505 T2919 T2961 T2919 T2961 -1.3049868931701716e-07
Rt15873 T2919 T3514 1206923.6243288396
Gcorr5506 T2919 T4276 T2919 T4276 -1.3385777735214208e-07
Rt15874 T2919 T4278 403853.28846874827
Rt15875 T2919 T4279 711113.78395774821
Rt15876 T2919 T5582 2549337.8674663152
Rt15877 T2919 T5805 3823182.1731147422
Gcorr5507 T2920 T2922 T2920 T2922 -5.7999040427151305e-08
Rt15878 T2920 T2923 3164628.9722358696
Rt15879 T2920 T2945 32876205.946118291
Gcorr5508 T2920 T3680 T2920 T3680 -2.6205308024670342e-07
Rt15880 T2920 T4275 400154.72758970712
Rt15881 T2920 T4276 1882119.4343619642
Rt15882 T2920 T4278 867506.8534913552
Rt15883 T2920 T5865 2245286.0630123038
Gcorr5509 T2921 T3570 T2921 T3570 -1.2237712588378715e-07
Rt15884 T2921 T3830 1769274.6498746804
Rt15885 T2921 T4008 7675877.8190172054
Rt15886 T2921 T4028 2234107.7261682795
Rt15887 T2921 T4125 809894.0168292853
Rt15888 T2921 T4282 509967.85906557698
Rt15889 T2921 T4284 5781504.2086497936
Rt15890 T2921 T5336 1258998.051957319
Rt15891 T2921 T5337 9692647.3798797745
Gcorr5510 T2922 T2923 T2922 T2923 -3.3307359557214523e-09
Rt15892 T2922 T2961 4122565.82367054
Gcorr5511 T2922 T2962 T2922 T2962 -2.5463172975210991e-07
Rt15893 T2922 T3509 2116490.6133130146
Rt15894 T2922 T4278 1038006.958350129
Rt15895 T2922 T5366 488456.74452360504
Rt15896 T2922 T5427 3627623.9717060211
Gcorr5512 T2922 T5805 T2922 T5805 -2.1264411223149023e-07
Rt15897 T2922 T5865 938447.26729428594
Rt15898 T2923 T3509 7745694.706172782
Gcorr5513 T2923 T3680 T2923 T3680 -2.0437691115820167e-09
Gcorr5514 T2923 T3809 T2923 T3809 -2.7257133757268055e-07
Rt15899 T2923 T4031 2453422.8998312647
Gcorr5515 T2923 T4275 T2923 T4275 -2.8543115932843168e-07
Rt15900 T2923 T4466 863574.63726294017
Gcorr5516 T2923 T5427 T2923 T5427 -1.3369948626973328e-08
Rt15901 T2923 T5446 685429.56364344212
Rt15902 T2923 T5865 489380.16263207636
Gcorr5517 T2924 T3355 T2924 T3355 -3.7959058975253323e-07
Gcorr5518 T2924 T3444 T2924 T3444 -4.1744227167343825e-07
Rt15903 T2924 T3518 3495368.8961358406
Rt15904 T2924 T3567 2843830.9621201493
Gcorr5519 T2924 T3926 T2924 T3926 -9.2610168702664037e-09
Rt15905 T2924 T4219 392771.10485736729
Rt15906 T2924 T5759 3058212.37468867
Rt15907 T2924 T5777 749970.0191774274
Rt15908 T2925 T2927 9740816.5778441615
Rt15909 T2925 T2977 3433874.0460917554
Rt15910 T2925 T2978 2785113.7093979819
Rt15911 T2925 T3512 3226266.2810701896
Gcorr5520 T2925 T5000 T2925 T5000 -5.0908846375834031e-08
Rt15912 T2925 T5235 1143543.8716666675
Gcorr5521 T2925 T5770 T2925 T5770 -7.4828605865260874e-07
Rt15913 T2925 T5776 7053490.4693849813
Rt15914 T2925 T5880 273846.8659443456
Rt15915 T2925 T6019 6233987.231604293
Rt15916 T2926 T3442 69587314.252929747
Rt15917 T2926 T3687 775066.83641461737
Rt15918 T2926 T3842 948290.35061870364
Rt15919 T2926 T3890 1255530.6265825757
Gcorr5522 T2926 T5255 T2926 T5255 -1.6942349870986642e-07
Gcorr5523 T2926 T5413 T2926 T5413 -2.4514767693866882e-07
Rt15920 T2926 T5414 10470417.781428797
Rt15921 T2926 T5920 1047249.4763561953
Gcorr5524 T2926 T5948 T2926 T5948 -2.286030768236476e-07
Rt15922 T2927 T2933 3754904.1758400402
Gcorr5525 T2927 T2977 T2927 T2977 -2.6257915873255801e-07
Rt15923 T2927 T2985 2397159.8912567636
Gcorr5526 T2927 T3930 T2927 T3930 -2.5603470155171311e-07
Rt15924 T2927 T3990 1313433.6299223704
Rt15925 T2927 T4999 1585318.565289486
Rt15926 T2927 T5000 1295823.0994719723
Rt15927 T2927 T5024 472106.89745582786
Rt15928 T2927 T5249 155233869.52982026
Rt15929 T2927 T5880 13576729.174203802
Gcorr5527 T2928 T3496 T2928 T3496 -3.7028702818850367e-07
Rt15930 T2928 T3987 2146911.5968747069
Rt15931 T2928 T3998 1644835.266970712
Rt15932 T2928 T4108 4927852.2757504545
Rt15933 T2928 T4217 612158.1389480182
Rt15934 T2928 T5910 680850.30638532224
Gcorr5528 T2928 T5953 T2928 T5953 -3.8345325740489793e-08
Rt15935 T2929 T3556 100641210.44994697
Rt15936 T2929 T3763 961714.82125250984
Rt15937 T2929 T3982 3080024.0216649808
Rt15938 T2929 T4088 1383379.244632076
Rt15939 T2929 T4430 18335581.861034989
Rt15940 T2929 T5567 30670831.557312515
Gcorr5529 T2929 T5701 T2929 T5701 -2.8824776764884725e-07
Rt15941 T2929 T6009 1786440.1571454944
Gcorr5530 T2930 T3437 T2930 T3437 -1.7295002717237681e-07
Rt15942 T2930 T3461 2273029.7925792839
Gcorr5531 T2930 T3462 T2930 T3462 -3.6817934046372136e-07
Rt15943 T2930 T4170 1068082.8679306926
Rt15944 T2930 T4211 871199.63835672266
Rt15945 T2930 T5823 3546496.1663433108
Rt15946 T2930 T5922 609258.91316330188
Rt15947 T2931 T3549 7455898.8080128003
Rt15948 T2931 T3550 2786491.5006080368
Rt15949 T2931 T3905 801560.78871486045
Rt15950 T2931 T4064 2740798.6599037866
Gcorr5532 T2931 T5198 T2931 T5198 -3.4458983635659084e-07
Rt15951 T2931 T5426 601856.16720609763
Gcorr5533 T2931 T5967 T2931 T5967 -5.0836392825750288e-07
Rt15952 T2932 T3454 4165510.2327215979
Rt15953 T2932 T3455 1440541.8622823928
Gcorr5534 T2932 T3456 T2932 T3456 -3.8514189411988111e-07
Rt15954 T2932 T3946 151091.40762599284
Gcorr5535 T2932 T5014 T2932 T5014 -1.2899199059142195e-07
Rt15955 T2932 T5261 223713.31365617062
Gcorr5536 T2932 T5687 T2932 T5687 -2.0836007391773497e-06
Rt15956 T2932 T5973 3277670.7469500224
Rt15957 T2932 T5989 872113.63017688727
Gcorr5537 T2933 T2985 T2933 T2985 -1.0844141790545149e-07
Rt15958 T2933 T2997 15090746.591611326
Rt15959 T2933 T2998 1409980.5648205057
Rt15960 T2933 T3748 3369373.6827147305
Rt15961 T2933 T4184 18975957.750398703
Rt15962 T2933 T5024 114492222.13590226
Rt15963 T2933 T5249 1408278.1952286998
Rt15964 T2933 T5349 536308.34727868543
Gcorr5538 T2933 T5634 T2933 T5634 -3.0774593445987174e-09
Rt15965 T2933 T5969 1970998.5076588101
Rt15966 T2934 T2935 2013974.553583785
Rt15967 T2934 T2943 3859463.3007834326
Rt15968 T2934 T3041 7110043.2453405242
Rt15969 T2934 T4001 1143202.5021732124
Gcorr5539 T2934 T4915 T2934 T4915 -1.5369159181238e-07
Rt15970 T2934 T4916 4818780.5872205803
Rt15971 T2934 T4918 807381.04757101787
Gcorr5540 T2934 T4919 T2934 T4919 -2.0311731943210599e-07
Rt15972 T2935 T2936 820269.5156337762
Rt15973 T2935 T2999 7470737.1355061457
Rt15974 T2935 T3001 3396501.7844288228
Rt15975 T2935 T4001 4161603.1383596659
Rt15976 T2935 T4916 1477955.9005009213
Rt15977 T2935 T4919 3378211.746765079
Gcorr5541 T2935 T4954 T2935 T4954 -4.2553985805454304e-07
Rt15978 T2935 T5883 1312415.0713105639
Rt15979 T2936 T2999 783915.92628741602
Rt15980 T2936 T3000 707572.20282119582
Rt15981 T2936 T3112 2319544.3724572351
Rt15982 T2936 T3553 1165287.8605566439
Gcorr5542 T2936 T4040 T2936 T4040 -3.8979155682652593e-08
Gcorr5543 T2936 T4914 T2936 T4914 -1.5047083246499043e-07
Gcorr5544 T2936 T4916 T2936 T4916 -4.5178947189944902e-07
Rt15983 T2936 T4954 324739.98303130164
Rt15984 T2936 T5657 34547507.593199253
Gcorr5545 T2936 T5658 T2936 T5658 -2.8053689860374954e-07
Gcorr5546 T2936 T5659 T2936 T5659 -4.1411685524922381e-07
Gcorr5547 T2936 T5883 T2936 T5883 -4.1152722433640863e-07
Gcorr5548 T2936 T5896 T2936 T5896 -1.9136226898417376e-08
Rt15985 T2937 T2938 505653.61716533318
Gcorr5549 T2937 T2991 T2937 T2991 -1.0294814417262936e-07
Rt15986 T2937 T2992 330634.15416085836
Rt15987 T2937 T3958 1217631.5611883558
Rt15988 T2937 T4298 19942245.515542693
Gcorr5550 T2937 T5060 T2937 T5060 -1.5927966344617273e-06
Rt15989 T2937 T5062 448747.90340330621
Gcorr5551 T2937 T5308 T2937 T5308 -1.1126153139358172e-06
Rt15990 T2937 T5693 1261150.6917944162
Rt15991 T2937 T5751 269568.38928437518
Gcorr5552 T2937 T6058 T2937 T6058 -4.8127335789685264e-07
Rt15992 T2938 T2939 3047480.0773466663
Rt15993 T2938 T2991 2380678.8275639918
Rt15994 T2938 T2995 3712717.4733236469
Rt15995 T2938 T3229 5521893.0217926344
Gcorr5553 T2938 T3581 T2938 T3581 -1.4935440851122136e-07
Rt15996 T2938 T4955 1233711.4916864198
Rt15997 T2938 T5060 384925.89847064816
Gcorr5554 T2938 T5062 T2938 T5062 -1.4904857922098629e-06
Rt15998 T2938 T5295 15620160.588693552
Rt15999 T2938 T5693 626938.13485333032
Gcorr5555 T2939 T2995 T2939 T2995 -1.2499362808383775e-07
Rt16000 T2939 T3007 3422991.7804810819
Rt16001 T2939 T3008 27609344.761701252
Rt16002 T2939 T4015 364456.29723883502
Rt16003 T2939 T5120 1240324.4512531646
Rt16004 T2939 T5295 880482.37190813466
Gcorr5556 T2939 T5693 T2939 T5693 -6.9210615142689771e-08
Gcorr5557 T2939 T5987 T2939 T5987 -1.0274963041485571e-06
Rt16005 T2939 T6016 561070.34841542842
Rt16006 T2940 T3444 923298.39941862389
Rt16007 T2940 T3601 10805037.069466166
Rt16008 T2940 T3862 6552777.5228575356
Rt16009 T2940 T4186 1122227.5237361568
Rt16010 T2940 T5263 1740163.6733518471
Gcorr5558 T2940 T5321 T2940 T5321 -5.0720044929558245e-07
Rt16011 T2940 T5757 462211.40143036528
Rt16012 T2941 T2986 8525573.2991355527
Rt16013 T2941 T3013 38158196.06499248
Rt16014 T2941 T3034 3137318.9244376263
Rt16015 T2941 T3224 1137274.8849566139
Gcorr5559 T2941 T4624 T2941 T4624 -8.5375528635452949e-08
Rt16016 T2941 T4787 318923.62430278852
Gcorr5560 T2941 T5064 T2941 T5064 -6.9405057859753508e-07
Rt16017 T2941 T5180 94920883.322114065
Rt16018 T2941 T5673 1791616.084186824
Rt16019 T2941 T5875 9204765.5721681286
Rt16020 T2941 T6069 2207868.752128033
Rt16021 T2942 T3799 1423771.8222204007
Rt16022 T2942 T3844 3647943.414546581
Gcorr5561 T2942 T3942 T2942 T3942 -2.6719898673503882e-07
Rt16023 T2942 T3962 12561333.006953953
Rt16024 T2942 T4150 1256859.8014774749
Gcorr5562 T2942 T4221 T2942 T4221 -2.0658295557354159e-07
Rt16025 T2942 T5341 786914.68676012044
Rt16026 T2942 T5817 2124784.4567014514
Rt16027 T2942 T6061 395340.16804765299
Rt16028 T2943 T3041 2121644.21961379
Rt16029 T2943 T3083 13555701.341975583
Rt16030 T2943 T3824 793468.60126236489
Rt16031 T2943 T4038 3431929.8276013564
Gcorr5563 T2943 T4077 T2943 T4077 -1.0254005417649422e-08
Rt16032 T2943 T4918 4389796.4068695595
Rt16033 T2943 T5256 2149292.726802282
Rt16034 T2943 T5679 946461.20000227785
Gcorr5564 T2943 T5748 T2943 T5748 -4.4499573091072585e-07
Gcorr5565 T2944 T3495 T2944 T3495 -2.3378180520726007e-07
Rt16035 T2944 T3591 749634.39085452526
Rt16036 T2944 T3776 776028.85736533499
Rt16037 T2944 T3822 15026714.818375027
Gcorr5566 T2944 T4129 T2944 T4129 -1.1952977193263428e-07
Rt16038 T2944 T5251 596328.11054205813
Gcorr5567 T2944 T5339 T2944 T5339 -5.2668500914525102e-07
Gcorr5568 T2944 T5868 T2944 T5868 -4.7831621433696865e-07
Rt16039 T2944 T5930 730735.26020665385
Rt16040 T2944 T6047 700896.09792882751
Rt16041 T2945 T3487 5825627.2327428134
Rt16042 T2945 T3680 6889846.7691143705
Rt16043 T2945 T3688 3345186.5099518425
Rt16044 T2945 T3989 502785.11843831447
Rt16045 T2945 T4121 467680.27146259102
Gcorr5569 T2945 T4270 T2945 T4270 -2.408755387373076e-07
Gcorr5570 T2945 T4271 T2945 T4271 -1.227950638468822e-07
Rt16046 T2945 T4272 298302.89517596381
Rt16047 T2945 T4275 3208562.2107593901
Rt16048 T2945 T4276 7129082.4555938011
Rt16049 T2945 T5624 6169799.979765391
Gcorr5571 T2945 T5789 T2945 T5789 -3.5394901003043127e-07
Rt16050 T2946 T3590 15185188.554401735
Gcorr5572 T2946 T3712 T2946 T3712 -1.8183723111941291e-07
Rt16051 T2946 T3856 2780183.2616471108
Rt16052 T2946 T3906 960629.02307652868
Rt16053 T2946 T5134 2820576.5821278673
Rt16054 T2946 T5703 1920157.2701499984
Rt16055 T2946 T5899 620763.06751948886
Gcorr5573 T2947 T3396 T2947 T3396 -3.2594065644854135e-08
Gcorr5574 T2947 T3473 T2947 T3473 -2.1619262492508827e-07
Gcorr5575 T2947 T4007 T2947 T4007 -2.8715466255986892e-07
Rt16056 T2947 T4104 1135150.130922958
Rt16057 T2947 T4105 1629875.604420848
Rt16058 T2947 T4224 698270.50943006156
Rt16059 T2947 T5171 1157195.4969010039
Rt16060 T2947 T5870 19055648.62627301
Rt16061 T2948 T3689 2363340.1838765726
Rt16062 T2948 T3792 939690.50418705505
Rt16063 T2948 T4014 1493498.6273047286
Rt16064 T2948 T4026 15617501.141962543
Rt16065 T2948 T4828 1270505.5458776958
Gcorr5576 T2948 T4829 T2948 T4829 -3.1694239346555814e-08
Rt16066 T2948 T4950 7817455.8516196972
Gcorr5577 T2948 T5038 T2948 T5038 -6.8657221891279194e-09
Rt16067 T2949 T2960 1774850.1359175781
Rt16068 T2949 T2993 4535019.3311566235
Rt16069 T2949 T3541 2235084.1949794958
Rt16070 T2949 T3806 2009930.1487455177
Rt16071 T2949 T4242 2729085.6579166497
Rt16072 T2949 T4243 5510082.9289095215
Rt16073 T2949 T4898 3946168.3325017323
Rt16074 T2950 T3835 900642.06402190495
Rt16075 T2950 T3971 1397548.6457657046
Rt16076 T2950 T4101 1023857.3680560715
Rt16077 T2950 T4361 13029046.943356914
Gcorr5578 T2950 T4363 T2950 T4363 -5.2192337012469364e-08
Rt16078 T2950 T4387 2949988.0859179902
Gcorr5579 T2950 T5267 T2950 T5267 -1.2379584714153609e-07
Gcorr5580 T2951 T3382 T2951 T3382 -1.5606965448511301e-07
Gcorr5581 T2951 T3456 T2951 T3456 -1.5445106258724093e-07
Rt16079 T2951 T3984 12009916.105218148
Rt16080 T2951 T4046 950723.90778791578
Rt16081 T2951 T4093 709726.07425443968
Rt16082 T2951 T4209 430145.69666858698
Rt16083 T2951 T5275 17454349.268946789
Rt16084 T2951 T5576 12456407.50008864
Rt16085 T2952 T2953 4499525.9600470457
Rt16086 T2952 T2979 979096.70473264996
Rt16087 T2952 T3286 2362683.5831910246
Rt16088 T2952 T4014 15851300.707348628
Rt16089 T2952 T4829 2665807.296363154
Rt16090 T2952 T5150 996924.46228984674
Gcorr5582 T2952 T5847 T2952 T5847 -1.1853194530967825e-07
Rt16091 T2953 T2954 1709573.7505314401
Rt16092 T2953 T2979 705941.15720633324
Gcorr5583 T2953 T3009 T2953 T3009 -4.3118713230162107e-08
Rt16093 T2953 T4181 1250720.1450488809
Gcorr5584 T2953 T4619 T2953 T4619 -1.7647095485060564e-07
Rt16094 T2953 T5150 1932018.3102202876
Rt16095 T2953 T5655 896803.777169668
Rt16096 T2953 T5681 3338685.7539609349
Gcorr5585 T2953 T5847 T2953 T5847 -4.6405711590074818e-07
Rt16097 T2954 T3734 1821520.3586728231
Rt16098 T2954 T3735 6539046.4931522645
Rt16099 T2954 T3779 1060308.345931231
Rt16100 T2954 T3831 87296432.402042657
Gcorr5586 T2954 T4181 T2954 T4181 -1.6176827279048206e-08
Rt16101 T2954 T4465 70732642.967622593
Rt16102 T2954 T4619 1622936.4413200435
Rt16103 T2954 T5681 1849911.7478652033
Rt16104 T2955 T3801 823904.3126557928
Rt16105 T2955 T3923 2208673.3614241355
Rt16106 T2955 T4016 1159199.535995319
Rt16107 T2955 T4139 2904668.4905773499
Rt16108 T2955 T4326 649687.40560993901
Gcorr5587 T2955 T4327 T2955 T4327 -5.2331651667899031e-07
Gcorr5588 T2955 T4330 T2955 T4330 -6.4906056543892565e-07
Rt16109 T2956 T3701 3242894.9970510844
Rt16110 T2956 T3743 1093361.4350487674
Rt16111 T2956 T3883 3046215.1811413234
Rt16112 T2956 T3909 1252070.2363020685
Rt16113 T2956 T4389 1329118.8154372671
Gcorr5589 T2956 T4392 T2956 T4392 -3.3473588056419359e-07
Rt16114 T2956 T4393 12163486.784901287
Gcorr5590 T2956 T5417 T2956 T5417 -1.161543790430341e-07
Rt16115 T2957 T3540 1896914.3763597996
Rt16116 T2957 T3693 1316901.9412939141
Rt16117 T2957 T3826 1515146.8656744477
Rt16118 T2957 T4036 2943688.6085192394
Gcorr5591 T2957 T4366 T2957 T4366 -1.64780131531271e-07
Rt16119 T2957 T4367 1734267.7396969215
Rt16120 T2957 T4368 11648274.689026913
Gcorr5592 T2957 T4370 T2957 T4370 -1.2841177091515693e-07
Rt16121 T2958 T3523 4948672.1202053018
Rt16122 T2958 T3786 18682807.14130789
Rt16123 T2958 T3866 1069173.042505499
Rt16124 T2958 T4043 1225900.0212865004
Rt16125 T2958 T4083 1700345.2377992107
Rt16126 T2958 T4214 412307.51394932321
Gcorr5593 T2958 T5706 T2958 T5706 -2.0031192244052369e-07
Rt16127 T2959 T3608 1708822.6880447359
Rt16128 T2959 T3614 3224204.2084661969
Rt16129 T2959 T3683 4829172.1357149603
Rt16130 T2959 T3873 1206084.0192682194
Gcorr5594 T2959 T4512 T2959 T4512 -8.9296360491312769e-08
Rt16131 T2959 T4514 2470960.6016044258
Rt16132 T2959 T4515 10916900.389649281
Rt16133 T2960 T2993 1573953.4821478336
Rt16134 T2960 T3037 7669572.3778865822
Rt16135 T2960 T3138 2401524.5922962632
Gcorr5595 T2960 T3905 T2960 T3905 -5.6733411985510821e-08
Gcorr5596 T2960 T4242 T2960 T4242 -9.179549487045955e-08
Rt16136 T2960 T4898 2885088.0383516983
Rt16137 T2960 T5196 1276864.070324302
Rt16138 T2960 T5198 3875992.0733202365
Rt16139 T2961 T2962 9354999.8023810145
Rt16140 T2961 T3021 7005988.3518376024
Rt16141 T2961 T3022 7054436.052089707
Rt16142 T2961 T3514 498853.56852428289
Rt16143 T2961 T5026 1720872.9953762777
Rt16144 T2961 T5366 11582562.612869315
Gcorr5597 T2961 T5582 T2961 T5582 -8.9607026615295913e-07
Rt16145 T2961 T5805 361049.56168307096
Rt16146 T2961 T5940 1360859.638157557
Rt16147 T2962 T3021 6875789.9385389201
Rt16148 T2962 T3023 2045965.5426816121
Rt16149 T2962 T3024 2203969.1842818428
Rt16150 T2962 T3509 428501.21137066901
Rt16151 T2962 T4984 1072485.253831015
Gcorr5598 T2962 T5044 T2962 T5044 -1.8567539521356904e-07
Rt16152 T2962 T5238 927870.46739813068
Rt16153 T2962 T5366 504205.5903699898
Gcorr5599 T2962 T5427 T2962 T5427 -1.114412866646631e-06
Gcorr5600 T2962 T5940 T2962 T5940 -4.6802452077343289e-09
Rt16154 T2963 T3708 2979075.3763488946
Rt16155 T2963 T3875 3560144.3741074647
Rt16156 T2963 T3932 1302782.0237732246
Rt16157 T2963 T4071 2385391.187161047
Rt16158 T2963 T4832 9086705.246521445
Rt16159 T2963 T5918 16916282.73715027
Rt16160 T2963 T5983 9145363.602572931
Gcorr5601 T2964 T3402 T2964 T3402 -4.7659737239733131e-09
Rt16161 T2964 T3427 1897882.7428325024
Gcorr5602 T2964 T3500 T2964 T3500 -8.6216225353242244e-08
Rt16162 T2964 T3825 1763796.8449594909
Rt16163 T2964 T4190 577252.06019275391
Rt16164 T2964 T5348 378390.11175195593
Gcorr5603 T2964 T5675 T2964 T5675 -1.5889434123395694e-07
Gcorr5604 T2964 T5761 T2964 T5761 -1.7080098406736066e-08
Rt16165 T2965 T3609 7669468.8899573451
Rt16166 T2965 T3698 1002626.4499684306
Rt16167 T2965 T3940 1094452.0750663911
Rt16168 T2965 T4023 2230073.3724858882
Gcorr5605 T2965 T4485 T2965 T4485 -1.4512486998291776e-07
Gcorr5606 T2965 T4488 T2965 T4488 -2.2345519318947939e-07
Gcorr5607 T2965 T5041 T2965 T5041 -4.3835406394879043e-07
Rt16169 T2965 T5559 854009.98500245623
Rt16170 T2966 T2967 3727489.1412652126
Rt16171 T2966 T2968 1768850.7309283966
Rt16172 T2966 T3720 1847932.4825855524
Rt16173 T2966 T3848 2750115.8492611023
Gcorr5608 T2966 T4611 T2966 T4611 -7.0474726212728142e-08
Rt16174 T2966 T4612 3764365.7672781381
Rt16175 T2966 T4695 2737346.8933688188
Gcorr5609 T2966 T4696 T2966 T4696 -1.2337413867146816e-07
Rt16176 T2967 T2968 1681970.4446602645
Rt16177 T2967 T2969 1645210.1780000788
Rt16178 T2967 T2970 2044109.9646813213
Rt16179 T2967 T3620 2373634.3377402201
Rt16180 T2967 T4695 3404104.8101166519
Gcorr5610 T2967 T4760 T2967 T4760 -1.2431340658076711e-07
Rt16181 T2967 T4761 2874680.8892752854
Rt16182 T2967 T5478 10422133.376925057
Gcorr5611 T2967 T5968 T2967 T5968 -1.2039746803109574e-07
Rt16183 T2968 T2969 3399882.7211190392
Rt16184 T2968 T2973 1805338.779974903
Rt16185 T2968 T2976 2114589.6886195811
Rt16186 T2968 T3720 3344207.7809509598
Gcorr5612 T2968 T4695 T2968 T4695 -6.0889480300823636e-08
Rt16187 T2968 T4696 3569893.3387034144
Rt16188 T2968 T4760 2634682.4046957684
Gcorr5613 T2968 T5812 T2968 T5812 -1.0830540813055316e-07
Rt16189 T2969 T2970 1627873.5993007338
Rt16190 T2969 T2971 5568399.9427500945
Rt16191 T2969 T2973 1811972.3276276768
Rt16192 T2969 T4060 1664484.1564923276
Rt16193 T2969 T4760 3159214.0545551134
Gcorr5614 T2969 T4761 T2969 T4761 -3.1150943178915081e-08
Rt16194 T2969 T4855 2855525.9253369635
Gcorr5615 T2969 T5914 T2969 T5914 -1.3000034924950387e-07
Rt16195 T2970 T2971 1660562.6913453932
Rt16196 T2970 T2972 4679092.8163930625
Rt16197 T2970 T3161 2280011.2521553957
Rt16198 T2970 T3620 3165381.8424438629
Rt16199 T2970 T4761 5154294.0273492476
Gcorr5616 T2970 T4855 T2970 T4855 -1.1866546781211402e-07
Rt16200 T2970 T4856 2694148.9167012447
Rt16201 T2970 T5968 6016939.8453574451
Rt16202 T2971 T2972 1669057.3122065191
Rt16203 T2971 T2974 4705125.9086604398
Rt16204 T2971 T2988 30566616.529861562
Rt16205 T2971 T4060 963397.20158858108
Rt16206 T2971 T4855 4911174.5011603413
Rt16207 T2971 T4856 102638788.43998961
Rt16208 T2971 T4956 1947145.8475125795
Rt16209 T2972 T2974 1716010.2840338354
Rt16210 T2972 T2975 8493249.0713546295
Rt16211 T2972 T3161 1823839.2250372996
Rt16212 T2972 T3790 1238203.6606062169
Rt16213 T2972 T4856 1907661.2022169905
Gcorr5617 T2972 T4956 T2972 T4956 -1.1298919188023325e-07
Rt16214 T2972 T5021 2036911.4631577646
Gcorr5618 T2972 T5022 T2972 T5022 -8.0557983464829212e-08
Rt16215 T2973 T2976 3728462.5811489727
Rt16216 T2973 T3028 744230.01580911421
Rt16217 T2973 T3933 1906602.6569277637
Rt16218 T2973 T4060 2689121.9139177962
Gcorr5619 T2973 T4760 T2973 T4760 -6.8519111080497576e-08
Rt16219 T2973 T5812 5596391.2860142877
Rt16220 T2973 T5914 1011114.9391452622
Gcorr5620 T2973 T6084 T2973 T6084 -5.0797238622947641e-07
Rt16221 T2974 T2975 1806182.0062955883
Rt16222 T2974 T2988 1691914.5349154412
Rt16223 T2974 T3039 5779875.2338755541
Rt16224 T2974 T3894 7954234.1863632714
Rt16225 T2974 T4956 1631890.5365813023
Rt16226 T2974 T5021 15489978.445317689
Rt16227 T2974 T5025 1692784.2946562953
Gcorr5621 T2974 T5923 T2974 T5923 -1.787666421230814e-08
Rt16228 T2975 T3039 1622297.9643405429
Rt16229 T2975 T3040 1994873.9795488189
Rt16230 T2975 T3051 2405940.6893840753
Gcorr5622 T2975 T3203 T2975 T3203 -9.3091385563630391e-08
Rt16231 T2975 T3790 1876405.6686461226
Rt16232 T2975 T5021 1224721.5125768047
Gcorr5623 T2975 T5025 T2975 T5025 -1.1049104400237432e-07
Rt16233 T2975 T5165 1644079.9172550694
Rt16234 T2975 T5716 2923131.2042711042
Gcorr5624 T2975 T5837 T2975 T5837 -2.093131518540407e-07
Rt16235 T2976 T3028 1532487.5223406584
Rt16236 T2976 T3029 2936363.1455687955
Rt16237 T2976 T3720 1527864.0870252093
Rt16238 T2976 T4102 2048750.5996478938
Gcorr5625 T2976 T4696 T2976 T4696 -8.7533468797575008e-08
Rt16239 T2976 T4717 2858732.151048644
Gcorr5626 T2976 T4839 T2976 T4839 -1.3897956750685944e-07
Rt16240 T2976 T5812 2270874.734622811
Gcorr5627 T2977 T2978 T2977 T2978 -8.7065711278428125e-08
Rt16241 T2977 T3030 4869490.0206539407
Gcorr5628 T2977 T3032 T2977 T3032 -4.0947732580732298e-08
Rt16242 T2977 T3833 1208994.2480936507
Rt16243 T2977 T3990 3033728.2931289836
Gcorr5629 T2977 T4998 T2977 T4998 -8.6837249286548336e-08
Rt16244 T2977 T5000 700009.89587264368
Rt16245 T2977 T5316 976986.47577992571
Rt16246 T2977 T5776 2072749.8999011698
Rt16247 T2978 T3030 1176039.0374483215
Rt16248 T2978 T3031 1867075.0660339692
Rt16249 T2978 T3063 7122389.0508693131
Rt16250 T2978 T3512 3424536.4004548313
Rt16251 T2978 T5114 1173747.6154073663
Rt16252 T2978 T5235 3843439.0076146941
Rt16253 T2978 T5428 16671009.632729365
Gcorr5630 T2978 T5775 T2978 T5775 -4.299852849154803e-07
Rt16254 T2978 T5776 574381.61122698477
Rt16255 T2979 T3009 1637347.0839761009
Rt16256 T2979 T3035 822932.53356247034
Rt16257 T2979 T3286 1850093.2438165732
Gcorr5631 T2979 T3951 T2979 T3951 -1.0255058238236329e-07
Gcorr5632 T2979 T5033 T2979 T5033 -1.6350840801782132e-07
Gcorr5633 T2979 T5150 T2979 T5150 -5.5334560020194037e-07
Rt16258 T2979 T5352 159111346.55425629
Gcorr5634 T2979 T5655 T2979 T5655 -6.6061051621075353e-08
Rt16259 T2979 T5847 365673.15521216899
Rt16260 T2980 T2981 3500883.4962135754
Rt16261 T2980 T3080 2078830.3314005923
Rt16262 T2980 T3431 5321012.951831637
Rt16263 T2980 T3564 1539695.5870727343
Rt16264 T2980 T5189 2034811.4858502245
Gcorr5635 T2980 T5190 T2980 T5190 -4.2049632773678621e-07
Rt16265 T2980 T5191 2741981.2511207946
Rt16266 T2980 T5192 6518004.7779911449
Rt16267 T2981 T3080 1931969.5782774047
Rt16268 T2981 T3081 3565636.72888888
Rt16269 T2981 T3082 3467832.6264807014
Rt16270 T2981 T4027 1311910.5749610937
Gcorr5636 T2981 T5190 T2981 T5190 -1.60798814830618e-07
Rt16271 T2981 T5191 1707266.5510262069
Rt16272 T2981 T5193 6153622.0561313052
Rt16273 T2981 T6056 9451498.7372090556
Rt16274 T2982 T3606 2424194.9040765688
Rt16275 T2982 T3694 4917649.1831230819
Rt16276 T2982 T3892 2406536.2302459064
Rt16277 T2982 T4005 2659484.2574131466
Rt16278 T2982 T4055 4908330.7837491659
Gcorr5637 T2982 T4506 T2982 T4506 -8.6319142604700374e-08
Rt16279 T2982 T4652 2080455.5093042394
Rt16280 T2982 T5488 8559219.1394882444
Gcorr5638 T2982 T6049 T2982 T6049 -7.6501548185353964e-08
Rt16281 T2983 T3878 2201584.4328429196
Rt16282 T2983 T3879 8595905.9109719228
Rt16283 T2983 T3911 4493053.1558349766
Rt16284 T2983 T4157 1143469.9375218917
Rt16285 T2983 T5297 3701951.4547119322
Rt16286 T2983 T5423 8546322.0315496698
Gcorr5639 T2983 T5766 T2983 T5766 -8.197285806867173e-08
Rt16287 T2984 T3020 4072252.6461667265
Rt16288 T2984 T3027 7176973.1292942781
Rt16289 T2984 T3219 1986067.7837814065
Rt16290 T2984 T3703 1302636.3652262883
Gcorr5640 T2984 T5319 T2984 T5319 -1.5114224545573108e-07
Gcorr5641 T2984 T5534 T2984 T5534 -1.7617625419218566e-07
Rt16291 T2984 T5882 1251536.4571009493
Rt16292 T2984 T6021 2949465.9629704035
Gcorr5642 T2985 T3052 T2985 T3052 -1.6063044542895096e-07
Rt16293 T2985 T3053 2865989.6573713962
Rt16294 T2985 T3930 1006532.4809834479
Rt16295 T2985 T4184 740205.76865731424
Gcorr5643 T2985 T4999 T2985 T4999 -1.6191341981464618e-07
Rt16296 T2985 T5249 918242.14712140569
Rt16297 T2985 T5326 5105460.5127944127
Rt16298 T2985 T5832 1662299.3757186239
Rt16299 T2986 T3013 1706251.2022979241
Rt16300 T2986 T3014 1678731.0491570302
Gcorr5644 T2986 T3069 T2986 T3069 -7.6332144415199025e-08
Rt16301 T2986 T3525 3610691.867601587
Rt16302 T2986 T4750 4310515.8829605915
Rt16303 T2986 T4988 708222.94597333425
Rt16304 T2986 T5673 709167.42571460526
Gcorr5645 T2986 T5724 T2986 T5724 -4.9823862114797631e-07
Rt16305 T2986 T5875 1292232.09322663
Rt16306 T2987 T3156 464762.82659021061
Rt16307 T2987 T3158 9715816.5149537455
Gcorr5646 T2987 T3397 T2987 T3397 -8.1660222271756442e-08
Rt16308 T2987 T4049 430975.33587153204
Gcorr5647 T2987 T5281 T2987 T5281 -5.2531497387093714e-07
Rt16309 T2987 T5282 964656.62931271002
Rt16310 T2987 T5283 964520.24317979615
Gcorr5648 T2987 T5284 T2987 T5284 -4.24138510929808e-07
Rt16311 T2988 T3894 9469137.1294633336
Rt16312 T2988 T3933 8707062.8546020929
Rt16313 T2988 T3934 639423.23310388206
Rt16314 T2988 T4060 1680750.3993816511
Rt16315 T2988 T4956 7520434.540685676
Rt16316 T2988 T5029 1603382.8188845159
Rt16317 T2988 T5923 1161975.0354494206
Gcorr5649 T2988 T5945 T2988 T5945 -4.74087055079633e-07
Rt16318 T2989 T3891 103447.03462692784
Rt16319 T2989 T4050 1028993.3606140373
Rt16320 T2989 T4109 1957763.9696792958
Rt16321 T2989 T4320 331207.97910687706
Gcorr5650 T2989 T4322 T2989 T4322 -2.9949728586315022e-06
Rt16322 T2989 T4342 3761787.8159153988
Gcorr5651 T2989 T5727 T2989 T5727 -9.4449352190111708e-08
Rt16323 T2990 T3725 6597977.5527617857
Rt16324 T2990 T3726 4294721.881565785
Rt16325 T2990 T4042 1089827.8927965462
Rt16326 T2990 T4049 771114.60951289535
Gcorr5652 T2990 T5284 T2990 T5284 -5.8984174979978186e-08
Rt16327 T2990 T5286 1718740.9050039994
Rt16328 T2990 T5287 2280107.6471473495
Rt16329 T2991 T2992 2898238.9832879151
Rt16330 T2991 T3044 2842298.4142848542
Rt16331 T2991 T3050 7518312.8046319671
Rt16332 T2991 T3229 1810269.6131814192
Rt16333 T2991 T4090 9018007.925909467
Rt16334 T2991 T5060 6535212.9034554176
Rt16335 T2991 T5061 1567881.3720361162
Rt16336 T2991 T5062 576398.30838510918
Rt16337 T2991 T5262 9845159.849188026
Gcorr5653 T2991 T6058 T2991 T6058 -1.8339205707280995e-07
Rt16338 T2992 T3044 3215188.1927531976
Rt16339 T2992 T3045 2106924.4155844781
Rt16340 T2992 T3046 1974044.5188417889
Rt16341 T2992 T3958 20167266.101301521
Gcorr5654 T2992 T4995 T2992 T4995 -2.0228966005876085e-07
Gcorr5655 T2992 T5062 T2992 T5062 -4.2315419875373185e-07
Rt16342 T2992 T5308 577469.53822673031
Gcorr5656 T2992 T5751 T2992 T5751 -1.1469323479251445e-06
Rt16343 T2992 T5978 3382564.1205060109
Rt16344 T2992 T6058 538460.98826525302
Rt16345 T2993 T3037 2208656.6394688045
Rt16346 T2993 T3159 2900959.0092236167
Gcorr5657 T2993 T3541 T2993 T3541 -6.6552638746871762e-08
Rt16347 T2993 T3863 927193.49528654746
Gcorr5658 T2993 T4240 T2993 T4240 -1.1633147826264952e-07
Rt16348 T2993 T4242 964324.88060813397
Gcorr5659 T2993 T5196 T2993 T5196 -2.423869351208177e-08
Rt16349 T2993 T5810 2144493.1272687516
Gcorr5660 T2994 T3385 T2994 T3385 -4.662282613185886e-08
Rt16350 T2994 T3387 1546756.4095805176
Rt16351 T2994 T3388 9861175.6025367416
Rt16352 T2994 T3967 1338365.7794135811
Rt16353 T2994 T4208 844651.16423726303
Rt16354 T2994 T5185 1586195.8647260212
Rt16355 T2994 T5840 2609519.1482867342
Gcorr5661 T2994 T6044 T2994 T6044 -3.4158564752927866e-07
Rt16356 T2995 T3007 3113197.9717221302
Rt16357 T2995 T3061 3289138.6971503566
Rt16358 T2995 T3062 12121788.737758059
Rt16359 T2995 T3581 1399382.9411884802
Rt16360 T2995 T4824 1338350.8344866736
Rt16361 T2995 T4955 4311679.5937313745
Rt16362 T2995 T5295 1062827.4651341401
Rt16363 T2995 T5873 11919252.297689842
Rt16364 T2996 T3372 579165.90553334041
Rt16365 T2996 T3374 3021170.8161780676
Rt16366 T2996 T3375 1880439.7416059226
Rt16367 T2996 T3963 414654.95653153065
Rt16368 T2996 T4204 6808649.569894298
Rt16369 T2996 T4227 272569.877693374
Gcorr5662 T2996 T5376 T2996 T5376 -5.8157024790175004e-07
Gcorr5663 T2996 T5782 T2996 T5782 -3.2472670389370722e-09
Gcorr5664 T2996 T6083 T2996 T6083 -1.0097299819203372e-06
Rt16370 T2997 T2998 1947816.1261154818
Gcorr5665 T2997 T3025 T2997 T3025 -2.0655878577702991e-07
Rt16371 T2997 T4075 973164.04965110321
Rt16372 T2997 T4183 1164153.5688604971
Rt16373 T2997 T4184 1151198.7561241635
Rt16374 T2997 T4735 3410655.4586233888
Gcorr5666 T2997 T5257 T2997 T5257 -6.4462230191141613e-08
Rt16375 T2997 T5909 96049633.558617353
Rt16376 T2997 T5969 1008846.9137513472
Rt16377 T2998 T3025 2634506.6076904438
Rt16378 T2998 T3026 1456820.6755380249
Rt16379 T2998 T3157 1513733.0918070874
Gcorr5667 T2998 T3748 T2998 T3748 -1.6697855816273037e-07
Gcorr5668 T2998 T4301 T2998 T4301 -1.7537493163746684e-07
Rt16380 T2998 T4304 5606941.6241260786
Rt16381 T2998 T4735 2375567.3810044732
Rt16382 T2998 T5634 560271.32144750934
Gcorr5669 T2998 T5969 T2998 T5969 -1.1643974212740244e-07
Rt16383 T2999 T3000 14059815.604138415
Rt16384 T2999 T3001 1702074.2326819913
Rt16385 T2999 T3162 1449200.2866573059
Rt16386 T2999 T3925 9741067.7229328267
Gcorr5670 T2999 T4954 T2999 T4954 -4.3658415941625635e-07
Gcorr5671 T2999 T5112 T2999 T5112 -1.1377343503609821e-08
Rt16387 T2999 T5659 787045.10375437734
Rt16388 T2999 T5883 1208411.8503631759
Rt16389 T3000 T3112 11977890.254769119
Rt16390 T3000 T3113 1688631.9162734973
Rt16391 T3000 T3114 1402264.5470585593
Rt16392 T3000 T3925 2297441.0592538072
Rt16393 T3000 T4816 9395514.8316527791
Gcorr5672 T3000 T4954 T3000 T4954 -4.8027185141968369e-07
Rt16394 T3000 T5658 855628.64543309389
Rt16395 T3000 T5659 1156409.5120513351
Gcorr5673 T3000 T5864 T3000 T5864 -2.0055462972009721e-07
Gcorr5674 T3001 T3162 T3001 T3162 -9.7552551735576619e-09
Gcorr5675 T3001 T3520 T3001 T3520 -1.4704340092683099e-07
Rt16396 T3001 T3837 3048193.0302388188
Rt16397 T3001 T4001 1341293.2532280218
Rt16398 T3001 T4919 2255136.1708644307
Rt16399 T3001 T4921 2339046.4327668599
Rt16400 T3001 T5112 786736.49328503723
Rt16401 T3001 T5883 33423415.05115388
Rt16402 T3002 T3434 17753089.856696341
Rt16403 T3002 T3846 432125.36295981356
Rt16404 T3002 T4136 841598.26629781071
Rt16405 T3002 T4210 478464.0015938147
Gcorr5676 T3002 T5245 T3002 T5245 -1.0840908551237695e-08
Rt16406 T3002 T5301 3243151.2006430025
Gcorr5677 T3002 T5996 T3002 T5996 -8.9930649143928574e-07
Rt16407 T3003 T3401 1288718.74716017
Rt16408 T3003 T3807 2049767.7265313312
Gcorr5678 T3003 T3823 T3003 T3823 -1.8484182964930621e-07
Rt16409 T3003 T4033 3580889.3698112085
Rt16410 T3003 T4052 1061073.6332457322
Rt16411 T3003 T4053 1720716.2213034767
Rt16412 T3003 T4203 5555332.2089983774
Rt16413 T3003 T4226 386111.43892974232
Gcorr5679 T3003 T5383 T3003 T5383 -3.4049726024956775e-07
Gcorr5680 T3004 T3458 T3004 T3458 -1.5686878889003451e-07
Gcorr5681 T3004 T3463 T3004 T3463 -4.7099217706739347e-08
Rt16414 T3004 T3761 1022046.9463229132
Rt16415 T3004 T4135 413162.32460741664
Rt16416 T3004 T4225 2240024.852352269
Gcorr5682 T3004 T5183 T3004 T5183 -7.0696165845476797e-07
Gcorr5683 T3004 T5368 T3004 T5368 -3.310775971209369e-08
Rt16417 T3004 T6036 411152.72442555876
Rt16418 T3005 T3006 3594501.016240865
Rt16419 T3005 T3136 2280428.729473453
Gcorr5684 T3005 T3137 T3005 T3137 -2.3813083384233342e-08
Rt16420 T3005 T4096 378174.92280126939
Rt16421 T3005 T4239 1335873.9294306124
Gcorr5685 T3005 T4241 T3005 T4241 -7.1314811482448667e-07
Rt16422 T3005 T5219 1195808.1626357439
Rt16423 T3005 T5623 5104283.3666247847
Rt16424 T3006 T3017 651866.21270792186
Rt16425 T3006 T3018 605068.73493709136
Rt16426 T3006 T3136 1504564.8473130139
Rt16427 T3006 T3938 649522.21093720896
Gcorr5686 T3006 T4238 T3006 T4238 -3.9941909388355638e-07
Rt16428 T3006 T5623 349588.90666819864
Gcorr5687 T3006 T5695 T3006 T5695 -4.2229161652829073e-07
Gcorr5688 T3006 T5833 T3006 T5833 -4.5936238783803537e-07
Gcorr5689 T3006 T6029 T3006 T6029 -4.1907184491346195e-07
Rt16429 T3007 T3008 1718373.9269662073
Gcorr5690 T3007 T3061 T3007 T3061 -5.9276193702819248e-08
Rt16430 T3007 T3071 744230.31742334354
Rt16431 T3007 T3211 2607421.1548081702
Rt16432 T3007 T4048 1749273.62370526
Gcorr5691 T3007 T4475 T3007 T4475 -1.5026225245377526e-07
Rt16433 T3007 T4477 14324587.775463376
Rt16434 T3007 T4823 548810.4232724735
Gcorr5692 T3007 T5295 T3007 T5295 -1.7288240862572031e-07
Rt16435 T3007 T5873 1309486.5393869402
Gcorr5693 T3007 T5934 T3007 T5934 -7.4387844841930349e-07
Rt16436 T3007 T6016 3794976.8844551044
Rt16437 T3008 T3071 3221551.702472866
Rt16438 T3008 T3072 2011725.4428326392
Rt16439 T3008 T3073 2236990.918161294
Rt16440 T3008 T4015 1578412.3653662326
Gcorr5694 T3008 T4823 T3008 T4823 -1.7434716684246848e-07
Rt16441 T3008 T5306 6836358.5543042198
Gcorr5695 T3008 T5728 T3008 T5728 -3.0929620793130834e-09
Rt16442 T3008 T5749 971488.43640368676
Rt16443 T3008 T5934 6086626.9084385224
Rt16444 T3008 T5987 7573993.505461555
Rt16445 T3008 T6016 2989838.2459828835
Gcorr5696 T3009 T3035 T3009 T3035 -4.3938203180807528e-08
Rt16446 T3009 T3084 2160367.4925103569
Rt16447 T3009 T3160 3285456.6961677643
Rt16448 T3009 T4181 1086830.0722922287
Rt16449 T3009 T4756 1826924.8557504031
Gcorr5697 T3009 T5032 T3009 T5032 -1.7724880002259399e-07
Rt16450 T3009 T5033 763488.75780939357
Rt16451 T3009 T5655 2036471.0398212702
Rt16452 T3010 T3011 5093406.2449954804
Rt16453 T3010 T3139 1598493.2602208927
Rt16454 T3010 T3140 188952224.60002363
Rt16455 T3010 T3725 1818760.6437908327
Gcorr5698 T3010 T5288 T3010 T5288 -6.2361931516724046e-08
Rt16456 T3010 T5293 2929334.4279636662
Rt16457 T3010 T5571 1167852.9409304305
Rt16458 T3011 T3015 6854134.7653556718
Rt16459 T3011 T3016 6833739.7713118689
Rt16460 T3011 T3139 2237886.1887224433
Rt16461 T3011 T3939 1661799.457684736
Gcorr5699 T3011 T4194 T3011 T4194 -1.3973439572852388e-07
Rt16462 T3011 T5154 1257637.4524832866
Rt16463 T3011 T5571 3020897.9567357716
Rt16464 T3011 T5753 10383105.842971204
Rt16465 T3012 T3481 1085045.4620128265
Gcorr5700 T3012 T3482 T3012 T3482 -5.8098812143131339e-08
Rt16466 T3012 T3817 1489842.4214910001
Rt16467 T3012 T4124 369546.93005101342
Gcorr5701 T3012 T4199 T3012 T4199 -1.5832839496614385e-07
Rt16468 T3012 T5119 5373255.8783458835
Gcorr5702 T3012 T5177 T3012 T5177 -4.9607677940523808e-07
Rt16469 T3012 T5405 261526.36507727561
Rt16470 T3012 T5859 5660519.7060001679
Gcorr5703 T3012 T6013 T3012 T6013 -4.3993025984190817e-07
Rt16471 T3013 T3014 1108915.7742571554
Rt16472 T3013 T3034 6540629.9788678149
Rt16473 T3013 T3067 2173389.7021880616
Rt16474 T3013 T3176 271956698.48721474
Rt16475 T3013 T3847 2596707.7326330803
Gcorr5704 T3013 T4750 T3013 T4750 -7.2675206530893742e-07
Rt16476 T3013 T5164 1962492.946410429
Gcorr5705 T3013 T5425 T3013 T5425 -1.5856660899061525e-07
Rt16477 T3013 T5673 10281123.255692627
Rt16478 T3013 T5724 403677.64764459024
Rt16479 T3013 T6069 1601013.4123480311
Rt16480 T3014 T3067 3586076.3907986204
Rt16481 T3014 T3069 820808.55687141814
Rt16482 T3014 T3088 2917140.6067210268
Rt16483 T3014 T3408 1893983.54426088
Rt16484 T3014 T4623 4343766.4489513095
Rt16485 T3014 T4749 3204645.7528627799
Rt16486 T3014 T4750 358336.97088618419
Gcorr5706 T3014 T4986 T3014 T4986 -3.7702278260154488e-08
Gcorr5707 T3014 T4988 T3014 T4988 -5.6107353222667145e-07
Gcorr5708 T3014 T5724 T3014 T5724 -4.7445738809226076e-07
Rt16487 T3015 T3016 1981468.685138182
Rt16488 T3015 T3055 8312267.1462673424
Rt16489 T3015 T3200 2548770.8809316154
Rt16490 T3015 T3327 3021879.3918290609
Rt16491 T3015 T4194 679846.41825261468
Rt16492 T3015 T5154 2774094.1061456939
Gcorr5709 T3015 T5589 T3015 T5589 -3.6036486276218862e-08
Rt16493 T3015 T5618 15478578.956521155
Rt16494 T3015 T5988 1996900.7947955446
Rt16495 T3016 T3055 2299127.3248599265
Rt16496 T3016 T3059 2087181.4925662605
Rt16497 T3016 T3111 11036029.372868344
Rt16498 T3016 T3939 1592310.9059272984
Rt16499 T3016 T5035 3611517.3439637995
Rt16500 T3016 T5153 2156915.5891691679
Rt16501 T3016 T5154 1698868.953414412
Gcorr5710 T3016 T5988 T3016 T5988 -1.5951813515171572e-07
Rt16502 T3017 T3018 7643163.8103306238
Rt16503 T3017 T3056 8419340.3729537521
Rt16504 T3017 T3201 642493.74230161286
Rt16505 T3017 T3326 1667276.8015797392
Gcorr5711 T3017 T4991 T3017 T4991 -7.6964817588743955e-07
Rt16506 T3017 T5124 2904456.2937026587
Gcorr5712 T3017 T5623 T3017 T5623 -4.3982737264704358e-07
Rt16507 T3017 T5695 1911280.7804637726
Rt16508 T3017 T5833 724136.34461125673
Rt16509 T3018 T3056 2294709.5488340156
Rt16510 T3018 T3065 5279937.6424822556
Rt16511 T3018 T3101 2514803.0237423563
Rt16512 T3018 T3938 6124454.2518128613
Rt16513 T3018 T4238 1520713.2029206802
Gcorr5713 T3018 T5623 T3018 T5623 -4.4989949767614924e-07
Rt16514 T3018 T5833 1925515.9617782477
Rt16515 T3018 T5900 2248559.2745383158
Rt16516 T3019 T3582 2204433.3655936532
Rt16517 T3019 T3836 2042957.4862150738
Rt16518 T3019 T3869 2333649.6081865444
Rt16519 T3019 T3887 1451419.5057214713
Rt16520 T3019 T4555 6504380.5612534368
Gcorr5714 T3019 T5230 T3019 T5230 -1.0876958505990641e-07
Rt16521 T3019 T5709 4292318.31562573
Rt16522 T3019 T5784 11344807.301652545
Rt16523 T3020 T3027 2520638.7610750422
Rt16524 T3020 T3054 5189795.3290758058
Rt16525 T3020 T3169 2000281.9305151207
Rt16526 T3020 T4004 5658954.5898313988
Rt16527 T3020 T5289 3391005.9318322698
Rt16528 T3020 T5640 2003220.4163557747
Rt16529 T3020 T5882 4352380.0336106727
Rt16530 T3021 T3022 1112931.8044884475
Gcorr5715 T3021 T3023 T3021 T3023 -2.3933307426535112e-07
Rt16531 T3021 T3078 819666.74299915542
Rt16532 T3021 T3098 663315.17252461729
Rt16533 T3021 T4082 1028920.6991638639
Gcorr5716 T3021 T4874 T3021 T4874 -6.024310906644486e-07
Gcorr5717 T3021 T4875 T3021 T4875 -6.7050020759877329e-07
Rt16534 T3021 T4876 357309.64980680298
Gcorr5718 T3021 T4983 T3021 T4983 -1.3123699052132571e-07
Rt16535 T3021 T4984 2017744.9083868286
Gcorr5719 T3021 T5026 T3021 T5026 -2.0413134854839635e-07
Rt16536 T3021 T5940 2882564.1521140118
Rt16537 T3022 T3078 8679148.4513774812
Rt16538 T3022 T3079 2554323.4159076014
Rt16539 T3022 T3184 1071148.0714950601
Rt16540 T3022 T3514 377494.21012900904
Rt16541 T3022 T4874 2595598.1257497678
Gcorr5720 T3022 T4876 T3022 T4876 -4.6421032760176833e-07
Rt16542 T3022 T5026 361391.48168919748
Rt16543 T3022 T5244 9285618.694945585
Gcorr5721 T3022 T5582 T3022 T5582 -1.3254481730968084e-06
Rt16544 T3022 T5885 1934081.0585660178
Rt16545 T3023 T3024 13135295.758434311
Rt16546 T3023 T3036 2203624.9833631217
Rt16547 T3023 T3131 2302664.4437950328
Rt16548 T3023 T4082 471597.01403377898
Rt16549 T3023 T4983 46692837.018595718
Rt16550 T3023 T4984 3011574.8861358599
Rt16551 T3023 T5044 862333.66690876812
Rt16552 T3023 T5233 8672877.2903037611
Gcorr5722 T3023 T5698 T3023 T5698 -1.7103880034545433e-07
Rt16553 T3024 T3036 2728528.5061403317
Rt16554 T3024 T3209 2104897.6179656782
Rt16555 T3024 T3509 9742980.5429562572
Rt16556 T3024 T3840 8736565.9657303225
Rt16557 T3024 T5044 2936754.1585526899
Rt16558 T3024 T5238 1614127.8935758928
Rt16559 T3024 T5580 2558479.467194139
Rt16560 T3024 T5979 2097440.4063153625
Rt16561 T3025 T3026 13855862.741282694
Rt16562 T3025 T3099 1963696.474344979
Rt16563 T3025 T3173 2042011.7663123235
Rt16564 T3025 T3754 15775337.960812189
Rt16565 T3025 T4075 817673.43977259402
Rt16566 T3025 T4304 1400886.5442185984
Gcorr5723 T3025 T4307 T3025 T4307 -1.5714849470274593e-07
Rt16567 T3025 T4308 2128935.8065770618
Rt16568 T3025 T4735 3068577.1390586924
Rt16569 T3026 T3099 2162253.7717446093
Rt16570 T3026 T3100 1292177.2204052883
Rt16571 T3026 T3157 38664971.493514076
Rt16572 T3026 T3804 6602657.2441375554
Rt16573 T3026 T4301 1056267.4864224489
Gcorr5724 T3026 T4303 T3026 T4303 -3.2916306606764018e-08
Rt16574 T3026 T4304 1865988.4347424288
Rt16575 T3027 T3703 701438.48487289925
Gcorr5725 T3027 T3915 T3027 T3915 -9.0024627173252752e-08
Rt16576 T3027 T4004 1705497.3852742417
Rt16577 T3027 T4044 1096161.8414529562
Rt16578 T3027 T5289 2729998.9489761237
Gcorr5726 T3027 T5319 T3027 T5319 -4.0506825003555788e-07
Rt16579 T3027 T5729 1119843.4730133126
Rt16580 T3027 T5882 2570836.2977434518
Gcorr5727 T3027 T6086 T3027 T6086 -1.5936647741507966e-07
Rt16581 T3028 T3029 3679766.8498765244
Rt16582 T3028 T3179 3320986.309605069
Rt16583 T3028 T3183 1974396.0166350428
Rt16584 T3028 T3933 4082385.1740277591
Rt16585 T3028 T4839 1236032.5854511908
Rt16586 T3028 T5812 26774657.545226257
Gcorr5728 T3028 T5914 T3028 T5914 -4.8705148642943983e-07
Rt16587 T3028 T6084 2131293.9883445902
Rt16588 T3029 T3179 2042481.7150332513
Rt16589 T3029 T3180 2230573.9939804715
Rt16590 T3029 T3181 5658181.0731437299
Rt16591 T3029 T4102 827109.83403523557
Gcorr5729 T3029 T4717 T3029 T4717 -1.4216568831910032e-07
Rt16592 T3029 T4818 1332835.1896878802
Rt16593 T3029 T4839 4084035.2956797793
Gcorr5730 T3029 T6082 T3029 T6082 -2.0171324124943113e-08
Gcorr5731 T3030 T3031 T3030 T3031 -4.9911873510857991e-08
Rt16594 T3030 T3032 2511066.7968027424
Rt16595 T3030 T3132 1957066.0523561218
Rt16596 T3030 T3135 691208.69705136062
Rt16597 T3030 T4115 908499.70373363513
Gcorr5732 T3030 T4627 T3030 T4627 -2.4974374243640528e-07
Rt16598 T3030 T5316 1729859.6947681988
Gcorr5733 T3030 T5428 T3030 T5428 -2.9165563216728767e-07
Gcorr5734 T3030 T5732 T3030 T5732 -6.4210381808046373e-07
Rt16599 T3030 T5775 453812.68989983998
Gcorr5735 T3030 T5776 T3030 T5776 -1.7668980464305786e-07
Rt16600 T3030 T5851 2253275.6693393304
Rt16601 T3031 T3063 2458980.6407435476
Rt16602 T3031 T3064 7945398.8365103174
Rt16603 T3031 T3168 2809386.8004371887
Gcorr5736 T3031 T3749 T3031 T3749 -4.0837916949681956e-08
Rt16604 T3031 T4115 829679.28416199866
Gcorr5737 T3031 T5114 T3031 T5114 -3.4762239604531462e-08
Rt16605 T3031 T5258 3354049.7021808703
Rt16606 T3031 T5428 969680.96676919714
Rt16607 T3031 T5976 5528759.6137444414
Rt16608 T3032 T3132 11440717.370150616
Rt16609 T3032 T3133 2435144.5852024644
Rt16610 T3032 T3134 2587029.9402911463
Rt16611 T3032 T3833 541366.29671215627
Rt16612 T3032 T4627 2026090.1783188167
Gcorr5738 T3032 T4998 T3032 T4998 -4.6711106400616878e-07
Rt16613 T3032 T5316 1489875.772858337
Rt16614 T3032 T5774 1192924.2830709575
Gcorr5739 T3032 T5836 T3032 T5836 -1.0708318903043486e-07
Rt16615 T3033 T3954 918272.26913948299
Rt16616 T3033 T4040 1409453.3246244995
Rt16617 T3033 T4138 4547268.9093232611
Rt16618 T3033 T4164 1072158.5231338493
Gcorr5740 T3033 T4908 T3033 T4908 -1.9634455248571248e-07
Rt16619 T3033 T4910 15973074.451203225
Rt16620 T3033 T4911 2003495.4595668977
Rt16621 T3033 T4913 30644244.121630017
Rt16622 T3034 T3176 3822423.8043909008
Gcorr5741 T3034 T3224 T3034 T3224 -7.9368595141070559e-08
Gcorr5742 T3034 T3333 T3034 T3333 -1.8056824849353357e-07
Rt16623 T3034 T3469 1820602.1068641415
Rt16624 T3034 T4094 870570.42711923213
Rt16625 T3034 T4617 3706366.6125884457
Rt16626 T3034 T4618 13907516.515707355
Rt16627 T3034 T4624 680762.34334512777
Rt16628 T3034 T5164 3463649.9028431904
Rt16629 T3034 T6069 18213600.382576488
Rt16630 T3035 T3084 2063562.213394854
Rt16631 T3035 T3208 3563945.2073153732
Gcorr5743 T3035 T3430 T3035 T3430 -4.4464943457778596e-07
Rt16632 T3035 T3951 1106809.6796276176
Rt16633 T3035 T5033 549566.81477642991
Rt16634 T3035 T5352 2576978.254910138
Gcorr5744 T3035 T5803 T3035 T5803 -1.2908141840579543e-07
Rt16635 T3035 T5804 713684.90042615344
Gcorr5745 T3035 T5847 T3035 T5847 -4.7467873071894538e-07
Gcorr5746 T3036 T3131 T3036 T3131 -9.3541130038246997e-09
Rt16636 T3036 T3209 9949927.9222039878
Rt16637 T3036 T3210 2197596.8625263623
Rt16638 T3036 T3284 43782869.68650344
Rt16639 T3036 T4035 1192309.0083809562
Gcorr5747 T3036 T5044 T3036 T5044 -3.2337013679676298e-08
Rt16640 T3036 T5580 2241236.4025517157
Rt16641 T3036 T5698 1403285.5535624428
Rt16642 T3036 T5699 4968518.326298763
Rt16643 T3037 T3138 2055868.9103037838
Rt16644 T3037 T3159 1793484.4946430293
Gcorr5748 T3037 T3334 T3037 T3334 -1.7316506166462277e-08
Rt16645 T3037 T3968 2495149.0826420393
Rt16646 T3037 T5196 1616726.6170467928
Rt16647 T3037 T5810 12392339.738021523
Gcorr5749 T3037 T5860 T3037 T5860 -4.9619886719728918e-08
Rt16648 T3037 T5975 944411.05460856098
Gcorr5750 T3038 T3731 T3038 T3731 -7.9750423491492253e-08
Rt16649 T3038 T3829 4977427.4758052519
Rt16650 T3038 T3960 1096354.6114648157
Rt16651 T3038 T4032 1080446.8433085172
Gcorr5751 T3038 T4146 T3038 T4146 -2.3493304820615505e-07
Gcorr5752 T3038 T4295 T3038 T4295 -3.7038393331990686e-08
Rt16652 T3038 T5211 5343543.9286317583
Rt16653 T3038 T5627 756700.4351049976
Rt16654 T3038 T5845 1353846.7021758961
Rt16655 T3039 T3040 9615727.5243031085
Gcorr5753 T3039 T3572 T3039 T3572 -3.5417023753707438e-07
Rt16656 T3039 T3589 2437255.1182678989
Rt16657 T3039 T3894 1307527.8687963879
Rt16658 T3039 T5025 1232852.7904253288
Rt16659 T3039 T5716 2124725.8580381675
Rt16660 T3039 T5796 1767431.5960995469
Rt16661 T3040 T3051 13405590.441640379
Rt16662 T3040 T3068 2525467.1569999782
Rt16663 T3040 T3074 1718142.7128287591
Rt16664 T3040 T3589 2244258.3271873994
Rt16665 T3040 T4769 3481040.1397905177
Gcorr5754 T3040 T4932 T3040 T4932 -8.4743545770192962e-08
Rt16666 T3040 T5716 901947.52178580232
Rt16667 T3040 T5837 2826150.7948500318
Rt16668 T3041 T3083 7334230.06969498
Rt16669 T3041 T3384 708884.83691386343
Gcorr5755 T3041 T3520 T3041 T3520 -1.047857974414367e-07
Rt16670 T3041 T4001 1370350.3807690188
Rt16671 T3041 T4918 3191484.6261853795
Rt16672 T3041 T4920 860137.47192225489
Rt16673 T3041 T5256 1375711.4852555778
Gcorr5756 T3041 T5917 T3041 T5917 -5.4219207579544644e-07
Rt16674 T3042 T3043 1847037.0524863456
Rt16675 T3042 T3445 1943442.8966902967
Rt16676 T3042 T3880 2223997.7711656941
Rt16677 T3042 T4415 3010421.2897746679
Gcorr5757 T3042 T5528 T3042 T5528 -5.2976696117881352e-07
Rt16678 T3042 T5649 1323127.2849889298
Gcorr5758 T3042 T5750 T3042 T5750 -1.3211608398446698e-07
Rt16679 T3043 T3075 3730250.1447743694
Rt16680 T3043 T3076 2141146.369420819
Rt16681 T3043 T3445 4404731.3777238727
Rt16682 T3043 T3955 1562617.8669859946
Gcorr5759 T3043 T4415 T3043 T4415 -1.8488187368612029e-08
Rt16683 T3043 T5125 3522450.9324195329
Rt16684 T3043 T5750 3057728.2116450705
Gcorr5760 T3043 T6028 T3043 T6028 -1.1685034923426667e-07
Rt16685 T3044 T3045 3271620.9271335574
Rt16686 T3044 T3164 9433745.9015542809
Rt16687 T3044 T3165 1203958.9899177928
Rt16688 T3044 T4090 597298.52522471349
Rt16689 T3044 T5262 870532.57587572816
Gcorr5761 T3044 T5468 T3044 T5468 -4.3780148610097015e-07
Rt16690 T3044 T5931 1404757.5888915176
Gcorr5762 T3044 T5932 T3044 T5932 -5.2706761607111265e-08
Rt16691 T3044 T5978 6846843.5756742749
Gcorr5763 T3044 T6058 T3044 T6058 -1.1584415577767518e-07
Rt16692 T3045 T3046 12790951.804877803
Rt16693 T3045 T3047 17446113.379440729
Rt16694 T3045 T3164 3114072.1726093283
Rt16695 T3045 T3207 618606.11410447559
Rt16696 T3045 T3692 7088338.9891797034
Rt16697 T3045 T4995 739183.4045924932
Gcorr5764 T3045 T5133 T3045 T5133 -6.977186241011618e-07
Rt16698 T3045 T5207 1732853.2841947952
Gcorr5765 T3045 T5931 T3045 T5931 -1.0282428181322438e-07
Rt16699 T3045 T5978 1967264.9150553758
Rt16700 T3046 T3047 1754303.0615444081
Rt16701 T3046 T3048 11529961.373130139
Rt16702 T3046 T3166 1948910.2095388218
Rt16703 T3046 T3958 2823219.7924052724
Rt16704 T3046 T4994 967917.12240896479
Rt16705 T3046 T4995 2181681.0167121412
Rt16706 T3046 T5308 2035202.5391084852
Gcorr5766 T3046 T5893 T3046 T5893 -2.0531732859174766e-07
Rt16707 T3047 T3048 1887047.6496156983
Rt16708 T3047 T3049 18272319.016414907
Rt16709 T3047 T3086 570530.40607904282
Rt16710 T3047 T3207 1268640.544276454
Rt16711 T3047 T4837 647053.29703773884
Gcorr5767 T3047 T4994 T3047 T4994 -1.8582768171625063e-07
Rt16712 T3047 T4995 1747586.1574268586
Rt16713 T3047 T5133 4032547.6717172945
Gcorr5768 T3047 T5224 T3047 T5224 -7.0822488904046364e-07
Gcorr5769 T3048 T3049 T3048 T3049 -8.998152974291214e-08
Rt16714 T3048 T3166 1760860.5571244343
Rt16715 T3048 T3485 2857572.3619953259
Rt16716 T3048 T4057 997990.1926591727
Rt16717 T3048 T4833 1459837.3905119398
Rt16718 T3048 T4837 2850381.2493508188
Rt16719 T3048 T4994 1284817.3320386915
Gcorr5770 T3048 T5067 T3048 T5067 -1.6944509483955065e-07
Rt16720 T3049 T3086 1883624.1325721373
Rt16721 T3049 T3087 2370155.5788438721
Gcorr5771 T3049 T3624 T3049 T3624 -8.5236701553892987e-08
Rt16722 T3049 T3793 3113731.3735072161
Rt16723 T3049 T4057 327689.21807125024
Rt16724 T3049 T4745 1329259.7249162269
Gcorr5772 T3049 T4833 T3049 T4833 -8.4920628561562692e-07
Rt16725 T3049 T4837 728477.0662418626
Gcorr5773 T3049 T5224 T3049 T5224 -9.3534855985971418e-08
Rt16726 T3049 T5984 3908340.8172278078
Rt16727 T3050 T3229 2927646.9048500261
Rt16728 T3050 T3230 2912394.5243241098
Rt16729 T3050 T3324 2808410.9081942257
Rt16730 T3050 T3736 5889706.8742709216
Rt16731 T3050 T4090 462259.21056399908
Rt16732 T3050 T5061 1084443.6246903532
Rt16733 T3050 T5323 7076043.8392968876
Rt16734 T3050 T5324 2407574.9176674457
Gcorr5774 T3050 T5932 T3050 T5932 -3.8257218465571631e-07
Gcorr5775 T3050 T6048 T3050 T6048 -4.7174607542379576e-08
Rt16735 T3051 T3068 2492124.9004663439
Gcorr5776 T3051 T3141 T3051 T3141 -6.7948286825113322e-08
Rt16736 T3051 T3203 1490287.2835604625
Rt16737 T3051 T4143 728429.1012932274
Rt16738 T3051 T5165 11298906.540950652
Rt16739 T3051 T5225 2345138.7520462978
Gcorr5777 T3051 T5769 T3051 T5769 -1.4016388500946953e-07
Rt16740 T3051 T5837 1350639.2227573213
Rt16741 T3052 T3053 3102200.6982149775
Rt16742 T3052 T3186 2396742.7555134227
Rt16743 T3052 T3189 58308364.642711073
Rt16744 T3052 T4179 1035998.3367666405
Rt16745 T3052 T4183 5136010.1393414084
Rt16746 T3052 T4184 1155390.6778856895
Rt16747 T3052 T4317 2932027.7852783119
Rt16748 T3052 T5257 8292520.6126783816
Rt16749 T3052 T5326 1811167.9728961028
Gcorr5778 T3052 T5746 T3052 T5746 -1.575036305530184e-08
Rt16750 T3053 T3186 2596600.1751906169
Rt16751 T3053 T3187 1939314.1647412824
Rt16752 T3053 T3188 3868395.0959232016
Rt16753 T3053 T3930 1778151.856178334
Rt16754 T3053 T4689 14336676.535988476
Rt16755 T3053 T5326 10910253.384969428
Rt16756 T3053 T5731 2925763.6085441224
Rt16757 T3053 T5746 21257658.480333798
Rt16758 T3053 T5832 26150995.733856581
Rt16759 T3053 T6035 1853085.476725515
Rt16760 T3054 T3169 2062217.5281326773
Rt16761 T3054 T3170 21198004.270159803
Rt16762 T3054 T3689 2092390.2362916199
Rt16763 T3054 T4026 2460720.2746080691
Rt16764 T3054 T5038 2944888.4961534091
Rt16765 T3054 T5640 2469038.2484274171
Rt16766 T3054 T5641 2372614.9298668955
Rt16767 T3055 T3059 2268494.6257037306
Rt16768 T3055 T3060 10282894.122479305
Rt16769 T3055 T3200 2685109.6978264889
Rt16770 T3055 T3356 1840632.8574528145
Rt16771 T3055 T4133 26885019.10291288
Rt16772 T3055 T4751 5115025.9825504282
Rt16773 T3055 T5034 5474618.441545439
Rt16774 T3055 T5035 2406003.2300060466
Rt16775 T3055 T5988 3713415.7682456216
Rt16776 T3056 T3065 1920768.8746964536
Rt16777 T3056 T3066 9029152.8758544493
Rt16778 T3056 T3201 2086767.5234328327
Rt16779 T3056 T3357 417207.89730157424
Rt16780 T3056 T4161 8261082.6958332825
Gcorr5779 T3056 T4942 T3056 T4942 -1.0512812808577672e-06
Rt16781 T3056 T4991 7837091.0568517856
Rt16782 T3056 T5131 600758.73977714463
Rt16783 T3056 T5833 2369907.2863032701
Gcorr5780 T3056 T5900 T3056 T5900 -1.0226483141562961e-07
Gcorr5781 T3057 T3552 T3057 T3552 -3.6903448226312535e-07
Rt16784 T3057 T3570 3611872.6637544692
Rt16785 T3057 T3571 5622843.6653738227
Rt16786 T3057 T3572 2500599.0263321348
Rt16787 T3057 T4286 292088.7640381793
Gcorr5782 T3057 T4288 T3057 T4288 -1.5083857248858361e-08
Rt16788 T3057 T4299 2230089.3173397426
Rt16789 T3057 T5358 1169397.7572689704
Gcorr5783 T3058 T3639 T3058 T3639 -7.4268083917330657e-08
Rt16790 T3058 T3729 1253738.6388022702
Rt16791 T3058 T3994 1180924.4811075395
Rt16792 T3058 T4159 907075.96714193036
Gcorr5784 T3058 T4701 T3058 T4701 -9.6353030828494128e-08
Rt16793 T3058 T4715 3606137.5205053417
Rt16794 T3058 T4716 2665337.2808779655
Gcorr5785 T3058 T4723 T3058 T4723 -1.1763625591330435e-07
Rt16795 T3059 T3060 1441836.4345062303
Rt16796 T3059 T3089 1366301.6577293146
Rt16797 T3059 T3111 1863632.6906460465
Gcorr5786 T3059 T3822 T3059 T3822 -1.3218388875618978e-07
Gcorr5787 T3059 T4751 T3059 T4751 -2.0822949184793833e-07
Rt16798 T3059 T5035 5521773.9603713993
Rt16799 T3059 T5036 1046793.4106355546
Rt16800 T3059 T5153 4272043.5736042131
Rt16801 T3059 T5155 6040203.264711949
Rt16802 T3060 T3089 2494308.3862609291
Rt16803 T3060 T3090 2764014.1913217697
Rt16804 T3060 T3142 10072743.468049265
Rt16805 T3060 T4133 897442.44238388678
Rt16806 T3060 T4661 8198564.7415544474
Rt16807 T3060 T4751 1828863.6641048808
Gcorr5788 T3060 T5036 T3060 T5036 -1.5651733574702532e-07
Rt16808 T3060 T5944 2608845.6347138886
Rt16809 T3061 T3062 2750074.4217457254
Rt16810 T3061 T3226 886056.54651167348
Rt16811 T3061 T3231 1368586.4147144938
Rt16812 T3061 T4048 416053.475177655
Gcorr5789 T3061 T4477 T3061 T4477 -4.9393836568787745e-07
Rt16813 T3061 T4479 599723.86759688298
Gcorr5790 T3061 T4480 T3061 T4480 -4.811757789370273e-07
Gcorr5791 T3061 T4481 T3061 T4481 -1.2969338245065041e-07
Rt16814 T3061 T4824 7679810.9335906953
Rt16815 T3061 T5873 2119316.6098509072
Rt16816 T3062 T3226 6727692.9917032672
Rt16817 T3062 T3227 1381466.4037967001
Rt16818 T3062 T3228 1813179.8929517157
Rt16819 T3062 T3581 1610690.3143848206
Rt16820 T3062 T4481 1684680.5711152095
Rt16821 T3062 T4824 3139344.8840339663
Rt16822 T3062 T4825 3065453.0241257413
Gcorr5792 T3062 T5126 T3062 T5126 -1.5589854314409406e-07
Rt16823 T3063 T3064 13882766.128430175
Rt16824 T3063 T3512 3724083.5230176151
Rt16825 T3063 T4058 952506.5714618268
Rt16826 T3063 T4076 1304866.1831443093
Rt16827 T3063 T4987 3253337.0519337631
Gcorr5793 T3063 T5113 T3063 T5113 -4.5770618212873644e-08
Rt16828 T3063 T5114 862223.81680380902
Rt16829 T3063 T5258 8369177.8967026556
Rt16830 T3064 T3168 2000366.9931230443
Rt16831 T3064 T3287 3960881.8764943392
Gcorr5794 T3064 T3457 T3064 T3457 -9.6935669071081555e-08
Rt16832 T3064 T4058 952450.66376897646
Rt16833 T3064 T4168 811044.0275081112
Rt16834 T3064 T5258 909424.34761526203
Rt16835 T3064 T5259 13002325.711297754
Rt16836 T3064 T5612 24303379.091127641
Gcorr5795 T3064 T5842 T3064 T5842 -9.5717202583841283e-08
Rt16837 T3065 T3066 2239510.1796511603
Rt16838 T3065 T3101 2181093.2344742175
Rt16839 T3065 T3102 5229080.3861017926
Rt16840 T3065 T3962 1539063.9233278206
Gcorr5796 T3065 T5131 T3065 T5131 -9.98295659692902e-08
Rt16841 T3065 T5222 1278854.5337566016
Gcorr5797 T3065 T5815 T3065 T5815 -5.0991670976686849e-08
Rt16842 T3065 T5900 1925891.0757874395
Rt16843 T3066 T3102 2018231.1571544791
Rt16844 T3066 T3103 2444878.9068223392
Rt16845 T3066 T3163 13898450.961288225
Rt16846 T3066 T4161 657148.75122231885
Rt16847 T3066 T5131 10221053.844004475
Rt16848 T3066 T5221 1896580.0395752927
Rt16849 T3066 T5222 7641920.2609856576
Rt16850 T3066 T5402 130024235.8467105
Rt16851 T3066 T6079 6664239.2238690946
Rt16852 T3067 T3088 2539536.1775356671
Rt16853 T3067 T3117 2655684.830317324
Rt16854 T3067 T3190 2219806.2869887324
Rt16855 T3067 T3847 1934420.0513257068
Rt16856 T3067 T4621 3601582.5849021915
Gcorr5798 T3067 T4622 T3067 T4622 -1.7085211524971317e-07
Rt16857 T3067 T4623 1136814.8969842272
Rt16858 T3067 T5425 1740966.9223327935
Gcorr5799 T3067 T5724 T3067 T5724 -9.5257975862399402e-08
Rt16859 T3068 T3074 10925743.84414573
Rt16860 T3068 T3123 2593111.807873819
Rt16861 T3068 T3202 1974706.1079068952
Rt16862 T3068 T3624 1582680.8189419461
Gcorr5800 T3068 T4143 T3068 T4143 -6.8005540967165188e-08
Gcorr5801 T3068 T4744 T3068 T4744 -6.6288861113338426e-08
Rt16863 T3068 T4769 958431.50263993011
Rt16864 T3068 T5769 7154916.0477879662
Rt16865 T3068 T5837 58503629.222666986
Rt16866 T3068 T5911 3416469.5111197834
Gcorr5802 T3069 T3408 T3069 T3408 -1.0270483023830185e-07
Rt16867 T3069 T3525 5062197.3109867703
Rt16868 T3069 T4012 1794978.4296393825
Rt16869 T3069 T4076 998048.51630016614
Gcorr5803 T3069 T4750 T3069 T4750 -5.6970674393238287e-07
Rt16870 T3069 T4986 653974.49117959326
Rt16871 T3069 T4988 809284.42600867583
Gcorr5804 T3069 T5113 T3069 T5113 -2.8129984919668533e-07
Rt16872 T3069 T5765 1774816.0058607904
Rt16873 T3070 T3727 1039436.8580020767
Rt16874 T3070 T3897 509163.22164955811
Rt16875 T3070 T4112 279107.36586835666
Rt16876 T3070 T4235 197306.05460879358
Gcorr5805 T3070 T5608 T3070 T5608 -6.3364400035994814e-07
Gcorr5806 T3070 T5843 T3070 T5843 -5.3019060942559493e-07
Gcorr5807 T3070 T5887 T3070 T5887 -5.1435056843611476e-07
Rt16877 T3071 T3072 17565042.326285362
Rt16878 T3071 T3211 8792309.1948654279
Rt16879 T3071 T3212 2221093.259615609
Rt16880 T3071 T3213 3886741.3426743848
Rt16881 T3071 T4188 3005428.7960088146
Rt16882 T3071 T4473 2620598.0276937876
Rt16883 T3071 T4475 2400780.4123647162
Gcorr5808 T3071 T4823 T3071 T4823 -7.6867634505546478e-07
Rt16884 T3071 T5728 9495056.0554789454
Rt16885 T3071 T5934 854595.02331343107
Rt16886 T3072 T3073 7736480.5558183026
Gcorr5809 T3072 T3843 T3072 T3843 -2.4390102894635781e-07
Rt16887 T3072 T4047 693070.77484611201
Rt16888 T3072 T4188 1045689.4520432982
Rt16889 T3072 T4306 22265608.202801611
Rt16890 T3072 T5306 2111170.9132118397
Rt16891 T3072 T5728 1954776.6552968011
Rt16892 T3073 T3804 4018133.4235560312
Rt16893 T3073 T3843 824668.7133562665
Rt16894 T3073 T4015 1628681.3190119616
Gcorr5810 T3073 T4074 T3073 T4074 -1.1039503537608345e-07
Rt16895 T3073 T4300 1551519.1500632656
Gcorr5811 T3073 T4302 T3073 T4302 -1.520526812559079e-07
Rt16896 T3073 T5306 935459.01632885903
Rt16897 T3073 T5987 17573055.427886806
Gcorr5812 T3074 T3485 T3074 T3485 -5.1960853065132341e-08
Rt16898 T3074 T3589 6136513.1309490604
Rt16899 T3074 T3624 1715458.7501413461
Gcorr5813 T3074 T3787 T3074 T3787 -1.3746311094888709e-07
Rt16900 T3074 T4057 10495827.748750299
Rt16901 T3074 T4768 1967542.6135409018
Rt16902 T3074 T4769 3031107.7237263685
Rt16903 T3074 T4932 754843.37520453008
Rt16904 T3074 T5903 2934387.2063899548
Rt16905 T3075 T3076 1571865.2654447951
Rt16906 T3075 T3077 1932570.4242306985
Rt16907 T3075 T3750 3242265.6168196886
Rt16908 T3075 T3868 4309333.2005384965
Rt16909 T3075 T4056 5188378.4337806944
Rt16910 T3075 T4403 52758982.386366487
Rt16911 T3075 T5125 2897118.2474972559
Rt16912 T3075 T5653 3146140.6343958406
Gcorr5814 T3075 T5850 T3075 T5850 -1.4098766060746845e-07
Rt16913 T3076 T3077 3630969.2789103589
Rt16914 T3076 T3333 1782480.6990844787
Rt16915 T3076 T3738 1538291.9372734486
Rt16916 T3076 T3955 2480625.3884566883
Gcorr5815 T3076 T5125 T3076 T5125 -4.373094195405977e-08
Gcorr5816 T3076 T5710 T3076 T5710 -1.976731276263268e-07
Rt16917 T3076 T5850 2699410.8280125386
Rt16918 T3076 T6028 2509501.8397275861
Rt16919 T3077 T3333 1743014.5371522864
Rt16920 T3077 T3868 1279200.8686105206
Rt16921 T3077 T4174 1011255.9557647445
Gcorr5817 T3077 T4398 T3077 T4398 -1.2176179165825803e-07
Rt16922 T3077 T4616 4364538.7045462793
Rt16923 T3077 T5653 7355936.9606135525
Rt16924 T3077 T5850 4904387.4199735504
Rt16925 T3078 T3079 2357918.734039126
Rt16926 T3078 T3098 7761183.6793648442
Rt16927 T3078 T3149 2254434.0127406465
Rt16928 T3078 T3235 3843091.7870041756
Rt16929 T3078 T4162 2307256.3069448005
Gcorr5818 T3078 T4809 T3078 T4809 -1.6709775918486992e-07
Rt16930 T3078 T4873 2980309.8825699901
Rt16931 T3078 T4874 768594.24822289881
Rt16932 T3078 T4875 2520564.9826996145
Gcorr5819 T3078 T4876 T3078 T4876 -5.8363464202506804e-07
Rt16933 T3079 T3184 2478856.3467138698
Gcorr5820 T3079 T3185 T3079 T3185 -1.27276370782319e-08
Gcorr5821 T3079 T3236 T3079 T3236 -7.4838220559704498e-08
Rt16934 T3079 T4154 1582897.9963801308
Rt16935 T3079 T4162 842153.61888839537
Gcorr5822 T3079 T4732 T3079 T4732 -6.8025778531739734e-08
Rt16936 T3079 T4808 2338568.5051267869
Rt16937 T3079 T4809 1803139.0841938064
Gcorr5823 T3079 T4874 T3079 T4874 -1.5390036525485617e-07
Rt16938 T3079 T5885 3227339.5583017757
Rt16939 T3080 T3081 1606670.8336863765
Rt16940 T3080 T3431 4352723.0699804286
Rt16941 T3080 T3549 1927588.3183413828
Rt16942 T3080 T4120 2937389.7486078832
Rt16943 T3080 T5191 6433850.990161581
Rt16944 T3080 T5192 5647442.4723357577
Rt16945 T3080 T5194 1818537.2650644677
Gcorr5824 T3080 T6056 T3080 T6056 -1.6966654667913712e-07
Rt16946 T3081 T3082 1950067.4130604598
Rt16947 T3081 T3171 2009001.571125472
Rt16948 T3081 T3172 22338755.979616653
Rt16949 T3081 T4120 1591077.2862511328
Gcorr5825 T3081 T5194 T3081 T5194 -1.4324929702077526e-07
Rt16950 T3081 T5340 2774218.9387053247
Rt16951 T3081 T5848 54109003.043300964
Rt16952 T3081 T6056 1189620.0054193742
Rt16953 T3082 T3171 2307897.0942902681
Rt16954 T3082 T3371 8409394.1704898141
Rt16955 T3082 T3824 1671559.1318574233
Rt16956 T3082 T4027 3173689.8205574388
Rt16957 T3082 T4077 2934327.0762446914
Rt16958 T3082 T5193 1238473.8134278171
Rt16959 T3082 T5643 2382086.4506110498
Gcorr5826 T3082 T5748 T3082 T5748 -1.4491710345915756e-07
Rt16960 T3082 T5848 3430543.8783901953
Gcorr5827 T3082 T6056 T3082 T6056 -1.1161607152332835e-07
Gcorr5828 T3083 T3371 T3083 T3371 -2.2565252673418316e-07
Rt16961 T3083 T3384 1182844.0048485533
Rt16962 T3083 T3610 2709606.3504562601
Rt16963 T3083 T3824 563078.7035246311
Rt16964 T3083 T5256 644052.7142764302
Gcorr5829 T3083 T5748 T3083 T5748 -5.2117006174794323e-07
Gcorr5830 T3083 T5917 T3083 T5917 -1.7193088498067306e-08
Rt16965 T3083 T6033 978414.75177237904
Gcorr5831 T3084 T3160 T3084 T3160 -2.3493208453065004e-07
Gcorr5832 T3084 T3208 T3084 T3208 -2.6143105563129519e-07
Rt16966 T3084 T3809 1792731.1138516404
Rt16967 T3084 T3837 33313660.745393824
Rt16968 T3084 T5032 604747.06610552187
Rt16969 T3084 T5033 2726763.2573938137
Gcorr5833 T3084 T5549 T3084 T5549 -1.304219514232143e-07
Rt16970 T3084 T5803 545925.29723790032
Gcorr5834 T3085 T3703 T3085 T3703 -1.3710542815859204e-07
Rt16971 T3085 T3803 24005307.427619528
Rt16972 T3085 T3915 2721244.0698282467
Rt16973 T3085 T3935 1104116.8331869727
Rt16974 T3085 T4013 1080832.2115018344
Rt16975 T3085 T5285 3312800.087100998
Rt16976 T3085 T5290 3176941.875829183
Rt16977 T3085 T5318 18042394.234727632
Rt16978 T3086 T3087 19930644.688308224
Rt16979 T3086 T3207 1708077.3493576497
Rt16980 T3086 T3422 5078607.0599670671
Rt16981 T3086 T3423 2053483.9688315333
Rt16982 T3086 T4147 1203982.866228543
Gcorr5835 T3086 T4837 T3086 T4837 -6.9338671034320988e-07
Gcorr5836 T3086 T5133 T3086 T5133 -1.5860591789809588e-07
Rt16983 T3086 T5224 588545.71853466786
Gcorr5837 T3086 T6002 T3086 T6002 -2.9218860184821035e-07
Rt16984 T3086 T6020 2058678.7456631684
Rt16985 T3087 T3793 1286446.0989032558
Rt16986 T3087 T4147 298760.16838896333
Rt16987 T3087 T4197 1031728.195482751
Gcorr5838 T3087 T4743 T3087 T4743 -1.489530224389866e-07
Gcorr5839 T3087 T5224 T3087 T5224 -1.4446317734422929e-07
Rt16988 T3087 T5635 6589648.2203565473
Rt16989 T3087 T5984 714729.95052397344
Gcorr5840 T3087 T6002 T3087 T6002 -7.0335763126555219e-07
Rt16990 T3088 T3117 8608137.9822441712
Rt16991 T3088 T3118 2294331.8352340353
Rt16992 T3088 T3408 19623110.284194093
Rt16993 T3088 T3457 1375779.8039236888
Rt16994 T3088 T4622 1689761.9378315751
Rt16995 T3088 T4623 38660806.885552302
Rt16996 T3088 T4749 1488608.3620351048
Rt16997 T3088 T5995 16440536.006434809
Rt16998 T3089 T3090 1691423.9196343643
Rt16999 T3089 T3091 2078768.4905041547
Rt17000 T3089 T3822 2071024.344156825
Rt17001 T3089 T4129 2737352.1572174383
Gcorr5841 T3089 T4736 T3089 T4736 -1.3303877116531989e-07
Rt17002 T3089 T5036 3162970.4640257829
Gcorr5842 T3089 T5155 T3089 T5155 -1.9473514655871291e-07
Rt17003 T3089 T5250 1314740.3564111849
Rt17004 T3089 T5944 2580477.2693772479
Rt17005 T3090 T3091 852688.89088371268
Rt17006 T3090 T3092 122034.8267405339
Rt17007 T3090 T3142 1424446.4970433768
Rt17008 T3090 T4151 707303.44835698779
Gcorr5843 T3090 T4661 T3090 T4661 -2.8406735713043177e-07
Rt17009 T3090 T4736 191727.52649943807
Gcorr5844 T3090 T5369 T3090 T5369 -2.8801682351403166e-07
Gcorr5845 T3090 T5692 T3090 T5692 -3.5996557124568751e-07
Gcorr5846 T3090 T5944 T3090 T5944 -1.0503853950021336e-07
Gcorr5847 T3090 T5956 T3090 T5956 -3.3095064767300497e-06
Rt17010 T3091 T3092 6355607.304474799
Rt17011 T3091 T3093 5071156.1116655301
Rt17012 T3091 T3591 553397.43900674104
Rt17013 T3091 T4129 3365049.2090791157
Gcorr5848 T3091 T4736 T3091 T4736 -2.037735548186897e-07
Rt17014 T3091 T5250 1919223.3333158039
Gcorr5849 T3091 T5339 T3091 T5339 -5.587504427323691e-07
Rt17015 T3091 T5369 779999.34191559732
Rt17016 T3092 T3093 1260443.2869852397
Rt17017 T3092 T3094 2486640.8795941859
Rt17018 T3092 T3204 2476535.2892780439
Rt17019 T3092 T3425 1925422.5272988931
Rt17020 T3092 T4151 17770737.841870934
Rt17021 T3092 T4724 26564128.067712873
Gcorr5850 T3092 T4736 T3092 T4736 -3.4591799700582994e-06
Gcorr5851 T3092 T5369 T3092 T5369 -1.7112662151725002e-08
Gcorr5852 T3092 T5371 T3092 T5371 -1.3977987363773837e-07
Rt17022 T3092 T5692 3810902.6851729178
Rt17023 T3092 T5956 237269.01814775213
Rt17024 T3092 T6040 14359386.859155808
Rt17025 T3093 T3094 3695827.7175626098
Rt17026 T3093 T3095 2071281.6494838677
Rt17027 T3093 T3591 1279235.3203831387
Rt17028 T3093 T3950 1798488.9480600778
Gcorr5853 T3093 T5339 T3093 T5339 -1.5989162216321464e-07
Rt17029 T3093 T5369 1121329.8098801405
Rt17030 T3093 T5370 2766898.3790222039
Rt17031 T3093 T5371 3840814.8955032309
Gcorr5854 T3093 T5956 T3093 T5956 -3.1588328642498454e-07
Rt17032 T3094 T3095 1354906.5758805277
Rt17033 T3094 T3096 2409395.6191258407
Rt17034 T3094 T3204 4757989.6982658897
Rt17035 T3094 T3467 3448416.1918858942
Rt17036 T3094 T3811 3152592.1650389256
Rt17037 T3094 T5371 1047583.4656770224
Rt17038 T3094 T5712 21801369.538884163
Rt17039 T3094 T5780 17538630.919609528
Gcorr5855 T3094 T5994 T3094 T5994 -1.5889039076671694e-07
Rt17040 T3094 T6040 9507048.9756973702
Rt17041 T3095 T3096 5070335.5393805075
Rt17042 T3095 T3097 1661854.6374383448
Rt17043 T3095 T3130 2005267.5846542395
Rt17044 T3095 T3950 5212656.4955243599
Rt17045 T3095 T5370 1884251.1909597677
Gcorr5856 T3095 T5371 T3095 T5371 -2.2935950834306573e-07
Gcorr5857 T3095 T5925 T3095 T5925 -3.3557308200390842e-08
Rt17046 T3095 T5994 1357123.6941225335
Rt17047 T3096 T3097 2367576.2233819892
Rt17048 T3096 T3119 2586019.3499168041
Rt17049 T3096 T3234 4332110.3318140786
Rt17050 T3096 T3467 1692455.2179069987
Rt17051 T3096 T4725 13602730.433457434
Rt17052 T3096 T4885 3541450.8630716358
Rt17053 T3096 T5780 2760184.5406262325
Rt17054 T3096 T5994 6384204.2003832059
Rt17055 T3097 T3119 2443072.5343757733
Rt17056 T3097 T3120 2252869.0656933771
Rt17057 T3097 T3130 8590138.6706732195
Rt17058 T3097 T3945 1421494.1454265111
Rt17059 T3097 T4885 4049194.8574801623
Gcorr5858 T3097 T5793 T3097 T5793 -1.3980996864843641e-07
Rt17060 T3097 T5924 3148601.5301494529
Rt17061 T3097 T5925 1452209.2740069393
Gcorr5859 T3097 T5994 T3097 T5994 -1.3854157695122289e-07
Rt17062 T3098 T3149 2455937.4306626627
Rt17063 T3098 T3522 1989272.8410320531
Rt17064 T3098 T3616 1826357.8165832984
Rt17065 T3098 T4082 1760308.1422556152
Rt17066 T3098 T4875 863455.13036540162
Gcorr5860 T3098 T4876 T3098 T4876 -6.6084105138189278e-07
Rt17067 T3098 T4983 3647634.7097081649
Rt17068 T3098 T5216 8180393.3111285632
Gcorr5861 T3098 T6062 T3098 T6062 -3.2093082916523287e-08
Rt17069 T3099 T3100 7028215.9854514664
Rt17070 T3099 T3173 7218700.8276285203
Gcorr5862 T3099 T3205 T3099 T3205 -1.4815369529522237e-07
Rt17071 T3099 T3428 12623130.011020625
Rt17072 T3099 T4073 429350.90304486442
Rt17073 T3099 T4303 1422301.8786112613
Rt17074 T3099 T4304 25754705.531163458
Rt17075 T3099 T4307 1275631.1481736633
Gcorr5863 T3099 T5208 T3099 T5208 -4.223674814656812e-07
Rt17076 T3100 T3205 1465639.9200697595
Rt17077 T3100 T3426 1106430.3852422265
Rt17078 T3100 T3804 1845547.5234338038
Rt17079 T3100 T3843 2771369.8411041158
Gcorr5864 T3100 T4301 T3100 T4301 -9.3594922512977625e-08
Rt17080 T3100 T4302 2828719.1374184485
Rt17081 T3100 T4303 912225.92861885694
Gcorr5865 T3100 T4305 T3100 T4305 -7.5080822664818742e-08
Gcorr5866 T3100 T6017 T3100 T6017 -1.8699484402954009e-07
Rt17082 T3101 T3799 3667196.4809384295
Gcorr5867 T3101 T3810 T3101 T3810 -1.3702468622240888e-07
Rt17083 T3101 T3938 1486277.707499641
Rt17084 T3101 T3962 1491890.4520194968
Rt17085 T3101 T4221 22706855.712123204
Rt17086 T3101 T4238 3731780.9755001669
Rt17087 T3101 T5815 1009623.5481594781
Gcorr5868 T3101 T5900 T3101 T5900 -1.1825230023223056e-07
Rt17088 T3101 T5986 1952591.2408838689
Rt17089 T3102 T3103 6012257.0862785578
Rt17090 T3102 T3104 1415296.7234334489
Rt17091 T3102 T3844 16953739.05317178
Rt17092 T3102 T3962 2008054.5082176311
Rt17093 T3102 T5222 4549161.7548531126
Rt17094 T3102 T5402 1816553.9774944531
Rt17095 T3102 T5754 2704532.3788732886
Rt17096 T3103 T3104 2394397.373731737
Rt17097 T3103 T3105 28951512.401952595
Rt17098 T3103 T3163 12222305.258849809
Rt17099 T3103 T4177 561778.55827630591
Rt17100 T3103 T5402 2632692.7520654649
Rt17101 T3103 T5739 21532385.40521754
Rt17102 T3103 T5740 3869595.5136041376
Rt17103 T3103 T6079 4650429.3085497692
Rt17104 T3104 T3105 6597936.2760543386
Rt17105 T3104 T3106 1815358.048157789
Rt17106 T3104 T3844 1394809.4238026342
Rt17107 T3104 T3942 5232667.9848994035
Rt17108 T3104 T5020 1382640.4145344794
Rt17109 T3104 T5402 4686557.4613308804
Rt17110 T3104 T5740 2614171.1897016945
Gcorr5869 T3104 T5754 T3104 T5754 -2.0583728968147833e-07
Rt17111 T3105 T3106 1685999.7575114437
Rt17112 T3105 T3107 6616653.4053491838
Rt17113 T3105 T3283 2052843.8562207632
Rt17114 T3105 T3435 2101296.9284675815
Rt17115 T3105 T4177 2332914.1476183175
Rt17116 T3105 T5421 2486772.0974235418
Rt17117 T3105 T5470 5596801.1648057327
Gcorr5870 T3105 T5694 T3105 T5694 -8.3419526737116833e-08
Rt17118 T3105 T5740 1989691.0968813812
Rt17119 T3106 T3107 1561556.2783279493
Rt17120 T3106 T3108 5139459.4621974565
Rt17121 T3106 T3116 14787397.34444782
Rt17122 T3106 T3942 1344363.7791321529
Rt17123 T3106 T5008 1563135.1687900063
Rt17124 T3106 T5020 2744711.6191529646
Rt17125 T3106 T5421 3814701.0092928852
Gcorr5871 T3106 T5740 T3106 T5740 -1.8556602276943346e-07
Rt17126 T3107 T3108 1582276.9490920065
Rt17127 T3107 T3109 6929526.0753908167
Rt17128 T3107 T3283 704665.50829927681
Rt17129 T3107 T3452 2903478.5309268921
Rt17130 T3107 T3832 6228550.3042408582
Rt17131 T3107 T5007 2009031.460776259
Gcorr5872 T3107 T5008 T3107 T5008 -1.9672177611042725e-07
Rt17132 T3107 T5420 4384969.7594854506
Rt17133 T3107 T5421 876714.13084630924
Gcorr5873 T3107 T5694 T3107 T5694 -6.3813418256822886e-07
Rt17134 T3108 T3109 2065949.6500038602
Rt17135 T3108 T3110 6204353.9275395777
Rt17136 T3108 T3116 11108894.642409137
Rt17137 T3108 T4113 1403611.4752816097
Rt17138 T3108 T4960 3640634.7882864093
Rt17139 T3108 T5007 16319108.343900498
Rt17140 T3108 T5008 1455642.8822066044
Rt17141 T3109 T3110 1742303.9819324715
Rt17142 T3109 T3126 6597452.3693054393
Rt17143 T3109 T3341 2066407.9529897431
Rt17144 T3109 T3452 1274395.2299159733
Rt17145 T3109 T4959 1889228.045407665
Gcorr5874 T3109 T4960 T3109 T4960 -1.0532067945964555e-07
Rt17146 T3109 T5007 2028777.309390079
Gcorr5875 T3109 T5227 T3109 T5227 -1.2644405253595901e-08
Rt17147 T3110 T3126 2092622.5544792782
Rt17148 T3110 T3127 6055522.5169402836
Rt17149 T3110 T4113 1852268.9890737426
Rt17150 T3110 T4141 1416139.9072087326
Rt17151 T3110 T4931 2403338.3255324746
Gcorr5876 T3110 T4959 T3110 T4959 -5.1540678896923858e-08
Rt17152 T3110 T4960 1561651.4474925331
Gcorr5877 T3110 T5947 T3110 T5947 -8.0320881756069206e-08
Rt17153 T3111 T3776 4208855.4512325497
Gcorr5878 T3111 T3821 T3111 T3821 -3.4444372315644761e-07
Rt17154 T3111 T3822 8324963.8457549345
Rt17155 T3111 T3939 909219.61813826207
Rt17156 T3111 T5153 1691081.9436727737
Rt17157 T3111 T5155 1978108.7032337137
Rt17158 T3111 T5377 1178614.4469915782
Gcorr5879 T3112 T3113 T3112 T3113 -1.1083366168822613e-07
Rt17159 T3112 T3553 3706729.3475478045
Rt17160 T3112 T3554 17599552.840107571
Rt17161 T3112 T4024 882573.17812335829
Rt17162 T3112 T4123 924612.30876765749
Gcorr5880 T3112 T4277 T3112 T4277 -1.4564933960879995e-07
Rt17163 T3112 T5657 1514606.2282472798
Rt17164 T3112 T5658 1968875.9620922569
Rt17165 T3113 T3114 5145703.6252162848
Rt17166 T3113 T3115 999888.9020014269
Rt17167 T3113 T3124 5933963.9686570177
Rt17168 T3113 T4123 550334.88943808584
Rt17169 T3113 T4265 4157717.86927982
Gcorr5881 T3113 T4267 T3113 T4267 -4.7079808504591924e-07
Gcorr5882 T3113 T4277 T3113 T4277 -9.0694072726181371e-09
Rt17170 T3113 T5658 6039603.6927576251
Rt17171 T3113 T5864 838461.18707798724
Rt17172 T3114 T3115 1882198.4146272067
Rt17173 T3114 T3575 1395910.1153164909
Rt17174 T3114 T3576 748665.13035231375
Rt17175 T3114 T3925 740071.41837213072
Rt17176 T3114 T4816 379700.67933804175
Gcorr5883 T3114 T5660 T3114 T5660 -6.0063923795714103e-07
Gcorr5884 T3114 T5864 T3114 T5864 -7.4290747031018038e-09
Gcorr5885 T3114 T5915 T3114 T5915 -4.8975385021598498e-07
Rt17177 T3115 T3124 640340.82127493585
Rt17178 T3115 T3125 641817.26349938358
Rt17179 T3115 T3174 1660947.8205785905
Rt17180 T3115 T3575 2557528.0791746024
Gcorr5886 T3115 T4265 T3115 T4265 -7.5222988588289586e-07
Gcorr5887 T3115 T4266 T3115 T4266 -6.5127543047617909e-07
Rt17181 T3115 T4267 352995.77716507157
Gcorr5888 T3115 T4268 T3115 T4268 -8.496235727928565e-08
Rt17182 T3115 T4269 5701040.8508005589
Rt17183 T3115 T4816 62693738.830590799
Gcorr5889 T3115 T5864 T3115 T5864 -2.3563890409411034e-07
Rt17184 T3116 T3462 3451412.3588082115
Rt17185 T3116 T3942 1364471.790143393
Rt17186 T3116 T4113 1231645.0253642115
Rt17187 T3116 T4150 4408336.6144497301
Rt17188 T3116 T5008 1731199.3875935075
Rt17189 T3116 T5018 5803023.7428462189
Rt17190 T3116 T5019 1930025.5059643521
Rt17191 T3117 T3118 2572741.4198114532
Rt17192 T3117 T3190 2370516.7876506415
Rt17193 T3117 T3533 1989431.5646187002
Rt17194 T3117 T3534 1409356.865461095
Rt17195 T3117 T4383 2105899.8840982034
Gcorr5890 T3117 T4384 T3117 T4384 -9.2125462736258079e-08
Rt17196 T3117 T4621 3573979.1221740772
Rt17197 T3117 T4622 2625347.0959830428
Gcorr5891 T3117 T5722 T3117 T5722 -9.0391575172237003e-08
Rt17198 T3118 T3457 2960251.5791205158
Rt17199 T3118 T3533 1954178.4292203269
Rt17200 T3118 T3535 3473167.189710292
Rt17201 T3118 T3536 1854455.9538301595
Gcorr5892 T3118 T4622 T3118 T4622 -8.3604185429793115e-08
Rt17202 T3118 T4822 17474969.086091358
Rt17203 T3118 T5722 2172384.3649219605
Rt17204 T3118 T5995 6142969.9463928146
Rt17205 T3118 T6070 5372782.9498083405
Rt17206 T3119 T3120 2316379.6816710131
Rt17207 T3119 T3121 955682.5006331047
Rt17208 T3119 T3234 4379585.7358862823
Rt17209 T3119 T3542 1553607.1882176704
Rt17210 T3119 T3872 2173534.7182859485
Rt17211 T3119 T4725 64559000.679020539
Rt17212 T3119 T4726 726620.63493445783
Gcorr5893 T3119 T4788 T3119 T4788 -5.5900912959732842e-07
Gcorr5894 T3119 T4789 T3119 T4789 -1.4440345804054251e-07
Rt17213 T3119 T4885 9270041.30797779
Rt17214 T3119 T5924 7370741.9718340896
Rt17215 T3120 T3121 5224181.9011311596
Rt17216 T3120 T3122 1351605.1053531461
Rt17217 T3120 T3454 2211778.5332953692
Rt17218 T3120 T3945 4596609.5229193466
Rt17219 T3120 T4789 1889442.9026135842
Gcorr5895 T3120 T4937 T3120 T4937 -1.1229423285905521e-07
Rt17220 T3120 T5793 2530070.5514900279
Rt17221 T3120 T5924 7523646.3611010034
Rt17222 T3121 T3122 2037651.8857138788
Rt17223 T3121 T3143 5999925.9682944529
Rt17224 T3121 T3232 2047111.6526092091
Rt17225 T3121 T3542 2616618.5111465398
Gcorr5896 T3121 T4726 T3121 T4726 -4.2943602281467759e-07
Rt17226 T3121 T4788 1977754.0213189856
Rt17227 T3121 T4789 1987825.5079448675
Rt17228 T3121 T4936 4217550.8847203245
Rt17229 T3122 T3143 1914320.9207997143
Rt17230 T3122 T3144 1049779.5878549251
Rt17231 T3122 T3454 4290038.2682070574
Rt17232 T3122 T3896 3085795.035507862
Gcorr5897 T3122 T4789 T3122 T4789 -1.2243611810258009e-07
Rt17233 T3122 T4936 10950041.716879813
Rt17234 T3122 T4937 837728.26850962231
Gcorr5898 T3122 T4952 T3122 T4952 -2.4868983137112183e-07
Rt17235 T3123 T3202 2675988.5348786749
Rt17236 T3123 T3358 5720207.6130228546
Rt17237 T3123 T3460 2658073.8598215827
Rt17238 T3123 T4078 1137073.0868152699
Rt17239 T3123 T4143 1462309.407002504
Gcorr5899 T3123 T5548 T3123 T5548 -1.3421344332046259e-07
Rt17240 T3123 T5610 3338436.396965242
Rt17241 T3123 T5769 1768270.9694123408
Gcorr5900 T3123 T5911 T3123 T5911 -2.1244527871003094e-08
Rt17242 T3124 T3125 6117937.9776087636
Rt17243 T3124 T3332 2438825.4236224759
Rt17244 T3124 T3440 2074182.750394234
Rt17245 T3124 T3441 1105642.745656342
Gcorr5901 T3124 T4123 T3124 T4123 -1.3340055915802811e-08
Gcorr5902 T3124 T4263 T3124 T4263 -1.6640561409306546e-07
Rt17246 T3124 T4264 6614096.1330264788
Rt17247 T3124 T4265 690553.95113129506
Rt17248 T3124 T4266 3128417.607861578
Gcorr5903 T3124 T4267 T3124 T4267 -7.2784671423371247e-07
Rt17249 T3125 T3174 5307435.0707147634
Rt17250 T3125 T3175 1648333.3166476944
Rt17251 T3125 T3332 1416542.3974084773
Rt17252 T3125 T3491 1907326.9134155228
Rt17253 T3125 T4266 730375.13496500975
Gcorr5904 T3125 T4267 T3125 T4267 -6.1579409037160092e-07
Rt17254 T3125 T4268 2381196.1671906263
Rt17255 T3125 T5246 9401640.8914416805
Gcorr5905 T3125 T5688 T3125 T5688 -1.9773283621316569e-07
Gcorr5906 T3125 T6037 T3125 T6037 -5.0189130371017552e-08
Rt17256 T3126 T3127 1762288.7491411602
Rt17257 T3126 T3128 5999492.2680699788
Rt17258 T3126 T3341 1998512.3202877117
Rt17259 T3126 T3510 19733254.644758776
Rt17260 T3126 T3917 1574677.4313149147
Rt17261 T3126 T4930 1586196.7637808854
Gcorr5907 T3126 T4931 T3126 T4931 -2.1094955126124205e-08
Rt17262 T3126 T4959 2140535.3264265144
Gcorr5908 T3126 T5226 T3126 T5226 -1.3977048210640361e-07
Rt17263 T3127 T3128 2006107.3196271346
Rt17264 T3127 T3129 1952646.8291567117
Rt17265 T3127 T3437 8195014.2910627266
Rt17266 T3127 T4141 1650264.9854323878
Rt17267 T3127 T4929 4445498.9991064919
Gcorr5909 T3127 T4930 T3127 T4930 -1.3959446043733788e-07
Rt17268 T3127 T4931 1792152.5536279709
Rt17269 T3127 T6088 3586935.777883451
Rt17270 T3128 T3129 2038792.693676312
Rt17271 T3128 T3150 1845806.200977382
Rt17272 T3128 T3335 4955288.2438688008
Rt17273 T3128 T3510 1402016.5480703558
Gcorr5910 T3128 T4867 T3128 T4867 -1.7736092074532414e-07
Rt17274 T3128 T4928 2073333.6316838309
Rt17275 T3128 T4929 3970776.152145498
Rt17276 T3128 T4930 3770174.4889282519
Rt17277 T3129 T3150 5051812.1224967465
Rt17278 T3129 T3151 1920494.537129235
Rt17279 T3129 T3437 2307178.5858788118
Rt17280 T3129 T3882 4411418.8559954874
Rt17281 T3129 T4867 4190725.4361340967
Rt17282 T3129 T4929 3094166.9731254042
Rt17283 T3129 T5181 2223335.647348959
Gcorr5911 T3129 T6088 T3129 T6088 -9.9889481894170476e-08
Gcorr5912 T3130 T3495 T3130 T3495 -2.1583165601403723e-07
Rt17284 T3130 T3945 1425529.6834574642
Rt17285 T3130 T3946 1285232.4957803106
Rt17286 T3130 T3950 1162322.7716828207
Gcorr5913 T3130 T5370 T3130 T5370 -1.2445648490465651e-07
Rt17287 T3130 T5687 1531074081.8434303
Rt17288 T3130 T5925 1752214.6883032157
Rt17289 T3130 T5926 998641.10815422086
Rt17290 T3131 T3616 2453413.6508411132
Rt17291 T3131 T3617 577136.05916811991
Rt17292 T3131 T3618 5728035.6822747746
Rt17293 T3131 T4035 994250.75328085711
Gcorr5914 T3131 T4082 T3131 T4082 -1.2231175906281964e-08
Rt17294 T3131 T5233 1120371.3665527054
Gcorr5915 T3131 T5300 T3131 T5300 -6.306756005190844e-07
Rt17295 T3131 T5698 12441768.494298793
Rt17296 T3131 T6026 2000386.8207615972
Rt17297 T3132 T3133 35126484.656196639
Rt17298 T3132 T3135 8192939.1462737992
Rt17299 T3132 T3517 641225.40895934415
Rt17300 T3132 T3588 3488240.6774667837
Rt17301 T3132 T4097 2232972.2922689007
Rt17302 T3132 T4360 3670941.9381837621
Gcorr5916 T3132 T4362 T3132 T4362 -6.4090960164776227e-07
Rt17303 T3132 T4627 1797050.0227942422
Rt17304 T3132 T5851 1022191.4017376162
Rt17305 T3133 T3134 12682188.330247186
Gcorr5917 T3133 T3598 T3133 T3598 -7.8385065461971433e-08
Rt17306 T3133 T3599 2482153.520172867
Rt17307 T3133 T3953 1166390.0082656257
Rt17308 T3133 T4097 875663.63987062243
Rt17309 T3133 T4356 26514952.795736078
Rt17310 T3133 T4358 10054896.104328014
Rt17311 T3133 T4627 5811955.2070561526
Rt17312 T3133 T5836 1848841.1974096717
Gcorr5918 T3134 T3337 T3134 T3337 -1.7385520041933618e-07
Rt17313 T3134 T3833 1489796.4386096953
Rt17314 T3134 T3953 1284959.1463804534
Rt17315 T3134 T4100 1003507.1901596406
Rt17316 T3134 T4996 3182939.4769150526
Rt17317 T3134 T5773 4475256.2941314718
Rt17318 T3134 T5774 3687508.7551450599
Rt17319 T3134 T5836 16515555.783738267
Rt17320 T3135 T3517 1933911.4037659224
Rt17321 T3135 T3625 1637616.6389319901
Rt17322 T3135 T3749 3326797.885442018
Rt17323 T3135 T4115 747617.88312932185
Rt17324 T3135 T4142 5641530.8346818862
Rt17325 T3135 T4362 51586761.5828024
Gcorr5919 T3135 T4364 T3135 T4364 -1.2950094777388114e-09
Rt17326 T3135 T4663 72309464.564095452
Rt17327 T3135 T5732 685726.30911774922
Gcorr5920 T3135 T5775 T3135 T5775 -6.9470479004056272e-07
Rt17328 T3135 T5851 16493046.945272623
Rt17329 T3136 T3137 22190281.295566961
Rt17330 T3136 T3778 1356815.9128977621
Gcorr5921 T3136 T3810 T3136 T3810 -3.186015539144091e-07
Rt17331 T3136 T3938 1213326.6699417913
Rt17332 T3136 T4237 2087148.151160778
Rt17333 T3136 T4239 1264416.7307808276
Gcorr5922 T3136 T5623 T3136 T5623 -1.5064224447631653e-07
Rt17334 T3136 T6029 1487884.1818739024
Rt17335 T3137 T3710 2775861.5231737434
Rt17336 T3137 T3778 1361949.0850045485
Rt17337 T3137 T3863 1514025.4368423324
Rt17338 T3137 T4096 1915601.7281452117
Rt17339 T3137 T4231 2567846.9803605988
Rt17340 T3137 T4239 939279.00444401568
Rt17341 T3137 T4240 4098542.8029486402
Rt17342 T3138 T3551 8277547.3011853844
Rt17343 T3138 T3881 2191283.0193638774
Rt17344 T3138 T3905 1070698.7524650623
Rt17345 T3138 T3968 8330463.1062065959
Gcorr5923 T3138 T5196 T3138 T5196 -4.8659290950681529e-08
Rt17346 T3138 T5198 2524008.7818219275
Gcorr5924 T3138 T5315 T3138 T5315 -3.696511396321818e-08
Rt17347 T3138 T5852 8598004.5429439768
Rt17348 T3138 T5860 661277.87372470438
Rt17349 T3139 T3140 915651.57400017313
Gcorr5925 T3139 T3728 T3139 T3728 -1.5024337811213824e-07
Gcorr5926 T3139 T3821 T3139 T3821 -1.5652483830694571e-07
Rt17350 T3139 T3939 1426173.5862770446
Rt17351 T3139 T4222 1157355.4574785433
Rt17352 T3139 T5293 3798501.1896837861
Gcorr5927 T3139 T5571 T3139 T5571 -1.3576181656892325e-07
Rt17353 T3139 T5753 1311936.0089655567
Rt17354 T3140 T3725 238267.96318901371
Rt17355 T3140 T3726 13948160.160301577
Rt17356 T3140 T3727 2085050.5390641554
Rt17357 T3140 T3728 355530.13817694044
Gcorr5928 T3140 T4222 T3140 T4222 -8.3884331651275301e-07
Gcorr5929 T3140 T5287 T3140 T5287 -1.7518396349803429e-06
Gcorr5930 T3140 T5291 T3140 T5291 -2.4313420236389332e-08
Rt17358 T3140 T5293 425909.53568346653
Rt17359 T3140 T6015 505260.47233305912
Rt17360 T3141 T3203 1820931.9759948705
Rt17361 T3141 T3505 2172605.9622130115
Rt17362 T3141 T3506 2179891.0928510898
Rt17363 T3141 T3996 14440284.855198514
Rt17364 T3141 T4078 1461632.6220804211
Rt17365 T3141 T4143 1224253.092524776
Rt17366 T3141 T4660 120801746.7766131
Gcorr5931 T3141 T5209 T3141 T5209 -1.4592576299774969e-07
Rt17367 T3141 T5225 4353241.3419921799
Rt17368 T3141 T5866 2932932.6876523164
Rt17369 T3141 T6087 5270737.3342339322
Rt17370 T3142 T3619 1779017.6598001991
Rt17371 T3142 T3747 5469264.6232646452
Rt17372 T3142 T4133 4712420.2242196081
Rt17373 T3142 T4151 2136132.0087306332
Rt17374 T3142 T4176 961473.43458667002
Rt17375 T3142 T4645 3636883.3924133801
Gcorr5932 T3142 T4646 T3142 T4646 -3.6675143170344286e-08
Rt17376 T3142 T4661 1424258.4956303877
Gcorr5933 T3142 T4736 T3142 T4736 -3.5081786191104692e-07
Rt17377 T3143 T3144 4498630.7407038836
Rt17378 T3143 T3145 2707074.4766321685
Rt17379 T3143 T3232 1418491.6599814221
Rt17380 T3143 T3700 2627906.3204387897
Rt17381 T3143 T4069 3178484.288214983
Rt17382 T3143 T4936 1689303.4157025863
Rt17383 T3143 T4952 5230880.0955367498
Gcorr5934 T3143 T5254 T3143 T5254 -2.3167822673528587e-07
Rt17384 T3143 T5344 3606795.4829380056
Rt17385 T3144 T3145 2174869.7231553211
Rt17386 T3144 T3146 3994789.8051463999
Rt17387 T3144 T3147 2041275.7753724344
Rt17388 T3144 T3896 1916272.395298413
Gcorr5935 T3144 T4937 T3144 T4937 -2.4154626865295748e-07
Rt17389 T3144 T4952 1267939.4300773877
Rt17390 T3144 T4953 6927498.4250355167
Rt17391 T3144 T5794 5783785.0646492708
Rt17392 T3145 T3146 1630301.1743440216
Rt17393 T3145 T3532 4642308.8626075359
Rt17394 T3145 T3700 1731983.1024536134
Rt17395 T3145 T3861 1368284.216398472
Rt17396 T3145 T4952 8779152.4488907475
Rt17397 T3145 T5344 30722905.174301319
Rt17398 T3145 T5355 1510972.6415091287
Gcorr5936 T3145 T5794 T3145 T5794 -1.747233637396366e-07
Rt17399 T3145 T6073 23465634.285907593
Rt17400 T3146 T3147 1972616.2670039735
Rt17401 T3146 T3148 2049633.4974549094
Rt17402 T3146 T3221 5781296.8798745247
Rt17403 T3146 T3532 1609194.7602301596
Rt17404 T3146 T5182 2640183.405678153
Gcorr5937 T3146 T5298 T3146 T5298 -5.106768304145364e-08
Gcorr5938 T3146 T5355 T3146 T5355 -1.4910081480360262e-07
Rt17405 T3146 T5794 1501524.1514010783
Rt17406 T3147 T3148 4581841.3660623962
Rt17407 T3147 T3198 1561715.2446954497
Rt17408 T3147 T3455 2569457.6793396017
Rt17409 T3147 T3896 3596755.3061136426
Rt17410 T3147 T4953 1794963.0186646492
Rt17411 T3147 T5298 2255719.3598172627
Gcorr5939 T3147 T5794 T3147 T5794 -2.8422330622128485e-08
Rt17412 T3147 T5892 35833369.781700402
Rt17413 T3148 T3198 440977.47369714634
Rt17414 T3148 T3221 2147152.2925530658
Rt17415 T3148 T3222 2284670.3686737926
Rt17416 T3148 T4045 2476719.0688010668
Rt17417 T3148 T5005 7543916.9695409108
Gcorr5940 T3148 T5182 T3148 T5182 -1.5465216319740503e-07
Rt17418 T3148 T5298 741671.46973893105
Gcorr5941 T3148 T5892 T3148 T5892 -9.3114782259357984e-07
Rt17419 T3148 T5974 2099353.7460439699
Rt17420 T3149 T3235 13954170.85504589
Rt17421 T3149 T3522 9173524.5769762024
Rt17422 T3149 T3980 992450.0383350366
Rt17423 T3149 T4103 1009370.5439618164
Rt17424 T3149 T4873 10988090.269434251
Rt17425 T3149 T4875 26371878.944326546
Rt17426 T3149 T5395 2229673.9363246327
Rt17427 T3149 T6062 38860174.080670647
Rt17428 T3150 T3151 2217373.059285209
Rt17429 T3150 T3152 2229678.0307254991
Rt17430 T3150 T3335 2370519.3039858313
Rt17431 T3150 T3668 2910771.5727548073
Rt17432 T3150 T4086 3779371.1854208778
Gcorr5942 T3150 T4806 T3150 T4806 -1.0594577439155573e-07
Rt17433 T3150 T4866 2030171.4793421964
Rt17434 T3150 T4867 1921108.7894997527
Rt17435 T3150 T4928 13361561.109880663
Gcorr5943 T3150 T6080 T3150 T6080 -1.5598000947119437e-07
Rt17436 T3151 T3152 4536687.5491239317
Rt17437 T3151 T3153 1840109.3701782546
Rt17438 T3151 T3154 1998171.4073035878
Rt17439 T3151 T3882 1783847.3354331937
Rt17440 T3151 T4806 2531716.7705961475
Rt17441 T3151 T4867 3448688.3915098417
Gcorr5944 T3151 T5181 T3151 T5181 -9.5576181039134672e-08
Gcorr5945 T3151 T5820 T3151 T5820 -6.7578171294055385e-08
Rt17442 T3151 T5821 3005123.4607655122
Rt17443 T3152 T3153 693693.64443411061
Rt17444 T3152 T3580 3711772.4106473238
Rt17445 T3152 T3668 1609067.7112410387
Rt17446 T3152 T3895 1288378.8418338373
Rt17447 T3152 T4801 7063236.3417749917
Rt17448 T3152 T4802 3924907.9435124393
Rt17449 T3152 T4806 906819.68068428582
Gcorr5946 T3152 T4866 T3152 T4866 -1.3867111600160874e-07
Gcorr5947 T3152 T5820 T3152 T5820 -7.0154670647061563e-07
Rt17450 T3153 T3154 1855010.5102730282
Rt17451 T3153 T3155 2227886.1273474824
Rt17452 T3153 T3217 5521913.4201098904
Rt17453 T3153 T3580 1581281.8863827421
Gcorr5948 T3153 T4802 T3153 T4802 -1.1518423561765384e-07
Rt17454 T3153 T4804 3561785.4858213305
Gcorr5949 T3153 T4806 T3153 T4806 -6.9942072867860197e-07
Gcorr5950 T3153 T4861 T3153 T4861 -3.9044472208002725e-08
Rt17455 T3153 T5820 720477.76581266697
Rt17456 T3154 T3155 1878274.4543208075
Rt17457 T3154 T3233 4424852.1788743343
Rt17458 T3154 T3438 2450465.9990414311
Rt17459 T3154 T3882 3531200.2987020458
Rt17460 T3154 T4861 5532170.0589723559
Rt17461 T3154 T5213 4960211.9423030512
Gcorr5951 T3154 T5820 T3154 T5820 -1.1237302766155832e-07
Rt17462 T3154 T5821 1417658.9928514312
Rt17463 T3155 T3217 2072562.153718651
Rt17464 T3155 T3218 1769633.7549095447
Rt17465 T3155 T3233 1759734.6817754593
Rt17466 T3155 T3578 3840088.9406423336
Gcorr5952 T3155 T4804 T3155 T4804 -1.5596210511701486e-07
Rt17467 T3155 T4859 5421792.9296377283
Rt17468 T3155 T4861 1638230.7595999555
Rt17469 T3155 T5111 2471863.5902473829
Gcorr5953 T3155 T5213 T3155 T5213 -1.5178866923658689e-07
Rt17470 T3156 T3158 949075.44122672803
Rt17471 T3156 T3912 10630304.295118406
Rt17472 T3156 T3915 626440.4224052924
Rt17473 T3156 T4044 3116364.7483930741
Rt17474 T3156 T5281 446227.90150210093
Gcorr5954 T3156 T5282 T3156 T5282 -4.5484561567428021e-07
Gcorr5955 T3156 T5283 T3156 T5283 -1.7467596821689564e-07
Gcorr5956 T3156 T5285 T3156 T5285 -4.1926242665421153e-07
Rt17475 T3157 T3748 4803507.6228758544
Rt17476 T3157 T3804 12163372.360587034
Gcorr5957 T3157 T3900 T3157 T3900 -2.2079648751591038e-07
Rt17477 T3157 T4074 927243.90060256142
Rt17478 T3157 T4297 1130874.8704282918
Rt17479 T3157 T4301 1144610.431523558
Rt17480 T3157 T5634 5219161.5706581585
Rt17481 T3158 T3397 13857825.785696382
Rt17482 T3158 T3515 1693021.059522874
Gcorr5958 T3158 T3867 T3158 T3867 -1.0282264810832794e-07
Rt17483 T3158 T3912 1860535.0736262561
Rt17484 T3158 T4230 1618106.9763414811
Gcorr5959 T3158 T5281 T3158 T5281 -3.0897566301875558e-08
Rt17485 T3158 T5282 829416.11932036839
Rt17486 T3159 T3334 2314901.686968809
Rt17487 T3159 T3709 6225745.7468745299
Rt17488 T3159 T3710 4108406.7097934727
Rt17489 T3159 T3863 24160187.154915765
Rt17490 T3159 T4240 4125968.1711478252
Rt17491 T3159 T5200 1234894.7394429073
Rt17492 T3159 T5810 895760.22103036207
Gcorr5960 T3159 T5975 T3159 T5975 -1.9261588663842402e-07
Rt17493 T3159 T6038 3123803.9257245674
Rt17494 T3160 T3509 3202502.6116920034
Gcorr5961 T3160 T3735 T3160 T3735 -4.0163335426326596e-07
Rt17495 T3160 T3809 1327183.144021743
Rt17496 T3160 T3840 1081163.8575413798
Gcorr5962 T3160 T4181 T3160 T4181 -7.5300536195027978e-08
Rt17497 T3160 T4756 1088778.8431305885
Rt17498 T3160 T5031 757677.92655985325
Rt17499 T3160 T5032 754945.63540850044
Gcorr5963 T3160 T5446 T3160 T5446 -2.575414920906136e-07
Rt17500 T3161 T3521 2241347.8179594851
Rt17501 T3161 T3620 2196898.4336397871
Rt17502 T3161 T3790 2655886.7442015056
Rt17503 T3161 T3887 1905071.0423550266
Rt17504 T3161 T4091 2518208.5643397295
Gcorr5964 T3161 T4856 T3161 T4856 -1.1685741004263143e-08
Rt17505 T3161 T5022 2827009.1204572273
Gcorr5965 T3161 T5230 T3161 T5230 -1.889292132542805e-07
Rt17506 T3161 T5231 1778614.3923197987
Gcorr5966 T3161 T5968 T3161 T5968 -7.9763031946544209e-08
Gcorr5967 T3162 T3809 T3162 T3809 -6.2181348363506233e-07
Rt17507 T3162 T3837 2606582.0093054534
Rt17508 T3162 T3925 924291.53395050194
Rt17509 T3162 T4031 1101192.9116750932
Rt17510 T3162 T5112 668131.65635682386
Rt17511 T3162 T5549 1202567.9807137162
Gcorr5968 T3162 T5659 T3162 T5659 -3.0081040023783963e-07
Rt17512 T3162 T5660 1508185.381370153
Rt17513 T3163 T3656 13922558.619779665
Rt17514 T3163 T3658 3318422.7867686762
Rt17515 T3163 T3696 2482102.2050231732
Rt17516 T3163 T3697 1546190.2862775358
Rt17517 T3163 T4161 2094004.6849322063
Rt17518 T3163 T4177 970311.79437804187
Gcorr5969 T3163 T4719 T3163 T4719 -1.2152682360333961e-08
Rt17519 T3163 T4720 1697371.8250718697
Rt17520 T3163 T5596 12794526.125528565
Gcorr5970 T3163 T5739 T3163 T5739 -4.5508900573264594e-07
Rt17521 T3163 T6079 1780667.0545559349
Rt17522 T3164 T3165 2098857.7094669575
Rt17523 T3164 T3432 2353761.6310654171
Rt17524 T3164 T3537 3771195.9450222766
Rt17525 T3164 T3692 1127137.9184913817
Rt17526 T3164 T5207 27610417.134699028
Gcorr5971 T3164 T5468 T3164 T5468 -1.068404817483411e-07
Rt17527 T3164 T5743 2061846.103337612
Rt17528 T3164 T5931 2006839.1288881353
Rt17529 T3165 T3432 2153376.1353491442
Rt17530 T3165 T3684 1519598.8752878085
Rt17531 T3165 T3736 3314773.9936777186
Rt17532 T3165 T4090 1268401.6455480079
Gcorr5972 T3165 T4647 T3165 T4647 -7.6249566719038419e-08
Rt17533 T3165 T5468 1000087.497968888
Gcorr5973 T3165 T5931 T3165 T5931 -4.4958936575005346e-07
Gcorr5974 T3165 T5932 T3165 T5932 -1.3781088190775646e-07
Rt17534 T3165 T6025 2705078.2824106435
Gcorr5975 T3166 T3485 T3166 T3485 -4.6316317423708334e-08
Gcorr5976 T3166 T3486 T3166 T3486 -1.9521927708936245e-07
Rt17535 T3166 T3958 38259404.49118086
Rt17536 T3166 T4130 1319370.3408638786
Rt17537 T3166 T4994 4446373.3233686173
Rt17538 T3166 T5067 830957.53013413423
Rt17539 T3166 T5893 1415764.4711432841
Rt17540 T3167 T3777 1275748.0399644624
Rt17541 T3167 T3798 30638744.261614703
Rt17542 T3167 T4037 402384.13998613186
Rt17543 T3167 T4080 2257260.049851303
Rt17544 T3167 T4236 199566.86686435732
Gcorr5977 T3167 T5786 T3167 T5786 -5.0602789943813223e-07
Gcorr5978 T3167 T5798 T3167 T5798 -5.3425259581975119e-08
Rt17545 T3168 T3287 2641417.0924195135
Rt17546 T3168 T3527 1659673.8368512439
Rt17547 T3168 T3540 3877449.145726792
Rt17548 T3168 T3749 1491085.7855790716
Gcorr5979 T3168 T4380 T3168 T4380 -1.1480908003994599e-07
Gcorr5980 T3168 T5258 T3168 T5258 -2.1678154746076375e-07
Rt17549 T3168 T5636 2614876.1594209801
Rt17550 T3168 T5842 1781537.0545837148
Rt17551 T3168 T5976 4557617.5258653006
Rt17552 T3169 T3170 1404832.2202425059
Gcorr5981 T3169 T3924 T3169 T3924 -4.2492537480021231e-08
Rt17553 T3169 T3944 3018272.3086442132
Rt17554 T3169 T4004 1017020.3264412482
Rt17555 T3169 T4218 851305.74407632079
Rt17556 T3169 T5289 14519800.994647514
Rt17557 T3169 T5640 2506640.9518233743
Rt17558 T3169 T5641 10768588.816745969
Gcorr5982 T3169 T6053 T3169 T6053 -2.2263465649790386e-07
Rt17559 T3170 T3689 1699018.3699386248
Rt17560 T3170 T3690 1386779.015780071
Gcorr5983 T3170 T3753 T3170 T3753 -6.3405930735952216e-08
Rt17561 T3170 T3924 1840394.299135939
Gcorr5984 T3170 T4218 T3170 T4218 -2.0115202734384889e-07
Rt17562 T3170 T5163 14265589.244577603
Rt17563 T3170 T5641 888797.04880947515
Rt17564 T3170 T5642 1307770.0700988194
Rt17565 T3171 T3172 1149035.9864977575
Rt17566 T3171 T3371 1514368.1299738199
Gcorr5985 T3171 T3920 T3171 T3920 -7.1233763293253952e-08
Rt17567 T3171 T4011 12761706.873500217
Rt17568 T3171 T5296 1094708.0573870407
Gcorr5986 T3171 T5340 T3171 T5340 -5.5818113078312124e-08
Gcorr5987 T3171 T5643 T3171 T5643 -5.3579861361118825e-08
Rt17569 T3171 T5848 1327363.2164323346
Rt17570 T3172 T3550 696330.95140919881
Rt17571 T3172 T3551 1421368.5580946261
Rt17572 T3172 T3920 1153202.8122363291
Gcorr5988 T3172 T4087 T3172 T4087 -2.0894917789180137e-07
Rt17573 T3172 T4120 14978581.789842354
Rt17574 T3172 T4228 1323689.2150034995
Gcorr5989 T3172 T5199 T3172 T5199 -6.6793702412718701e-07
Gcorr5990 T3172 T5296 T3172 T5296 -8.681182232054285e-08
Rt17575 T3172 T5340 504088.25035931217
Gcorr5991 T3172 T5852 T3172 T5852 -5.25738987134706e-08
Rt17576 T3173 T3428 2133409.3801929271
Rt17577 T3173 T3429 1738594.8730300718
Rt17578 T3173 T3573 3690204.1289180559
Rt17579 T3173 T3754 1254013.3857508551
Rt17580 T3173 T4307 2550966.2387840892
Rt17581 T3173 T4308 35628066.935132623
Rt17582 T3173 T4309 2118553.5633405792
Gcorr5992 T3173 T5943 T3173 T5943 -1.4211505355845301e-07
Rt17583 T3174 T3175 1013281.4581746303
Rt17584 T3174 T3487 933403.62068799301
Rt17585 T3174 T3575 8817036.394326875
Rt17586 T3174 T3989 3565281.8523410843
Rt17587 T3174 T4268 616368.10506721586
Rt17588 T3174 T4269 3433591.2641286454
Rt17589 T3174 T4270 13819221.47370057
Gcorr5993 T3174 T6037 T3174 T6037 -6.6923572984099042e-07
Rt17590 T3175 T3487 2024193.1788341873
Rt17591 T3175 T3491 2162751.8820744245
Rt17592 T3175 T3497 5389841.940864278
Rt17593 T3175 T3948 1452889.7444130734
Gcorr5994 T3175 T4268 T3175 T4268 -6.4050773712630569e-07
Rt17594 T3175 T4274 660040517.17662156
Gcorr5995 T3175 T5246 T3175 T5246 -9.4474997027452728e-08
Rt17595 T3175 T5856 3640940.7620106358
Rt17596 T3175 T6037 700290.3268242284
Rt17597 T3176 T3469 2075595.4025832189
Rt17598 T3176 T3470 2669567.0444908561
Rt17599 T3176 T3504 6294278.4290909208
Rt17600 T3176 T3847 376411.23361894186
Gcorr5996 T3176 T4617 T3176 T4617 -1.4786290007555067e-07
Rt17601 T3176 T5164 759442.55548103619
Gcorr5997 T3176 T5425 T3176 T5425 -6.2870343097322599e-07
Rt17602 T3176 T5597 2060179.7635761499
Rt17603 T3176 T5919 2913268.6622447981
Gcorr5998 T3177 T3446 T3177 T3446 -3.2967275826276813e-08
Rt17604 T3177 T3705 399286.38524662255
Gcorr5999 T3177 T3706 T3177 T3706 -1.1008380973146269e-06
Rt17605 T3177 T3781 730681.99117388425
Rt17606 T3177 T4107 4480660.8917279113
Rt17607 T3177 T5403 176598.05163727418
Gcorr6000 T3177 T5404 T3177 T5404 -7.8130372586749208e-07
Rt17608 T3177 T5435 1769786.1552566232
Rt17609 T3177 T5965 3945112.232898742
Rt17610 T3178 T3754 2115390.2667626152
Rt17611 T3178 T3904 4357649.1820781035
Rt17612 T3178 T4062 1286395.5847096322
Rt17613 T3178 T4075 3533335.768436363
Rt17614 T3178 T4179 2094900.2755498795
Rt17615 T3178 T4183 962886.0377757859
Gcorr6001 T3178 T4310 T3178 T4310 -1.3213251331801277e-07
Rt17616 T3178 T4315 3820058.2440847885
Gcorr6002 T3178 T5257 T3178 T5257 -1.5751478546347521e-07
Rt17617 T3178 T5909 2099186.4336731886
Rt17618 T3179 T3180 4236177.0022872603
Rt17619 T3179 T3183 260794.28224506011
Rt17620 T3179 T3508 2050685.3804076286
Rt17621 T3179 T4028 5684561.071616007
Rt17622 T3179 T4839 701216.14079203922
Rt17623 T3179 T5762 8094207.3345298935
Rt17624 T3179 T6082 713042.71112155472
Gcorr6003 T3179 T6084 T3179 T6084 -1.8558959344489594e-06
Rt17625 T3180 T3181 2114340.1876175916
Rt17626 T3180 T3182 1969339.6870885405
Rt17627 T3180 T3508 2007233.3304408311
Rt17628 T3180 T4059 1505948.8027287985
Rt17629 T3180 T4818 24082641.54693725
Rt17630 T3180 T4819 20162248.434972282
Rt17631 T3180 T4924 957987.11820544058
Gcorr6004 T3180 T5830 T3180 T5830 -1.0707186971701405e-07
Rt17632 T3180 T6082 10092459.634741548
Rt17633 T3181 T3182 2069103.274397094
Rt17634 T3181 T3191 2121667.7144110617
Rt17635 T3181 T3196 3732263.8711594273
Rt17636 T3181 T3342 1477911.6188307579
Rt17637 T3181 T4102 6858594.135892815
Rt17638 T3181 T4718 16211214.418836171
Rt17639 T3181 T4818 30854418.051760409
Rt17640 T3181 T4819 1201294.9050350792
Rt17641 T3181 T4889 5200708.866455934
Gcorr6005 T3181 T4890 T3181 T4890 -1.0245785074370609e-07
Rt17642 T3182 T3191 2027842.8583551885
Rt17643 T3182 T3192 3599693.7647396885
Rt17644 T3182 T3193 1698235.3050664223
Rt17645 T3182 T4059 2824721.360780295
Gcorr6006 T3182 T4819 T3182 T4819 -1.1065403525775835e-07
Rt17646 T3182 T4890 22746384.205396984
Rt17647 T3182 T4893 11345011.91271189
Rt17648 T3182 T5830 1008522.71048532
Rt17649 T3183 T3830 1961078.2374255008
Rt17650 T3183 T3933 1346380.3188663195
Rt17651 T3183 T3934 2937782.5216002092
Rt17652 T3183 T4028 580839.39298977365
Gcorr6007 T3183 T4839 T3183 T4839 -1.7878648286607411e-06
Gcorr6008 T3183 T5336 T3183 T5336 -4.4465732844918015e-07
Gcorr6009 T3183 T5762 T3183 T5762 -1.0490486094400204e-07
Rt17653 T3183 T5763 535502.74420978862
Gcorr6010 T3183 T6082 T3183 T6082 -3.3780939952417006e-07
Rt17654 T3183 T6084 486884.62552830775
Rt17655 T3184 T3185 2173783.6794347782
Gcorr6011 T3184 T3514 T3184 T3514 -8.6563213916393362e-09
Rt17656 T3184 T3829 1596329.1934513764
Rt17657 T3184 T4146 1904086.9416985493
Rt17658 T3184 T4808 8107066.6002785144
Gcorr6012 T3184 T4836 T3184 T4836 -1.2478565613338827e-07
Rt17659 T3184 T5244 675141.04176489252
Gcorr6013 T3184 T5885 T3184 T5885 -3.9092352874397713e-08
Gcorr6014 T3185 T3640 T3185 T3640 -7.7486447553511285e-08
Rt17660 T3185 T3829 4678923.185298766
Rt17661 T3185 T4153 412746.08211023855
Rt17662 T3185 T4154 1014937.3592552161
Rt17663 T3185 T4731 3166149.0407987689
Rt17664 T3185 T4808 3245356.4010336171
Rt17665 T3185 T4836 1303792.9959115512
Gcorr6015 T3185 T6063 T3185 T6063 -5.5753113136744513e-07
Rt17666 T3186 T3187 2242786.9510762789
Rt17667 T3186 T3189 2290388.2949986942
Rt17668 T3186 T3448 4774108.9964120472
Rt17669 T3186 T3539 1616691.230945233
Rt17670 T3186 T4109 25485731.657859206
Gcorr6016 T3186 T4317 T3186 T4317 -1.4683512953765196e-07
Rt17671 T3186 T4318 6489883.3198226159
Rt17672 T3186 T4321 2515097.0348428925
Gcorr6017 T3186 T4689 T3186 T4689 -5.613375456185932e-08
Rt17673 T3186 T5746 1760776.7669102333
Rt17674 T3187 T3188 1824073.0820208902
Rt17675 T3187 T3285 5910078.6635101968
Rt17676 T3187 T3448 2008773.9320707007
Rt17677 T3187 T3449 1573723.9437108969
Gcorr6018 T3187 T4321 T3187 T4321 -1.2781808363242682e-07
Rt17678 T3187 T4323 6992628.2582618743
Rt17679 T3187 T4689 1822187.9427231322
Rt17680 T3187 T5730 2505964.689472382
Gcorr6019 T3187 T5731 T3187 T5731 -1.6230176804216003e-07
Rt17681 T3188 T3285 1795743.8636851788
Rt17682 T3188 T3336 1074714.649098563
Rt17683 T3188 T3337 3304971.9791283379
Rt17684 T3188 T3930 2870917.6394399763
Rt17685 T3188 T4949 18098867.591598138
Rt17686 T3188 T4997 7869647.1554477159
Rt17687 T3188 T5730 5389258.6650417065
Rt17688 T3188 T5731 1410219.5226496451
Gcorr6020 T3188 T5811 T3188 T5811 -1.7115525711869913e-07
Rt17689 T3189 T3539 4884149.735641594
Rt17690 T3189 T3879 4445741.045017303
Rt17691 T3189 T3904 1488091.977030921
Rt17692 T3189 T4111 1841729.6807654107
Rt17693 T3189 T4179 1117609.3747161748
Gcorr6021 T3189 T4315 T3189 T4315 -1.7586607621014491e-07
Rt17694 T3189 T4316 2996419.1749495547
Rt17695 T3189 T4317 2752264.6245154119
Rt17696 T3189 T4318 12748441.427956104
Rt17697 T3190 T3504 1878491.4510238783
Rt17698 T3190 T3534 19049193.177986044
Rt17699 T3190 T3847 1032439.0999839682
Gcorr6022 T3190 T3883 T3190 T3883 -7.9252274851975314e-09
Rt17700 T3190 T3884 780362.83227708889
Rt17701 T3190 T4384 8018607.5216270098
Gcorr6023 T3190 T4391 T3190 T4391 -3.1762677922047842e-07
Rt17702 T3190 T4621 6155653.0399320889
Gcorr6024 T3190 T5425 T3190 T5425 -2.4127521155294448e-07
Rt17703 T3190 T5705 861249.61446313164
Rt17704 T3191 T3192 6622642.8056267081
Rt17705 T3191 T3196 4396454.332908107
Gcorr6025 T3191 T3645 T3191 T3645 -8.6394294443480835e-08
Rt17706 T3191 T3838 1733223.4379225327
Rt17707 T3191 T3997 203705.13568067999
Gcorr6026 T3191 T4889 T3191 T4889 -2.0365630751785578e-08
Rt17708 T3191 T4890 479789.37176841579
Rt17709 T3191 T4891 5454846.577481865
Gcorr6027 T3191 T4892 T3191 T4892 -1.3033946638132987e-06
Gcorr6028 T3191 T4893 T3191 T4893 -1.3446948473771238e-07
Rt17710 T3192 T3193 766504.61915475025
Rt17711 T3192 T3194 1102577.1492061457
Rt17712 T3192 T3195 8128109.3042698372
Gcorr6029 T3192 T3490 T3192 T3490 -1.4062780985539526e-07
Rt17713 T3192 T3997 537814.72411343153
Gcorr6030 T3192 T4892 T3192 T4892 -4.7780177843575715e-07
Rt17714 T3192 T4893 573566.77764399129
Rt17715 T3192 T5792 2605117.6062992662
Gcorr6031 T3192 T5874 T3192 T5874 -5.9343988748399935e-07
Rt17716 T3193 T3194 637988.76607176277
Rt17717 T3193 T3206 988262.02814023884
Rt17718 T3193 T3828 1156108.4828725322
Rt17719 T3193 T4059 1399665.7145029267
Gcorr6032 T3193 T4893 T3193 T4893 -3.305045461157268e-07
Gcorr6033 T3193 T5338 T3193 T5338 -4.2726226868725177e-07
Gcorr6034 T3193 T5672 T3193 T5672 -7.4786750493073731e-07
Gcorr6035 T3193 T5830 T3193 T5830 -1.8258316055525146e-09
Gcorr6036 T3193 T5831 T3193 T5831 -1.1316753816586132e-07
Rt17720 T3193 T5874 346701.64100502018
Rt17721 T3194 T3195 1766454.0388969688
Rt17722 T3194 T3206 7434919.7384774536
Rt17723 T3194 T3223 638280.32305939111
Rt17724 T3194 T3688 4734673.9529498033
Gcorr6037 T3194 T4893 T3194 T4893 -1.5184675918002065e-07
Rt17725 T3194 T4957 22348994.330103513
Gcorr6038 T3194 T5671 T3194 T5671 -4.3771450507142669e-07
Rt17726 T3194 T5672 473832.36710980203
Rt17727 T3194 T5792 4860446.9335473934
Gcorr6039 T3194 T5874 T3194 T5874 -5.4516012263083505e-07
Rt17728 T3195 T3223 4558675.0623428375
Rt17729 T3195 T3225 5784957.0905107986
Rt17730 T3195 T3489 1809438.8721876109
Rt17731 T3195 T3490 1428094.5299025243
Gcorr6040 T3195 T4895 T3195 T4895 -6.3856161219285118e-08
Rt17732 T3195 T4957 1408033.7160012347
Rt17733 T3195 T5792 3166945.7510652542
Rt17734 T3196 T3342 1882806.7381437018
Rt17735 T3196 T3631 4443915.6082102731
Rt17736 T3196 T3646 3005781.4869628749
Rt17737 T3196 T3838 1051401.4534269515
Rt17738 T3196 T4132 7334323.4457284138
Rt17739 T3196 T4889 1520895.5306716505
Rt17740 T3196 T5142 59283488.630777128
Gcorr6041 T3196 T5232 T3196 T5232 -1.0276759083563325e-08
Rt17741 T3197 T3524 787031.9138946496
Rt17742 T3197 T3526 1759092.1787286673
Rt17743 T3197 T3831 1412134.2635768256
Rt17744 T3197 T3976 2159730.7894337908
Gcorr6042 T3197 T4463 T3197 T4463 -4.7338383040441487e-07
Rt17745 T3197 T4604 1323785.1836233493
Gcorr6043 T3197 T4664 T3197 T4664 -1.2110044434859145e-07
Rt17746 T3197 T4684 4758293.0850340705
Rt17747 T3197 T5680 8866397.3139568232
Rt17748 T3198 T3455 969090.71209924866
Rt17749 T3198 T3456 810759.89903333399
Rt17750 T3198 T4045 2525451.9027964757
Rt17751 T3198 T4046 1596553.9726164921
Gcorr6044 T3198 T5049 T3198 T5049 -5.1993564426596656e-07
Rt17752 T3198 T5278 6145221.6684555635
Gcorr6045 T3198 T5298 T3198 T5298 -8.7777136994942588e-07
Gcorr6046 T3198 T5576 T3198 T5576 -2.1699565686017831e-07
Rt17753 T3198 T5892 348351.08707581955
Gcorr6047 T3198 T5974 T3198 T5974 -1.7278738118540773e-07
Rt17754 T3199 T3431 15209988.345813021
Rt17755 T3199 T3556 1935142.1174275819
Rt17756 T3199 T4064 1049226.953829698
Rt17757 T3199 T4088 924768.66818672069
Rt17758 T3199 T4746 15046621.439388234
Rt17759 T3199 T5303 2303399.2652114336
Rt17760 T3199 T5314 7398269.777663568
Gcorr6048 T3199 T5567 T3199 T5567 -1.5182453182630347e-07
Rt17761 T3200 T3327 8917522.798185531
Rt17762 T3200 T3356 2141382.4767889641
Rt17763 T3200 T3468 2971273.6351386574
Rt17764 T3200 T3903 495559.5410985371
Gcorr6049 T3200 T5034 T3200 T5034 -2.8732738948944784e-08
Gcorr6050 T3200 T5588 T3200 T5588 -6.7499347567388283e-07
Rt17765 T3200 T5589 2743003.6134159332
Rt17766 T3200 T5677 1045064.4098287658
Rt17767 T3200 T5988 11003948.167909989
Rt17768 T3201 T3326 2687543.189618194
Rt17769 T3201 T3357 2230574.222029842
Rt17770 T3201 T3488 1460938.7874391112
Rt17771 T3201 T3902 2092403.3152853218
Gcorr6051 T3201 T4941 T3201 T4941 -1.0901553614943089e-07
Rt17772 T3201 T4991 791256.94939278229
Rt17773 T3201 T5123 2835113.8062470322
Gcorr6052 T3201 T5124 T3201 T5124 -3.7763316845956997e-08
Gcorr6053 T3201 T5833 T3201 T5833 -7.6009083335428956e-07
Rt17774 T3202 T3358 2090944.419902676
Rt17775 T3202 T3400 4661239.094310876
Rt17776 T3202 T3624 38921608.156481974
Rt17777 T3202 T3793 1302545.209708371
Rt17778 T3202 T4550 2243792.8235367737
Rt17779 T3202 T4744 3577031.0258728047
Gcorr6054 T3202 T5610 T3202 T5610 -1.2340649181302227e-07
Rt17780 T3202 T5911 2906755.8316397439
Rt17781 T3203 T3505 4149484.5927155921
Rt17782 T3203 T3521 4588352.8411735361
Rt17783 T3203 T3790 337876.92092998652
Gcorr6055 T3203 T5022 T3203 T5022 -7.3102904147409479e-07
Rt17784 T3203 T5165 2013153.1776255025
Rt17785 T3203 T5209 890146.63551392336
Gcorr6056 T3203 T5225 T3203 T5225 -5.449678377645058e-08
Rt17786 T3204 T3425 5336728.052147055
Rt17787 T3204 T3594 634584.06641393842
Rt17788 T3204 T3655 12466622.468092643
Rt17789 T3204 T3811 1172658.2166031376
Gcorr6057 T3204 T4642 T3204 T4642 -5.0183438563904487e-07
Rt17790 T3204 T4724 3033578.0352651961
Rt17791 T3204 T5637 2017039.9709514626
Rt17792 T3204 T6040 3303604.728169967
Rt17793 T3205 T3426 4615492.6052394686
Rt17794 T3205 T3442 7011036.4500131095
Rt17795 T3205 T3718 2776707.1358421161
Rt17796 T3205 T3890 1298509.0774573893
Rt17797 T3205 T4073 731107.00820222683
Rt17798 T3205 T4303 32069895.221084535
Rt17799 T3205 T5208 6791889.8627657127
Gcorr6058 T3205 T5760 T3205 T5760 -2.5510486814026985e-07
Rt17800 T3205 T6017 1199187.5798206362
Rt17801 T3206 T3688 1724358.5323757257
Gcorr6059 T3206 T3828 T3206 T3828 -1.8912823200208372e-07
Rt17802 T3206 T4121 7607487.1614066334
Rt17803 T3206 T4122 1849184.9476763348
Rt17804 T3206 T5338 1284234.4746518317
Rt17805 T3206 T5672 1583015.4933891208
Rt17806 T3206 T5789 2056598.4426229754
Gcorr6060 T3206 T5874 T3206 T5874 -2.600024829878634e-07
Rt17807 T3207 T3422 2380255.3041855134
Rt17808 T3207 T3433 1985316.2466216602
Rt17809 T3207 T3692 392363.95581713459
Gcorr6061 T3207 T4995 T3207 T4995 -7.0000951499137992e-07
Rt17810 T3207 T5133 423699.92344227154
Gcorr6062 T3207 T5207 T3207 T5207 -5.15354633106575e-07
Gcorr6063 T3207 T5380 T3207 T5380 -1.307295638179284e-07
Rt17811 T3207 T5436 9247716.9649915546
Gcorr6064 T3207 T6020 T3207 T6020 -1.8509214748478234e-07
Rt17812 T3208 T3430 3933577.9198075575
Rt17813 T3208 T3837 962146.29565717012
Gcorr6065 T3208 T3979 T3208 T3979 -9.1678304537477239e-08
Rt17814 T3208 T5162 593323.35275827255
Rt17815 T3208 T5803 711823.86535459768
Rt17816 T3208 T5804 1649104.1023739011
Gcorr6066 T3208 T6007 T3208 T6007 -3.8101626485238424e-07
Rt17817 T3209 T3210 786419.73020135635
Rt17818 T3209 T3734 7552000.8387648761
Rt17819 T3209 T3735 1759118.1944686987
Rt17820 T3209 T3840 2571922.1304688333
Rt17821 T3209 T4614 2150292.1565608396
Rt17822 T3209 T4755 3020450.8370730123
Rt17823 T3209 T5580 908260.09542172332
Gcorr6067 T3209 T5979 T3209 T5979 -8.6092325777833348e-08
Gcorr6068 T3209 T6055 T3209 T6055 -4.4152941152715121e-07
Rt17824 T3210 T3284 8550172.3002962898
Rt17825 T3210 T3501 1431309.4970222705
Rt17826 T3210 T3502 653668.69464657176
Rt17827 T3210 T3734 842809.86528398679
Gcorr6069 T3210 T4460 T3210 T4460 -1.3939931839108856e-07
Gcorr6070 T3210 T4462 T3210 T4462 -7.1975161951079244e-07
Gcorr6071 T3210 T4614 T3210 T4614 -3.7502907599415587e-07
Gcorr6072 T3210 T5580 T3210 T5580 -3.0134069444301951e-07
Rt17828 T3210 T5699 2464201.7970877583
Rt17829 T3210 T6055 483542.07378867804
Rt17830 T3211 T3212 872133.35861351527
Rt17831 T3211 T3443 4558085.1428915784
Rt17832 T3211 T3605 1804182.3903276501
Rt17833 T3211 T4048 1920137.2349968699
Gcorr6073 T3211 T4474 T3211 T4474 -4.4390881970449997e-07
Rt17834 T3211 T4475 1707506.1574601007
Rt17835 T3211 T4476 1995377.3576906817
Rt17836 T3211 T4477 4778320.1013214123
Rt17837 T3212 T3213 2449512.7944182539
Rt17838 T3212 T3443 1400879.4667170083
Rt17839 T3212 T3719 587575.37282863236
Rt17840 T3212 T3834 1058673.6544591968
Gcorr6074 T3212 T4334 T3212 T4334 -2.0510155722270607e-07
Rt17841 T3212 T4473 11163279.346303418
Rt17842 T3212 T4474 563480.05500844179
Gcorr6075 T3212 T4475 T3212 T4475 -1.2531653764700651e-07
Gcorr6076 T3212 T4476 T3212 T4476 -4.840604098450653e-07
Gcorr6077 T3212 T5264 T3212 T5264 -3.612321217661219e-07
Rt17843 T3213 T3719 4279288.8685381282
Rt17844 T3213 T3733 1784045.892409899
Rt17845 T3213 T4187 3886066.8754511545
Rt17846 T3213 T4188 1064098.9924431923
Rt17847 T3213 T4332 9123613.7906740606
Rt17848 T3213 T4334 7796367.0217951555
Rt17849 T3213 T4473 3422160.0174750295
Rt17850 T3214 T3732 6358999.413260797
Rt17851 T3214 T3927 1018209.0061630793
Rt17852 T3214 T4047 2728000.7396438676
Rt17853 T3214 T4187 957089.28692354856
Rt17854 T3214 T4188 1181737.0600323989
Rt17855 T3214 T4306 4957712.5373987388
Rt17856 T3214 T4331 4927107.1221999489
Gcorr6078 T3214 T4332 T3214 T4332 -4.8983283255363007e-08
Rt17857 T3215 T3661 1548659.3007179259
Rt17858 T3215 T3895 3380944.9166046111
Rt17859 T3215 T4095 996625.42601639102
Gcorr6079 T3215 T4797 T3215 T4797 -1.1947289858607173e-07
Gcorr6080 T3215 T4798 T3215 T4798 -6.2632671701602901e-07
Rt17860 T3215 T4799 906593.56267289398
Rt17861 T3215 T5148 15148869.258357532
Rt17862 T3216 T3660 1665675.9423871629
Rt17863 T3216 T3861 4948683.9325373666
Rt17864 T3216 T4051 3390084.8861114671
Rt17865 T3216 T4171 1169835.7554456466
Rt17866 T3216 T4409 9313630.7625951413
Gcorr6081 T3216 T4410 T3216 T4410 -3.375412194404794e-08
Rt17867 T3216 T4425 3524274.5975385979
Rt17868 T3217 T3218 4901411.4140798971
Gcorr6082 T3217 T3580 T3217 T3580 -1.911882763717687e-08
Rt17869 T3217 T3665 1314078.4407766622
Rt17870 T3217 T3991 952573.92413825891
Rt17871 T3217 T4804 2474085.6079659201
Rt17872 T3217 T4805 28220825.954862967
Rt17873 T3217 T4859 4821359.5341004841
Rt17874 T3218 T3578 1572321.4515016228
Rt17875 T3218 T3583 795261.1436525801
Rt17876 T3218 T3584 4951214.7399772136
Rt17877 T3218 T3665 2397496.7823385173
Rt17878 T3218 T4859 2527898.438497752
Rt17879 T3218 T4860 1956476.8133169841
Gcorr6083 T3218 T4963 T3218 T4963 -5.0576559000253093e-07
Gcorr6084 T3218 T5111 T3218 T5111 -1.4433327072399654e-07
Rt17880 T3218 T5834 1985606.6999850834
Rt17881 T3219 T3565 2151818.2721600845
Rt17882 T3219 T3703 15321943.679594776
Gcorr6085 T3219 T3956 T3219 T3956 -4.3068452113036524e-08
Rt17883 T3219 T4013 727954.02550017647
Rt17884 T3219 T4061 981980.44191684015
Gcorr6086 T3219 T4682 T3219 T4682 -2.2338042019850362e-07
Rt17885 T3219 T5319 38835290.568183877
Gcorr6087 T3219 T5532 T3219 T5532 -1.618658146885783e-07
Rt17886 T3219 T5664 1103306.0357842173
Rt17887 T3219 T6021 8768822.3999355454
Rt17888 T3220 T3803 1400529.076090957
Rt17889 T3220 T3935 3663964.672775927
Rt17890 T3220 T3956 4363723.31387222
Rt17891 T3220 T4193 821249.57602143462
Gcorr6088 T3220 T4671 T3220 T4671 -1.6492044575403251e-07
Rt17892 T3220 T4673 7528257.5749839889
Rt17893 T3220 T5719 1868787.9855889985
Gcorr6089 T3220 T5795 T3220 T5795 -1.5627033309256471e-07
Rt17894 T3221 T3222 1956396.0727685806
Gcorr6090 T3221 T3532 T3221 T3532 -1.6216961486881211e-08
Rt17895 T3221 T3780 1560587.1746327183
Rt17896 T3221 T3936 939185.95462792052
Gcorr6091 T3221 T4946 T3221 T4946 -1.528296072014711e-07
Rt17897 T3221 T5004 4091931.0852405122
Rt17898 T3221 T5005 4480309.7693722742
Rt17899 T3221 T5182 2627288.0865079854
Rt17900 T3222 T3464 2223109.3190601519
Rt17901 T3222 T3465 690411303.39538789
Rt17902 T3222 T3466 1996927.6922270535
Rt17903 T3222 T3780 21986785.072686594
Rt17904 T3222 T4045 1312728.9909059193
Gcorr6092 T3222 T4945 T3222 T4945 -1.6628627095048464e-07
Rt17905 T3222 T4946 3491025.1367506017
Rt17906 T3222 T5005 4405928.2025967417
Rt17907 T3222 T5676 1510555.4606597144
Gcorr6093 T3222 T5974 T3222 T5974 -1.0824338111055922e-07
Rt17908 T3223 T3225 1308195.3847940129
Rt17909 T3223 T3487 8078321.132699457
Rt17910 T3223 T3688 472672.67470416258
Rt17911 T3223 T3948 460821.75812015514
Gcorr6094 T3223 T4274 T3223 T4274 -2.0731953970004984e-07
Gcorr6095 T3223 T4957 T3223 T4957 -8.0797304105771012e-08
Gcorr6096 T3223 T5624 T3223 T5624 -4.0935301777322121e-07
Rt17912 T3223 T5671 359090.86769142334
Gcorr6097 T3223 T5672 T3223 T5672 -4.8684147676082431e-07
Gcorr6098 T3223 T5958 T3223 T5958 -4.5582068242263021e-07
Rt17913 T3224 T3922 656487.27423578047
Rt17914 T3224 T3931 1339613.1068146441
Gcorr6099 T3224 T3977 T3224 T3977 -9.3210957557209047e-08
Rt17915 T3224 T4094 1031232.1951405655
Rt17916 T3224 T4624 152468915.78696266
Rt17917 T3224 T4785 556781.59726049763
Rt17918 T3224 T4787 19541986.073184393
Rt17919 T3224 T5064 2784788.7828897731
Gcorr6100 T3224 T5807 T3224 T5807 -1.4828826780216135e-07
Rt17920 T3225 T3489 2396761.4015042023
Rt17921 T3225 T3497 2986876.9552045348
Rt17922 T3225 T3555 2434133.6554753212
Rt17923 T3225 T3751 632996.541598476
Rt17924 T3225 T3948 10608608.032273564
Gcorr6101 T3225 T4901 T3225 T4901 -1.4123452598666326e-07
Gcorr6102 T3225 T4903 T3225 T4903 -2.8500795168900562e-07
Rt17925 T3225 T4957 4719784.6077035926
Rt17926 T3225 T5638 27307013.672326561
Rt17927 T3225 T5670 1009700.6854264409
Gcorr6103 T3225 T5671 T3225 T5671 -1.7429564552854152e-07
Rt17928 T3225 T5958 4606464.2856012871
Rt17929 T3226 T3227 2001457.0007215731
Rt17930 T3226 T3231 7691335.6040528193
Rt17931 T3226 T3609 3885979.5412340728
Rt17932 T3226 T3626 1760091.4727439224
Rt17933 T3226 T4023 3590061.8246174166
Gcorr6104 T3226 T4479 T3226 T4479 -4.3944373667570256e-07
Rt17934 T3226 T4480 1828661.2120085242
Rt17935 T3226 T4481 1700690.6439684059
Rt17936 T3226 T5243 3420020.0766346399
Gcorr6105 T3226 T6066 T3226 T6066 -1.2400484776470169e-07
Rt17937 T3227 T3228 4361683.7063896833
Rt17938 T3227 T3447 5515728.8988495395
Rt17939 T3227 T3566 1760961.3584302654
Rt17940 T3227 T3609 2654034.8806042154
Gcorr6106 T3227 T4481 T3227 T4481 -1.3802115683958051e-07
Rt17941 T3227 T5126 1821728.9295797329
Rt17942 T3227 T6066 3206421.5879621562
Rt17943 T3228 T3447 1917901.3952414128
Rt17944 T3228 T3472 3869202.0819111657
Rt17945 T3228 T3581 7354167.529513753
Rt17946 T3228 T3841 1554184.6509355665
Rt17947 T3228 T4825 3041693.2020247811
Rt17948 T3228 T5126 6019664.2573199514
Rt17949 T3228 T5304 3396765.5963849332
Rt17950 T3229 T3230 12713168.701785684
Rt17951 T3229 T3581 1852968.9836632779
Rt17952 T3229 T3841 1575093.3948454906
Gcorr6107 T3229 T4955 T3229 T4955 -2.0324271352659568e-07
Rt17953 T3229 T5009 1389995.3167162
Rt17954 T3229 T5060 1936652.4136308779
Rt17955 T3229 T5061 3332135.0866180463
Rt17956 T3229 T6048 3948664.9128073147
Rt17957 T3230 T3324 7384212.7039774591
Gcorr6108 T3230 T3472 T3230 T3472 -7.090577717581958e-08
Rt17958 T3230 T3503 1530656.4430157479
Rt17959 T3230 T3841 1864720.3083549195
Rt17960 T3230 T3937 1035635.5188433778
Gcorr6109 T3230 T5059 T3230 T5059 -2.1324484852348688e-07
Rt17961 T3230 T5323 2001819.3955780526
Rt17962 T3230 T5578 2748847.0051201009
Rt17963 T3230 T6048 2977860.5880631991
Rt17964 T3231 T3605 4098537.3851186098
Rt17965 T3231 T3626 1910880.2601511835
Rt17966 T3231 T3875 1398010.4598542161
Rt17967 T3231 T4048 2783017.7263989644
Rt17968 T3231 T4148 4200782.4350382285
Rt17969 T3231 T4478 2355947.4450307507
Gcorr6110 T3231 T4479 T3231 T4479 -2.0067487265746274e-07
Rt17970 T3231 T4480 2315516.0763403252
Rt17971 T3231 T4482 251563276.52399978
Rt17972 T3232 T3542 1864396.7904508126
Rt17973 T3232 T3623 1033952.2121625629
Rt17974 T3232 T3667 5309632.102653753
Rt17975 T3232 T4069 1596623.6929556581
Rt17976 T3232 T4788 25214790.621132348
Gcorr6111 T3232 T4936 T3232 T4936 -1.3096022806196815e-07
Rt17977 T3232 T5254 1185432.8780826905
Gcorr6112 T3232 T5373 T3232 T5373 -2.2945538904415482e-07
Rt17978 T3233 T3438 1923324.3692206619
Rt17979 T3233 T3473 9856446.8170634098
Rt17980 T3233 T3578 6636930.8669306524
Rt17981 T3233 T4104 262450.37083447457
Rt17982 T3233 T5111 3279666.7493339223
Rt17983 T3233 T5213 588790.84237629233
Gcorr6113 T3233 T5870 T3233 T5870 -8.22269588902147e-07
Gcorr6114 T3233 T5949 T3233 T5949 -1.8237240820576846e-08
Rt17984 T3234 T3467 1501303.2017253467
Rt17985 T3234 T3557 1771051.8944669885
Rt17986 T3234 T3675 6370187.736135575
Rt17987 T3234 T3872 446510.45848714444
Rt17988 T3234 T4650 3775456.2184678037
Gcorr6115 T3234 T4651 T3234 T4651 -6.2386460771552199e-07
Rt17989 T3234 T4725 908996.47261520708
Gcorr6116 T3234 T4933 T3234 T4933 -1.537457859941812e-07
Rt17990 T3235 T3758 2661614.655117312
Rt17991 T3235 T3980 483910.77255811304
Rt17992 T3235 T4162 250849.45742259955
Gcorr6117 T3235 T4809 T3235 T4809 -1.0846222519535917e-06
Rt17993 T3235 T4872 2008445.8070032385
Rt17994 T3235 T4873 684021.60690657678
Gcorr6118 T3235 T4993 T3235 T4993 -4.134709181398542e-07
Rt17995 T3236 T3758 1487421.8253807751
Gcorr6119 T3236 T3877 T3236 T3877 -1.4131038948329553e-08
Rt17996 T3236 T3929 827959.38685755711
Rt17997 T3236 T4154 1701226.3457589669
Rt17998 T3236 T4162 816226.94888897648
Rt17999 T3236 T4732 1528124.293753752
Rt18000 T3236 T4872 96445031.517718375
Gcorr6120 T3236 T5234 T3236 T5234 -1.5832503621880233e-07
Rt18001 T3237 T3238 1841032.2093833028
Rt18002 T3237 T3239 3332657.0987981907
Rt18003 T3237 T3724 627989.74567947048
Rt18004 T3237 T4594 3696899.3221704904
Gcorr6121 T3237 T4599 T3237 T4599 -4.3016365835879671e-07
Rt18005 T3237 T4600 1950165.9949122109
Rt18006 T3237 T5526 20631025.853957102
Rt18007 T3238 T3239 1716289.3895907903
Rt18008 T3238 T3240 1392896.4841731344
Rt18009 T3238 T3241 4281594.5062027536
Rt18010 T3238 T3622 1161592.3543429479
Rt18011 T3238 T4600 14849577.854220184
Gcorr6122 T3238 T4626 T3238 T4626 -1.2812066202336872e-07
Rt18012 T3238 T4845 1380429.7001471876
Rt18013 T3238 T5526 24194587.150395911
Gcorr6123 T3238 T5869 T3238 T5869 -2.3040067454985994e-07
Rt18014 T3239 T3240 3389856.8067804435
Rt18015 T3239 T3244 1859845.6826675797
Rt18016 T3239 T3360 4066754.0085004191
Rt18017 T3239 T3724 2409665.3629610827
Rt18018 T3239 T4600 7979589.4864148609
Rt18019 T3239 T4625 4763244.0337829925
Rt18020 T3239 T4626 4717478.0952601489
Rt18021 T3240 T3241 1862535.4921977266
Rt18022 T3240 T3242 6293374.0719626518
Rt18023 T3240 T3244 2013399.3094767663
Rt18024 T3240 T4072 1182674.9277396097
Rt18025 T3240 T4626 2573640.0718149045
Gcorr6124 T3240 T4737 T3240 T4737 -1.5883998868567618e-07
Gcorr6125 T3240 T4845 T3240 T4845 -1.1595378185630296e-07
Rt18026 T3240 T5854 2237843.6968713226
Rt18027 T3241 T3242 1538161.3454466239
Rt18028 T3241 T3243 12558027.66775623
Rt18029 T3241 T3622 737634.33044689335
Rt18030 T3241 T4099 2154621.5636298531
Rt18031 T3241 T4845 2945972.269862439
Rt18032 T3241 T5407 1671224.8273481962
Rt18033 T3241 T5854 20196094.822153661
Gcorr6126 T3241 T5869 T3241 T5869 -3.9065328724413118e-07
Rt18034 T3242 T3243 1654771.5150273889
Rt18035 T3242 T3245 5247819.3422476714
Rt18036 T3242 T3246 2451742.3664495046
Rt18037 T3242 T4072 973602.11347971158
Gcorr6127 T3242 T4737 T3242 T4737 -8.1131703961661727e-08
Gcorr6128 T3242 T5407 T3242 T5407 -1.5383427171598978e-07
Rt18038 T3242 T5409 1678251.586071674
Rt18039 T3242 T5854 2095158.8873219695
Rt18040 T3243 T3245 1644649.0541787941
Rt18041 T3243 T3247 8186262.1779495431
Rt18042 T3243 T3248 1948955.1519322733
Rt18043 T3243 T4099 1076668.0077849785
Rt18044 T3243 T5052 1459311.0641409019
Gcorr6129 T3243 T5406 T3243 T5406 -1.8116341685264056e-07
Rt18045 T3243 T5407 2347897.1698084255
Rt18046 T3243 T5409 18354386.210590109
Rt18047 T3244 T3360 1583589.2934346683
Rt18048 T3244 T3361 3816312.4943634057
Rt18049 T3244 T3970 659766.60339692002
Rt18050 T3244 T4072 2424473.3673560596
Gcorr6130 T3244 T4625 T3244 T4625 -1.4621317821091297e-07
Rt18051 T3244 T4626 8555348.9744150117
Rt18052 T3244 T4712 969809.89710195933
Rt18053 T3244 T4737 4708070.4962122254
Gcorr6131 T3244 T6032 T3244 T6032 -5.733489445838008e-07
Rt18054 T3245 T3246 1734121.4382615504
Rt18055 T3245 T3247 2054588.4100918372
Rt18056 T3245 T3251 2364763.9911030624
Rt18057 T3245 T4000 5879499.2552594319
Gcorr6132 T3245 T5052 T3245 T5052 -1.1521483822381709e-07
Rt18058 T3245 T5053 1806220.9508222013
Rt18059 T3245 T5409 1370317.0408700381
Rt18060 T3245 T5410 11786632.240024298
Rt18061 T3246 T3251 10105117.622710444
Gcorr6133 T3246 T3370 T3246 T3370 -2.1704869218571798e-07
Gcorr6134 T3246 T3970 T3246 T3970 -1.5276565930948677e-07
Rt18062 T3246 T4072 936861.76247526205
Rt18063 T3246 T4166 555174.38100522838
Gcorr6135 T3246 T4737 T3246 T4737 -2.3464976328103726e-07
Rt18064 T3246 T5409 6720032.7932482492
Rt18065 T3246 T5410 1277902.399390663
Rt18066 T3246 T5816 1547282.2333324743
Rt18067 T3247 T3248 276960.8934841486
Rt18068 T3247 T3249 9919316.337864615
Rt18069 T3247 T3973 1985521.7877196677
Rt18070 T3247 T4000 5914370.2828281075
Gcorr6136 T3247 T4740 T3247 T4740 -1.5853886239724766e-06
Rt18071 T3247 T4990 523909.02928300557
Rt18072 T3247 T5052 1547561.3488590245
Rt18073 T3247 T5053 2838512.3585678949
Rt18074 T3248 T3249 1728745.3282712693
Rt18075 T3248 T3250 2722414.1254290226
Rt18076 T3248 T3328 1793362.9669372388
Rt18077 T3248 T3331 2888191.6757833324
Gcorr6137 T3248 T4099 T3248 T4099 -1.6187076782278643e-07
Gcorr6138 T3248 T4738 T3248 T4738 -1.4216969901641076e-07
Rt18078 T3248 T4740 417467.63663091173
Gcorr6139 T3248 T4990 T3248 T4990 -1.592651536688999e-06
Rt18079 T3248 T5052 11584287.71084865
Rt18080 T3248 T5406 1745604.8732745717
Rt18081 T3249 T3250 2244459.2446127264
Rt18082 T3249 T3252 6899675.9842603235
Rt18083 T3249 T3254 1568860.2186838777
Rt18084 T3249 T3973 2013626.2738816999
Rt18085 T3249 T4740 9145377.3799493425
Rt18086 T3249 T4989 1299716.849275026
Rt18087 T3249 T4990 1405426.0648180733
Gcorr6140 T3249 T5309 T3249 T5309 -1.9369355308050893e-07
Rt18088 T3250 T3252 1683002.6074838305
Rt18089 T3250 T3253 1579337.7004229489
Rt18090 T3250 T3328 6271502.719324192
Rt18091 T3250 T3329 1077595.3385387454
Rt18092 T3250 T4738 5976599.2310340293
Rt18093 T3250 T4739 715844.93133003754
Rt18094 T3250 T4740 3873250.2148901676
Gcorr6141 T3250 T4989 T3250 T4989 -9.8616640639960689e-08
Gcorr6142 T3250 T5955 T3250 T5955 -4.786800810405314e-07
Rt18095 T3251 T3370 1725134.84307147
Rt18096 T3251 T3705 2185563.7741596797
Gcorr6143 T3251 T3706 T3251 T3706 -3.8201257256915704e-07
Rt18097 T3251 T4000 620483.50458981877
Rt18098 T3251 T5053 61189928.372062109
Rt18099 T3251 T5404 1368705.5429850507
Rt18100 T3251 T5410 793375.6734790362
Gcorr6144 T3251 T5891 T3251 T5891 -4.1458664562742644e-08
Rt18101 T3252 T3253 2315456.5882756608
Rt18102 T3252 T3254 1951640.9005036692
Rt18103 T3252 T3436 1990497.4983701345
Gcorr6145 T3252 T3987 T3252 T3987 -1.0030333330323032e-07
Gcorr6146 T3252 T4739 T3252 T4739 -6.6629316446626248e-08
Rt18104 T3252 T4989 1107683.9055136929
Rt18105 T3252 T5310 2923600.806611313
Rt18106 T3252 T5758 2318318.4659452518
Rt18107 T3253 T3329 12318808.103422733
Rt18108 T3253 T3330 2094158.3844001691
Rt18109 T3253 T3436 2059243.2050814664
Rt18110 T3253 T3839 2945870.9391358714
Gcorr6147 T3253 T4739 T3253 T4739 -2.0308046636215903e-07
Rt18111 T3253 T5017 3845028.2972012646
Rt18112 T3253 T5758 3877832.3504649526
Rt18113 T3253 T5955 1064438.9601781818
Gcorr6148 T3254 T3496 T3254 T3496 -2.5447439612330803e-07
Rt18114 T3254 T3973 3582900.7899446758
Rt18115 T3254 T3986 2141428.5921637239
Rt18116 T3254 T3987 1509177.9724069964
Gcorr6149 T3254 T4989 T3254 T4989 -1.9738539236079528e-09
Rt18117 T3254 T5309 647202.63465643756
Rt18118 T3254 T5310 3159028.5954551715
Rt18119 T3254 T5714 4780223.7709958851
Rt18120 T3255 T3256 3716271.1110338601
Rt18121 T3255 T3699 1932765.6646835664
Rt18122 T3255 T3797 2495737.5662354529
Rt18123 T3255 T4656 14385842.478821848
Rt18124 T3255 T4657 6512527.2950487314
Rt18125 T3255 T4658 6552522.4561734535
Rt18126 T3256 T3257 3488054.8916588118
Rt18127 T3256 T3258 1870272.1385049324
Rt18128 T3256 T3260 4291627.3112639822
Rt18129 T3256 T3699 760549.94069927931
Rt18130 T3256 T4657 2418761.6981643219
Rt18131 T3256 T4659 11291016.110812986
Rt18132 T3256 T4687 2640408.7436122727
Gcorr6150 T3256 T5632 T3256 T5632 -4.1217883095635062e-07
Rt18133 T3257 T3258 1235585.3009272313
Rt18134 T3257 T3259 747831.27278676291
Rt18135 T3257 T3352 2221816.8777278718
Rt18136 T3257 T3587 1701935.4766170997
Gcorr6151 T3257 T4655 T3257 T4655 -2.0910325171120351e-07
Rt18137 T3257 T4659 865794.76516242884
Gcorr6152 T3257 T4688 T3257 T4688 -4.3724933058775191e-07
Gcorr6153 T3257 T5010 T3257 T5010 -1.5649835122192325e-07
Rt18138 T3257 T5720 8500301.3063938934
Rt18139 T3258 T3259 4024007.4718143446
Rt18140 T3258 T3260 1823324.3757345984
Rt18141 T3258 T3261 1276795.4459600206
Rt18142 T3258 T3965 3334974.3822746566
Gcorr6154 T3258 T4659 T3258 T4659 -1.3997736023198972e-07
Rt18143 T3258 T4687 6661324.0242416719
Rt18144 T3258 T4688 1470088.072889189
Gcorr6155 T3258 T4752 T3258 T4752 -1.9936008831564554e-07
Rt18145 T3259 T3352 3853916.1903885123
Rt18146 T3259 T3354 1790160.644771175
Rt18147 T3259 T3965 1756121.3198047769
Rt18148 T3259 T3966 4129490.4434717763
Gcorr6156 T3259 T4659 T3259 T4659 -4.3103896667687989e-07
Rt18149 T3259 T4688 2946245.2920053201
Rt18150 T3259 T5010 2166552.9956052341
Rt18151 T3259 T5941 6986987.6422525411
Rt18152 T3260 T3261 3095823.719572382
Rt18153 T3260 T3262 2451256.7130044498
Rt18154 T3260 T3699 1474446.9373812694
Rt18155 T3260 T4081 1225914.4039815359
Rt18156 T3260 T4687 2459178.2215148113
Rt18157 T3260 T4752 10298892.477860456
Rt18158 T3260 T4767 6833804.7569110719
Gcorr6157 T3260 T5632 T3260 T5632 -1.5521769654277698e-07
Rt18159 T3261 T3262 1087084.8684803445
Rt18160 T3261 T3263 742638.87351933599
Rt18161 T3261 T3264 2943230.0740670734
Rt18162 T3261 T3965 606605.59962503426
Gcorr6158 T3261 T4688 T3261 T4688 -4.4161952429338704e-07
Rt18163 T3261 T4752 515336.58627742145
Gcorr6159 T3261 T4753 T3261 T4753 -8.6102071097128903e-08
Gcorr6160 T3261 T4868 T3261 T4868 -2.7395973944461464e-07
Gcorr6161 T3261 T6072 T3261 T6072 -4.6469850048425708e-07
Rt18164 T3262 T3263 3431636.246335472
Rt18165 T3262 T3267 2055214.0471106179
Rt18166 T3262 T4081 10023858.403392715
Rt18167 T3262 T4144 585556.93528370489
Gcorr6162 T3262 T4752 T3262 T4752 -3.0112437089695147e-07
Rt18168 T3262 T4767 36761870.924687289
Gcorr6163 T3262 T5669 T3262 T5669 -2.6468050740624272e-07
Rt18169 T3262 T6072 832735.4828854081
Rt18170 T3263 T3264 3834323.0382033181
Rt18171 T3263 T3265 5404242.4524278985
Rt18172 T3263 T3267 617837.92311598617
Rt18173 T3263 T4003 1092556.5237601649
Gcorr6164 T3263 T4752 T3263 T4752 -4.5520434734411703e-07
Rt18174 T3263 T4868 558759.38988229062
Gcorr6165 T3263 T5210 T3263 T5210 -4.8074050882650404e-07
Rt18175 T3263 T6072 6897022.7557965433
Rt18176 T3264 T3265 2332044.2439743727
Rt18177 T3264 T3266 2396055.5921577867
Rt18178 T3264 T3275 1714407.618754281
Rt18179 T3264 T3965 3076659.6460716426
Rt18180 T3264 T3966 31266861.671126537
Rt18181 T3264 T4753 1285490.6388745278
Rt18182 T3264 T4868 6135189.4069299046
Rt18183 T3264 T4869 2314680.9902840373
Gcorr6166 T3264 T5735 T3264 T5735 -1.2501654384638319e-07
Rt18184 T3265 T3266 2424833.086767246
Rt18185 T3265 T3282 1198845.3565749864
Gcorr6167 T3265 T3325 T3265 T3325 -7.7088265641025088e-08
Rt18186 T3265 T4003 1527274.6816821683
Rt18187 T3265 T4868 8043664.4718305701
Rt18188 T3265 T4869 1968517.2963093712
Rt18189 T3265 T5023 971589.73798068392
Gcorr6168 T3265 T5065 T3265 T5065 -1.2877908814042268e-07
Rt18190 T3266 T3275 14448013.972231628
Rt18191 T3266 T3276 1822895.1768196274
Rt18192 T3266 T3282 6812985.7241913211
Rt18193 T3266 T4128 1683955.1160579827
Rt18194 T3266 T4869 3589932.5394162703
Rt18195 T3266 T5065 1948419.7464201769
Gcorr6169 T3266 T5265 T3266 T5265 -5.1212833605181807e-08
Rt18196 T3266 T5735 1134602.8837725157
Rt18197 T3267 T3268 2366673.9303729683
Rt18198 T3267 T3269 5553082.6264921315
Rt18199 T3267 T3681 2957964.1654619221
Rt18200 T3267 T4003 4912954.6976358779
Gcorr6170 T3267 T4144 T3267 T4144 -8.5920969484638344e-08
Gcorr6171 T3267 T4868 T3267 T4868 -5.0958440902490832e-07
Rt18201 T3267 T5210 1090773.5980401465
Rt18202 T3267 T5669 3181823.3239368307
Rt18203 T3267 T6001 3061862.2289393679
Rt18204 T3267 T6072 6640160.1547926869
Rt18205 T3268 T3269 2067402.5485623835
Rt18206 T3268 T3270 7895286.4564574137
Rt18207 T3268 T3344 2235539.4388714042
Rt18208 T3268 T3345 19921139.088392962
Rt18209 T3268 T4144 871027.33767063497
Rt18210 T3268 T5105 1645601.2487550953
Rt18211 T3268 T5668 7359433.3033158351
Rt18212 T3268 T5669 3966231.8423302695
Gcorr6172 T3268 T6001 T3268 T6001 -7.8778967003734297e-08
Rt18213 T3269 T3270 2533165.1321788048
Rt18214 T3269 T3271 2587102.1568631548
Rt18215 T3269 T3681 2347048.8707720805
Rt18216 T3269 T3985 5571451.8526120577
Gcorr6173 T3269 T5105 T3269 T5105 -5.8822212097508782e-08
Rt18217 T3269 T5829 3820113.7417722619
Rt18218 T3269 T5929 2646603.4671078399
Rt18219 T3269 T6001 1514826.1022393629
Rt18220 T3270 T3271 2195121.0694807586
Rt18221 T3270 T3272 2023125.7995651294
Rt18222 T3270 T3273 7117222.4411334572
Rt18223 T3270 T3344 2119369.6763021229
Rt18224 T3270 T4089 2287171.7706900849
Gcorr6174 T3270 T5102 T3270 T5102 -1.5888786352141503e-07
Rt18225 T3270 T5103 1059295.088984495
Rt18226 T3270 T5105 2854915.8395315316
Gcorr6175 T3270 T5122 T3270 T5122 -1.2603760882914265e-07
Rt18227 T3270 T5929 4588290.9189236928
Rt18228 T3271 T3272 7953873.8618285963
Gcorr6176 T3271 T3523 T3271 T3523 -2.118231805236233e-07
Rt18229 T3271 T3985 1436868.6285526943
Rt18230 T3271 T4083 1325232.6968725938
Gcorr6177 T3271 T4175 T3271 T4175 -1.7467369226217985e-07
Rt18231 T3271 T5122 1817898.7934172822
Gcorr6178 T3271 T5829 T3271 T5829 -1.0353393882875636e-07
Rt18232 T3271 T5929 2825596.5441138381
Rt18233 T3271 T6041 1178224.1087809633
Rt18234 T3272 T3273 2595152.4707583236
Rt18235 T3272 T3274 5266245.1058830069
Rt18236 T3272 T3786 961148.06344007538
Rt18237 T3272 T4083 1650427.5178561429
Gcorr6179 T3272 T5103 T3272 T5103 -1.0305311708062673e-07
Rt18238 T3272 T5121 1201811.0525656699
Rt18239 T3272 T5122 2004343.606523182
Gcorr6180 T3272 T5706 T3272 T5706 -1.2950720237210487e-07
Rt18240 T3273 T3274 2705186.7972232373
Rt18241 T3273 T3346 2644129.7100757123
Rt18242 T3273 T3529 1618944.1692837661
Rt18243 T3273 T4089 979891.69084788673
Gcorr6181 T3273 T5093 T3273 T5093 -1.4568769773215274e-07
Rt18244 T3273 T5095 1904713.022752167
Rt18245 T3273 T5103 11097915.457937846
Rt18246 T3273 T5121 8731321.522092903
Rt18247 T3273 T5825 4395615.0066318028
Rt18248 T3274 T3346 2199517.5416441662
Rt18249 T3274 T3347 3812966.3112353231
Rt18250 T3274 T3348 1721529.8383375879
Rt18251 T3274 T3786 1684766.7298658218
Rt18252 T3274 T5121 3892738.455301804
Rt18253 T3274 T5648 1885065.0302170373
Rt18254 T3274 T5825 17488507.497517336
Gcorr6182 T3274 T6051 T3274 T6051 -1.351582409319845e-08
Rt18255 T3275 T3276 2741145.0815744069
Gcorr6183 T3275 T3277 T3275 T3277 -5.3941142454117748e-08
Rt18256 T3275 T3871 1230473.7047374134
Rt18257 T3275 T3966 873625.55747767969
Gcorr6184 T3275 T4753 T3275 T4753 -1.8601098807994953e-07
Rt18258 T3275 T4858 4678231.1318007233
Rt18259 T3275 T5294 2514490.2601007824
Rt18260 T3275 T5735 1238022.7870174779
Rt18261 T3276 T3277 2592365.3201312306
Rt18262 T3276 T3278 690764.91268842469
Rt18263 T3276 T3784 1493663.5819396225
Rt18264 T3276 T4128 4371226.309139967
Rt18265 T3276 T4858 4064455.2437408403
Gcorr6185 T3276 T5118 T3276 T5118 -1.6025195035120564e-07
Rt18266 T3276 T5265 481970.56886760343
Rt18267 T3276 T5735 30579628.8020516
Gcorr6186 T3276 T5913 T3276 T5913 -5.0685283760996916e-07
Rt18268 T3277 T3278 7131436.6825624695
Rt18269 T3277 T3279 3151890.1950538843
Rt18270 T3277 T3280 3263930.3121104296
Gcorr6187 T3277 T3299 T3277 T3299 -1.1480611950635475e-08
Rt18271 T3277 T3871 1205371.1307165893
Rt18272 T3277 T4714 13177722.585807638
Rt18273 T3277 T4830 1923713.5997680684
Rt18274 T3277 T4858 1348303.0303715188
Rt18275 T3277 T5118 4314525.7997049326
Rt18276 T3278 T3279 1423313.3873875504
Gcorr6188 T3278 T3355 T3278 T3355 -4.7857695641672635e-07
Rt18277 T3278 T3567 1814847.7143733201
Rt18278 T3278 T3784 1177732.0676889513
Rt18279 T3278 T5118 624183.01515135635
Gcorr6189 T3278 T5168 T3278 T5168 -1.4021288842040638e-07
Rt18280 T3278 T5172 1105847.7891920228
Gcorr6190 T3278 T5265 T3278 T5265 -5.1312998913276696e-07
Rt18281 T3278 T5913 3033594.4706608267
Rt18282 T3279 T3280 2727895.9945638864
Rt18283 T3279 T3281 5617312.0774802128
Rt18284 T3279 T3567 12210822.990735646
Rt18285 T3279 T4006 807673.75511895469
Rt18286 T3279 T4830 2709016.2036480489
Gcorr6191 T3279 T5118 T3279 T5118 -1.475421644375377e-07
Rt18287 T3279 T5168 753242.81905968185
Rt18288 T3279 T5607 2837246.8887760662
Gcorr6192 T3279 T5939 T3279 T5939 -4.0195436104731607e-07
Rt18289 T3280 T3281 2391631.8918444277
Rt18290 T3280 T3288 6140237.671507284
Rt18291 T3280 T3294 2082639.6138863231
Rt18292 T3280 T3299 1088342.1006893034
Rt18293 T3280 T4693 1359350.4221774517
Gcorr6193 T3280 T4714 T3280 T4714 -1.5665705565520615e-07
Rt18294 T3280 T4830 3725039.0870596641
Rt18295 T3280 T5607 12964274.559442693
Rt18296 T3280 T5841 5575701.6016102191
Rt18297 T3281 T3288 2476160.36390658
Rt18298 T3281 T3289 1962084.8335513065
Rt18299 T3281 T3290 4060620.7696494581
Rt18300 T3281 T4006 615827.25095140375
Rt18301 T3281 T4733 8923446.2757503688
Rt18302 T3281 T5013 3170393.9448079988
Rt18303 T3281 T5607 849654.70352234854
Gcorr6194 T3281 T5841 T3281 T5841 -6.3781700490897328e-08
Gcorr6195 T3281 T5939 T3281 T5939 -5.3567660436133637e-07
Rt18304 T3282 T3325 760220.29465827288
Rt18305 T3282 T3886 342169.56651222729
Rt18306 T3282 T4037 1433193.1715052251
Rt18307 T3282 T4128 1325311.3332761039
Gcorr6196 T3282 T5023 T3282 T5023 -4.678074930899718e-07
Rt18308 T3282 T5065 249521.75388188797
Gcorr6197 T3282 T5317 T3282 T5317 -5.6369126814255711e-08
Gcorr6198 T3282 T5711 T3282 T5711 -1.2558735239333188e-06
Gcorr6199 T3282 T5786 T3282 T5786 -5.0835142871515194e-08
Rt18309 T3283 T3435 1988627.6263543153
Rt18310 T3283 T3548 1641531.4903603336
Rt18311 T3283 T3653 6484343.4972518347
Rt18312 T3283 T3832 474498.61614348553
Gcorr6200 T3283 T4636 T3283 T4636 -1.3156345166240591e-07
Gcorr6201 T3283 T5420 T3283 T5420 -4.8310880074013848e-07
Gcorr6202 T3283 T5421 T3283 T5421 -6.2438489117892051e-07
Rt18313 T3283 T5461 13045457.666712102
Rt18314 T3283 T5694 554771.26831330953
Rt18315 T3284 T3501 906495.86357126059
Gcorr6203 T3284 T3618 T3284 T3618 -2.6503045248833299e-08
Rt18316 T3284 T3893 1427004.9879321752
Rt18317 T3284 T3999 3425624.8834248842
Rt18318 T3284 T4035 889553.70257862285
Rt18319 T3284 T4456 3920401.9934130651
Gcorr6204 T3284 T4460 T3284 T4460 -3.937545819433473e-07
Rt18320 T3284 T4613 6039313.572505624
Rt18321 T3284 T5699 1542307.9931514715
Rt18322 T3285 T3336 4202429.6779970732
Rt18323 T3285 T3449 3474148.3127185265
Rt18324 T3285 T3499 2082600.0539909494
Gcorr6205 T3285 T3801 T3285 T3801 -3.5863357606288812e-08
Rt18325 T3285 T4016 506867.68523841142
Gcorr6206 T3285 T4325 T3285 T4325 -1.3794936003808649e-07
Gcorr6207 T3285 T4327 T3285 T4327 -2.9793501719626855e-07
Rt18326 T3285 T5730 5540252.7748166025
Rt18327 T3285 T5811 977604.92662817216
Gcorr6208 T3286 T3690 T3286 T3690 -1.8201597697215938e-07
Rt18328 T3286 T3951 218905010.66949517
Rt18329 T3286 T4014 985078.76493057061
Rt18330 T3286 T4106 1250594.9992781826
Gcorr6209 T3286 T4829 T3286 T4829 -9.9094635645284867e-08
Rt18331 T3286 T4992 753767.40044470958
Rt18332 T3286 T5352 3223999.189075476
Rt18333 T3286 T5847 3290434.2040972859
Rt18334 T3287 T3527 5059091.1965386188
Rt18335 T3287 T3536 1772560376.4532464
Rt18336 T3287 T3577 2556511.1079347911
Rt18337 T3287 T4054 1144151.7076378101
Rt18338 T3287 T4168 1090864.2032338271
Rt18339 T3287 T4380 4223877.8546243133
Rt18340 T3287 T5611 17364178.799986321
Rt18341 T3287 T5612 2411487.8792938581
Rt18342 T3287 T5639 191467423.6134702
Gcorr6210 T3287 T5842 T3287 T5842 -5.8951035078310007e-08
Rt18343 T3288 T3289 5142500.2424055301
Rt18344 T3288 T3294 2025133.0840128511
Rt18345 T3288 T3492 2398707.2600296307
Rt18346 T3288 T3850 1397837.9559417276
Rt18347 T3288 T4178 7536442.7667900138
Gcorr6211 T3288 T4629 T3288 T4629 -1.4965216220333373e-07
Rt18348 T3288 T4631 3558367.6412907648
Rt18349 T3288 T4733 7193166.2674439494
Rt18350 T3288 T5841 1921375.3220290148
Rt18351 T3289 T3290 1561705.8667304902
Rt18352 T3289 T3291 8061185.577336085
Rt18353 T3289 T3492 1883037.4992506739
Rt18354 T3289 T4022 1090270.8047924875
Gcorr6212 T3289 T4692 T3289 T4692 -1.503046235801158e-07
Rt18355 T3289 T4733 1889406.0025963925
Rt18356 T3289 T4734 2358832.9948687758
Gcorr6213 T3289 T5013 T3289 T5013 -8.3001467675965528e-08
Rt18357 T3290 T3291 697781.46600394323
Rt18358 T3290 T3292 1965738.372118663
Rt18359 T3290 T3518 10072795.203435399
Rt18360 T3290 T4006 612013.92185326456
Gcorr6214 T3290 T4734 T3290 T4734 -5.4613672365921384e-07
Rt18361 T3290 T5013 570261.78179849836
Gcorr6215 T3290 T5030 T3290 T5030 -1.8519548199564633e-08
Rt18362 T3290 T5329 3378292.846179089
Gcorr6216 T3290 T5939 T3290 T5939 -5.4207875499384078e-07
Rt18363 T3291 T3292 5230442.0593443308
Rt18364 T3291 T3293 2066858.4419962845
Rt18365 T3291 T3353 242754415.32398149
Rt18366 T3291 T3453 1669855.0650576353
Rt18367 T3291 T4022 9802944.5635153465
Rt18368 T3291 T4734 1352627.3974912062
Gcorr6217 T3291 T5013 T3291 T5013 -5.4779892120563448e-07
Rt18369 T3291 T5030 1789722.5685174162
Rt18370 T3291 T5201 3658489.0206607464
Rt18371 T3292 T3293 1566417.6142829249
Rt18372 T3292 T3295 2154651.6214554273
Rt18373 T3292 T3518 1248158.347798456
Gcorr6218 T3292 T3926 T3292 T3926 -1.1525537866088526e-07
Rt18374 T3292 T5030 1529538.4332462107
Rt18375 T3292 T5329 29007731.057615187
Rt18376 T3292 T5330 1480330.6327109986
Gcorr6219 T3292 T5598 T3292 T5598 -1.0134104802888829e-07
Rt18377 T3293 T3295 4227196.6689664125
Rt18378 T3293 T3296 1582850.1126266501
Rt18379 T3293 T3297 2553668.5663342546
Rt18380 T3293 T3353 1999947.2002844003
Gcorr6220 T3293 T4878 T3293 T4878 -1.6833512444262702e-07
Gcorr6221 T3293 T5030 T3293 T5030 -1.5289866219331475e-07
Rt18381 T3293 T5201 16329625.046234703
Rt18382 T3293 T5598 915504.48076117912
Rt18383 T3293 T6064 3025731.824107877
Rt18384 T3294 T3299 2406900.542799043
Gcorr6222 T3294 T3340 T3294 T3340 -7.5030839194545393e-08
Rt18385 T3294 T3812 52444719.847080082
Rt18386 T3294 T3850 1224275.299325268
Rt18387 T3294 T3947 1018930.4223074411
Rt18388 T3294 T4590 6589889.6444339864
Rt18389 T3294 T4629 2106386.6285877633
Rt18390 T3294 T4630 6778275.7232604092
Rt18391 T3294 T4693 16330722.468027081
Gcorr6223 T3294 T5841 T3294 T5841 -1.7775758978999368e-07
Rt18392 T3295 T3296 2023824.3379623387
Gcorr6224 T3295 T3444 T3295 T3444 -4.1568293338395588e-08
Rt18393 T3295 T3601 1350482.7293907772
Rt18394 T3295 T3926 1554393.7020965279
Rt18395 T3295 T4900 2224390.1934783892
Rt18396 T3295 T5321 18788583.780365866
Rt18397 T3295 T5330 1079404.1303134747
Rt18398 T3295 T5598 5242544.9105525017
Rt18399 T3296 T3297 7502185.8483538032
Rt18400 T3296 T3298 1823207.2958339709
Rt18401 T3296 T3300 1664554.9593845357
Rt18402 T3296 T3601 11907607.493538795
Gcorr6225 T3296 T4844 T3296 T4844 -8.7735966185743391e-09
Rt18403 T3296 T4878 1321935.2288415362
Rt18404 T3296 T4900 1631210.078964618
Gcorr6226 T3296 T5598 T3296 T5598 -1.3916535481214165e-07
Rt18405 T3297 T3298 2070179.9858428375
Rt18406 T3297 T3353 3397730.8029550877
Rt18407 T3297 T3559 3887007.780266548
Rt18408 T3297 T3852 1144642.0249880021
Rt18409 T3297 T4878 3667778.0430413871
Gcorr6227 T3297 T5252 T3297 T5252 -9.0042664311789631e-09
Rt18410 T3297 T5787 1942754.775146344
Rt18411 T3297 T6064 8714053.2050788403
Rt18412 T3298 T3300 5392840.3872324796
Rt18413 T3298 T3301 2914276.8272946542
Rt18414 T3298 T3559 3519991.7909041056
Rt18415 T3298 T4117 927297.95891602023
Rt18416 T3298 T4686 1576857.9859484173
Gcorr6228 T3298 T4766 T3298 T4766 -5.9899888621653035e-08
Rt18417 T3298 T4844 2355444.296674618
Rt18418 T3298 T4878 21149739.862774838
Gcorr6229 T3298 T5787 T3298 T5787 -1.3004988691720368e-07
Gcorr6230 T3299 T3354 T3299 T3354 -3.3354519995669454e-08
Rt18419 T3299 T3451 1908793.363084109
Rt18420 T3299 T3871 1334568.1546407337
Rt18421 T3299 T3947 5785215.6306936657
Rt18422 T3299 T4630 3255476.3048371715
Gcorr6231 T3299 T4693 T3299 T4693 -1.0232935555242286e-07
Rt18423 T3299 T4714 1690249.3370104569
Rt18424 T3299 T5378 15022912.018479642
Rt18425 T3300 T3301 1945308.7620242767
Rt18426 T3300 T3302 2285839.8011770966
Rt18427 T3300 T3601 2858577.6961112651
Rt18428 T3300 T4186 4213575.9085576618
Rt18429 T3300 T4844 1480290.5234435636
Rt18430 T3300 T4897 35520421.369710378
Gcorr6232 T3300 T4900 T3300 T4900 -6.6191770059543148e-08
Rt18431 T3300 T5890 1926881.1444539153
Rt18432 T3301 T3302 6716601.2860731622
Rt18433 T3301 T3303 3083942.8187006391
Rt18434 T3301 T4117 4678561.7550684307
Rt18435 T3301 T4165 896529.48039692594
Rt18436 T3301 T4766 1910014.4690053747
Gcorr6233 T3301 T4844 T3301 T4844 -1.1497284832233602e-07
Rt18437 T3301 T4897 2233692.1996992743
Rt18438 T3301 T5691 10043297.045555932
Rt18439 T3302 T3303 359369.61039717047
Rt18440 T3302 T3304 4849117.3226485709
Rt18441 T3302 T3862 4950193.2330442229
Rt18442 T3302 T4186 410413.37507217529
Rt18443 T3302 T4897 1198828.7384602046
Gcorr6234 T3302 T5205 T3302 T5205 -1.0850416509832099e-06
Gcorr6235 T3302 T5263 T3302 T5263 -6.7964453177603654e-07
Rt18444 T3302 T5879 396492.23129935242
Gcorr6236 T3302 T5890 T3302 T5890 -8.4076618194106345e-08
Rt18445 T3303 T3304 1740594.3787720562
Rt18446 T3303 T3305 2674544.2311205873
Rt18447 T3303 T3306 2450570.3444860764
Rt18448 T3303 T3308 2426149.6162445014
Rt18449 T3303 T4165 15198835.18705735
Rt18450 T3303 T4879 3661257.0406613518
Gcorr6237 T3303 T4897 T3303 T4897 -1.3582054678721421e-07
Gcorr6238 T3303 T5039 T3303 T5039 -1.6502414457918776e-07
Rt18451 T3303 T5205 475394.48744746699
Rt18452 T3303 T5691 2423405.77240005
Gcorr6239 T3303 T5879 T3303 T5879 -1.0930921452424826e-06
Rt18453 T3304 T3305 1921683.8247625576
Rt18454 T3304 T3715 1244852.0081139479
Rt18455 T3304 T3862 1813706.1063941827
Rt18456 T3304 T4212 2841686.4198288941
Rt18457 T3304 T5205 2175601.3063237392
Gcorr6240 T3304 T5872 T3304 T5872 -1.682578574331315e-07
Rt18458 T3304 T5879 1206611.451333862
Rt18459 T3305 T3306 9248896.7307335436
Rt18460 T3305 T3307 2010813.6201327886
Rt18461 T3305 T3322 1906503.0950586209
Rt18462 T3305 T3715 6972907.8857326908
Rt18463 T3305 T5039 2327934.3554580207
Rt18464 T3305 T5205 14977003.011728371
Gcorr6241 T3305 T5212 T3305 T5212 -7.0180722606753664e-08
Rt18465 T3305 T5872 992531.12992589769
Rt18466 T3306 T3307 2120620.2650059382
Rt18467 T3306 T3308 2541078.468247164
Rt18468 T3306 T3310 1976638.3252553011
Rt18469 T3306 T3311 1323410.2213418174
Gcorr6242 T3306 T4764 T3306 T4764 -1.8351538311042959e-07
Rt18470 T3306 T4765 1909776.7421779928
Rt18471 T3306 T4879 4430146.8823400382
Rt18472 T3306 T5039 1592906.4960027314
Gcorr6243 T3306 T5157 T3306 T5157 -9.7637667634685626e-08
Rt18473 T3307 T3311 59633710.462900452
Rt18474 T3307 T3312 1983907.5801938274
Rt18475 T3307 T3313 1208531.048389972
Rt18476 T3307 T3322 5900994.0009204848
Gcorr6244 T3307 T5039 T3307 T5039 -4.1690299303968378e-10
Rt18477 T3307 T5157 2084147.1467118156
Rt18478 T3307 T5212 1303835.008447001
Gcorr6245 T3307 T5388 T3307 T5388 -1.0497074198499522e-07
Rt18479 T3308 T3310 7880651.4712331286
Rt18480 T3308 T3757 2118864.4161222982
Rt18481 T3308 T3914 2161716.2901752423
Rt18482 T3308 T4165 868425.97566748667
Rt18483 T3308 T4764 2823428.8893755968
Rt18484 T3308 T4879 3157371.7311407034
Rt18485 T3308 T5342 3864284.2089502644
Gcorr6246 T3308 T5691 T3308 T5691 -5.8199472269447674e-08
Gcorr6247 T3308 T5895 T3308 T5895 -1.2724189237192587e-07
Rt18486 T3309 T3563 24363071.119389802
Rt18487 T3309 T3757 1619626.3992335841
Rt18488 T3309 T4116 1049109.7210139371
Rt18489 T3309 T4117 1036133.2907531722
Rt18490 T3309 T4165 977115.36182974861
Rt18491 T3309 T4685 4110341.9028223953
Gcorr6248 T3309 T4766 T3309 T4766 -7.7095012753792944e-08
Rt18492 T3309 T5342 3886298.1799741932
Gcorr6249 T3309 T5504 T3309 T5504 -6.6806569963977991e-08
Rt18493 T3310 T3311 1986935.473351008
Rt18494 T3310 T3579 15128250.033661585
Rt18495 T3310 T3676 4607340.4863334605
Rt18496 T3310 T3914 1037289.4885692749
Rt18497 T3310 T4065 2454015.0669580493
Rt18498 T3310 T4763 1827400.9179355281
Rt18499 T3310 T4764 4572619.2070613354
Rt18500 T3310 T4765 8115946.437147948
Gcorr6250 T3310 T5715 T3310 T5715 -1.8786869019524661e-07
Rt18501 T3311 T3312 3247242.9584562154
Rt18502 T3311 T3785 2174144.009777321
Rt18503 T3311 T4065 1575487.0956653696
Gcorr6251 T3311 T4765 T3311 T4765 -2.0002627930915024e-08
Rt18504 T3311 T5157 2801294.9171325341
Rt18505 T3311 T5715 2091316.8161483388
Gcorr6252 T3311 T6022 T3311 T6022 -7.8201336232902073e-08
Rt18506 T3312 T3313 4405758.6380395433
Rt18507 T3312 T3314 1978376.8437943044
Rt18508 T3312 T3359 2469893.7973822318
Rt18509 T3312 T3785 1463334.669297395
Gcorr6253 T3312 T4754 T3312 T4754 -1.0102266497317995e-07
Rt18510 T3312 T5157 29546904.88695519
Rt18511 T3312 T5388 2598896.5287409662
Rt18512 T3312 T5723 5124355.1772086304
Rt18513 T3312 T6022 3078828.6081202175
Rt18514 T3313 T3314 3899073.9598004106
Rt18515 T3313 T3315 912591.34848712478
Rt18516 T3313 T3322 5197972.8135435292
Rt18517 T3313 T3590 2850066.6814353387
Gcorr6254 T3313 T4840 T3313 T4840 -1.6950310627495745e-07
Gcorr6255 T3313 T5212 T3313 T5212 -1.1220131484157031e-07
Rt18518 T3313 T5388 916660.41185452358
Rt18519 T3313 T5838 3109746.1191922715
Rt18520 T3314 T3315 1841808.6159628527
Rt18521 T3314 T3316 6326277.1063760305
Rt18522 T3314 T3359 7028124.5873071877
Rt18523 T3314 T3607 2336351.1194798355
Rt18524 T3314 T3959 1678324.0289453415
Gcorr6256 T3314 T4679 T3314 T4679 -2.2249467277127036e-07
Rt18525 T3314 T4722 2020407.5443070175
Rt18526 T3314 T4754 1974237.1307192808
Rt18527 T3314 T5388 7500886.8448184757
Rt18528 T3315 T3316 2228490.9996544854
Rt18529 T3315 T3317 6273689.2285358915
Rt18530 T3315 T3590 9826147.8009222783
Rt18531 T3315 T4196 1378058.788705566
Rt18532 T3315 T4722 4972417.3278782079
Rt18533 T3315 T4831 9225673.0268359501
Rt18534 T3315 T4840 1075459.3151128406
Gcorr6257 T3315 T5388 T3315 T5388 -2.5938951380800276e-07
Rt18535 T3316 T3317 4875586.8259811383
Rt18536 T3316 T3318 2164181.092710264
Rt18537 T3316 T3561 6221641.9971368918
Rt18538 T3316 T3607 738403.26341619506
Gcorr6258 T3316 T4679 T3316 T4679 -3.9429590575330557e-07
Rt18539 T3316 T4721 1771660.3834991455
Rt18540 T3316 T4722 1906383.250462065
Rt18541 T3316 T4831 5219537.6821719864
Rt18542 T3317 T3318 1353871.0785373996
Rt18543 T3317 T3319 1389388.8076563415
Rt18544 T3317 T3856 7599655.1880016299
Rt18545 T3317 T4196 781187.16805471142
Rt18546 T3317 T4831 1010073.4575173063
Gcorr6259 T3317 T4961 T3317 T4961 -2.1933986958447802e-08
Rt18547 T3317 T4962 5047823.0466435226
Gcorr6260 T3317 T5809 T3317 T5809 -1.49301735459254e-07
Rt18548 T3318 T3319 4781087.5128439218
Rt18549 T3318 T3320 1909970.3119783413
Rt18550 T3318 T3343 2061601.7639961848
Rt18551 T3318 T3561 2712448.2777163098
Rt18552 T3318 T4039 41786563.687366523
Rt18553 T3318 T4721 8414625.5459439661
Rt18554 T3318 T4827 3565353.2361679492
Gcorr6261 T3318 T4831 T3318 T4831 -1.3462966475628124e-07
Gcorr6262 T3318 T5783 T3318 T5783 -1.4727941822208165e-07
Rt18555 T3318 T5809 1079092.9205440045
Rt18556 T3319 T3320 1778172.0023132104
Rt18557 T3319 T3321 727619.7403430742
Rt18558 T3319 T3323 1203368.6621557693
Gcorr6263 T3319 T3856 T3319 T3856 -6.2835131401089945e-08
Rt18559 T3319 T4962 592883.02416070027
Gcorr6264 T3319 T5400 T3319 T5400 -1.0863764821813282e-07
Rt18560 T3319 T5809 4751842.8042682763
Gcorr6265 T3319 T6010 T3319 T6010 -4.1844256162476727e-07
Rt18561 T3320 T3321 9388644.4126144703
Rt18562 T3320 T3343 6453578.8759010006
Rt18563 T3320 T3569 1420127.6538329627
Rt18564 T3320 T3839 1749020.1086642966
Gcorr6266 T3320 T5016 T3320 T5016 -1.0641632210353087e-07
Rt18565 T3320 T5400 1680954.8158737232
Rt18566 T3320 T5783 1785534.0784714804
Gcorr6267 T3320 T5809 T3320 T5809 -6.8891870161923037e-08
Rt18567 T3321 T3323 8699194.4169012494
Gcorr6268 T3321 T3436 T3321 T3436 -3.4688502935742205e-08
Rt18568 T3321 T3839 1243428.0813980517
Rt18569 T3321 T3998 1913803.6236080525
Gcorr6269 T3321 T4962 T3321 T4962 -4.544136749679894e-07
Rt18570 T3321 T5400 1916196.3564963655
Rt18571 T3321 T5401 1633033.6051955377
Rt18572 T3321 T6010 1685313.4332461138
Rt18573 T3322 T3590 1379645.83235092
Rt18574 T3322 T3715 2445217.4939670698
Rt18575 T3322 T3906 6528106.2068958906
Rt18576 T3322 T5212 2325946.4210877311
Rt18577 T3322 T5838 24427351.968477357
Gcorr6270 T3322 T5872 T3322 T5872 -3.6548747590500106e-08
Rt18578 T3322 T5902 920615.56058468565
Gcorr6271 T3323 T3712 T3323 T3712 -2.0804285419524031e-07
Rt18579 T3323 T3856 3747101.7563809985
Rt18580 T3323 T3998 3570736.6549737579
Rt18581 T3323 T4108 1076812.8943879693
Gcorr6272 T3323 T4962 T3323 T4962 -1.1581713882704424e-07
Rt18582 T3323 T5335 1351276.7004701109
Rt18583 T3323 T6010 875821.55669705605
Rt18584 T3324 T3503 835717.69747619343
Rt18585 T3324 T3614 1508137.9843667666
Rt18586 T3324 T3683 2754343.7440534779
Rt18587 T3324 T3736 1539707.9819365107
Rt18588 T3324 T4633 1293599.9947377359
Gcorr6273 T3324 T5059 T3324 T5059 -4.6556625694963053e-07
Rt18589 T3324 T5323 2543554.6045098128
Rt18590 T3324 T5324 8190228.1543422742
Gcorr6274 T3324 T5583 T3324 T5583 -1.3662776684660355e-07
Gcorr6275 T3325 T3681 T3325 T3681 -1.9463263693330791e-07
Rt18591 T3325 T3798 696927.32262978819
Rt18592 T3325 T4003 1557597.473786806
Rt18593 T3325 T4037 496084136.29142344
Rt18594 T3325 T5023 1390588.2128967994
Gcorr6276 T3325 T5065 T3325 T5065 -5.2053784226151727e-07
Rt18595 T3325 T5317 584877.33799148607
Gcorr6277 T3325 T5798 T3325 T5798 -5.849708962058254e-07
Rt18596 T3325 T5828 898569.37731141387
Rt18597 T3326 T3902 1075100.4468509136
Rt18598 T3326 T3972 3493542.8942594654
Rt18599 T3326 T4018 853062.70865364186
Gcorr6278 T3326 T5123 T3326 T5123 -1.7433111731847957e-07
Rt18600 T3326 T5124 4623145.05715138
Rt18601 T3326 T5621 2010448.1148663715
Rt18602 T3326 T5695 15070726.980499018
Rt18603 T3327 T3903 1371443.3331191135
Rt18604 T3327 T4020 1570286.3929327826
Rt18605 T3327 T4021 2736395.3062255429
Rt18606 T3327 T4194 2112862.3250271212
Rt18607 T3327 T4742 4798061.8235698231
Rt18608 T3327 T5589 5727545.9488256946
Rt18609 T3327 T5618 12746250.041071929
Rt18610 T3328 T3329 2307887.7793673784
Rt18611 T3328 T3331 2510358.9612385291
Rt18612 T3328 T3995 1230443.783252144
Rt18613 T3328 T4149 1123882.4839985981
Gcorr6279 T3328 T4601 T3328 T4601 -1.3217702258782322e-07
Rt18614 T3328 T4738 1586748.5718051957
Rt18615 T3328 T5406 34278175.335875072
Rt18616 T3328 T5613 2737518.7253983207
Gcorr6280 T3328 T5992 T3328 T5992 -1.2151348910120769e-07
Rt18617 T3329 T3330 2729506.8641600539
Rt18618 T3329 T3714 649745.58855670423
Rt18619 T3329 T3744 612224.77178625052
Gcorr6281 T3329 T4149 T3329 T4149 -5.3833588747849444e-08
Gcorr6282 T3329 T4601 T3329 T4601 -2.2713800645497631e-07
Gcorr6283 T3329 T4602 T3329 T4602 -5.4447990389296827e-07
Rt18620 T3329 T4707 614541.73122235551
Gcorr6284 T3329 T4708 T3329 T4708 -1.5124628803162097e-07
Rt18621 T3329 T4738 10435383.754307715
Gcorr6285 T3329 T4739 T3329 T4739 -1.6311722106498847e-07
Rt18622 T3329 T5955 3584503.7637188635
Rt18623 T3330 T3569 4888947.3690529447
Rt18624 T3330 T3714 1473847.8695087545
Rt18625 T3330 T3839 1734620.4411031357
Rt18626 T3330 T3941 1430222.6294056256
Rt18627 T3330 T4708 1456496.0809862725
Gcorr6286 T3330 T5015 T3330 T5015 -1.0499176911009222e-07
Rt18628 T3330 T5016 3933073.8387102834
Rt18629 T3330 T5017 20018441.99260715
Gcorr6287 T3330 T5955 T3330 T5955 -9.0320509498442571e-08
Rt18630 T3331 T3974 1404445.808785547
Gcorr6288 T3331 T3995 T3331 T3995 -1.3891366116455978e-08
Rt18631 T3331 T4098 1755972.7444515279
Rt18632 T3331 T4099 1002987.4063750469
Rt18633 T3331 T5406 2495769.8008816121
Gcorr6289 T3331 T5408 T3331 T5408 -1.5688686115885287e-07
Rt18634 T3331 T5992 3444415.4488021568
Rt18635 T3332 T3440 2283493.7668418507
Rt18636 T3332 T3450 1718082.3086879828
Rt18637 T3332 T3491 17810812.513366289
Rt18638 T3332 T3901 1051992.0767463129
Rt18639 T3332 T4264 6924503.6324847676
Gcorr6290 T3332 T4266 T3332 T4266 -1.3815871695022902e-07
Rt18640 T3332 T4273 60164646.845389187
Rt18641 T3332 T5688 1332353.7651272491
Gcorr6291 T3332 T6014 T3332 T6014 -8.8598244054946043e-08
Rt18642 T3333 T3469 509079.08042826853
Rt18643 T3333 T3738 2992278.1554851849
Gcorr6292 T3333 T3931 T3333 T3931 -1.5950182446421309e-07
Rt18644 T3333 T4094 1032585.3956565805
Rt18645 T3333 T4174 16614040.930067614
Rt18646 T3333 T4616 5222517.3372624191
Gcorr6293 T3333 T4617 T3333 T4617 -1.1582207196391055e-06
Rt18647 T3333 T4618 610157.18414898706
Rt18648 T3333 T5710 3042739.9887962984
Rt18649 T3333 T5850 4765434.0579574164
Gcorr6294 T3334 T3709 T3334 T3709 -6.7814206769227486e-08
Rt18650 T3334 T3968 2306770.5723578767
Rt18651 T3334 T3988 1888964.7814016091
Gcorr6295 T3334 T4079 T3334 T4079 -3.3622097464474106e-08
Rt18652 T3334 T4234 1413806.5332095071
Rt18653 T3334 T5975 2493416.5927030984
Rt18654 T3334 T6038 784102.72640087293
Rt18655 T3335 T3510 1371400.584726464
Rt18656 T3335 T3562 1680584.0615397173
Rt18657 T3335 T3859 6350379.4023164921
Rt18658 T3335 T4086 1066700.3095682601
Rt18659 T3335 T4928 3019396.769745213
Gcorr6296 T3335 T5228 T3335 T5228 -1.6504871022156769e-07
Rt18660 T3335 T5229 2828524.8647715552
Rt18661 T3335 T6080 97098412.64970313
Rt18662 T3336 T3337 1594582.6366799884
Gcorr6297 T3336 T3338 T3336 T3338 -6.2691194789925183e-08
Rt18663 T3336 T3499 1135907.4490973186
Rt18664 T3336 T4100 508936.96257915261
Gcorr6298 T3336 T4352 T3336 T4352 -1.9594900887517949e-07
Rt18665 T3336 T4949 733531.71188521979
Gcorr6299 T3336 T4996 T3336 T4996 -2.024510694517601e-07
Gcorr6300 T3336 T4997 T3336 T4997 -1.1806379165938422e-07
Gcorr6301 T3336 T5811 T3336 T5811 -8.2459397814127208e-08
Rt18666 T3337 T3833 1326290.6488104651
Rt18667 T3337 T3930 3270486.0733583178
Rt18668 T3337 T3990 1460972.085567455
Rt18669 T3337 T4100 8325027.0333277155
Rt18670 T3337 T4996 4883024.4881445933
Rt18671 T3337 T4997 986797.70504700358
Gcorr6302 T3337 T4998 T3337 T4998 -9.7185909114587459e-08
Rt18672 T3338 T3499 1159040.1319055879
Rt18673 T3338 T3800 645676.25791683921
Rt18674 T3338 T3802 1345636.0096763596
Rt18675 T3338 T3953 1601637.5492312498
Rt18676 T3338 T4100 1095239.9041497365
Gcorr6303 T3338 T4345 T3338 T4345 -6.3676986172243019e-07
Gcorr6304 T3338 T4346 T3338 T4346 -1.7373940852222124e-07
Rt18677 T3338 T4352 747575.99129846354
Rt18678 T3338 T4353 6627813.4852847615
Gcorr6305 T3338 T5773 T3338 T5773 -7.3528983482601813e-08
Rt18679 T3339 T3858 2763332.2642722824
Rt18680 T3339 T3995 1484848.7740045537
Rt18681 T3339 T4149 2141615.5543833682
Rt18682 T3339 T4497 2252135.3720161906
Gcorr6306 T3339 T4498 T3339 T4498 -1.396648111042359e-07
Rt18683 T3340 T3812 1176836.5763532186
Rt18684 T3340 T3947 972022.17399122298
Rt18685 T3340 T4588 3673361.4895603852
Gcorr6307 T3340 T4589 T3340 T4589 -1.1288389485427417e-07
Rt18686 T3340 T4590 3469323.822623923
Gcorr6308 T3340 T5696 T3340 T5696 -5.3241500886028068e-08
Rt18687 T3341 T3452 4786754.9335056236
Rt18688 T3341 T3513 1647670.5761519324
Rt18689 T3341 T3864 2066918.1864048177
Rt18690 T3341 T3917 1758082.5985382143
Gcorr6309 T3341 T4959 T3341 T4959 -7.0369914430599595e-08
Rt18691 T3341 T5226 2377253.5153093338
Rt18692 T3341 T5227 2961414.964443644
Gcorr6310 T3341 T5307 T3341 T5307 -9.5873618069597461e-08
Rt18693 T3342 T3943 1275242.357014518
Rt18694 T3342 T4102 1886635.2513718712
Rt18695 T3342 T4132 1058739.5451176816
Rt18696 T3342 T4718 1885063.2631789644
Gcorr6311 T3342 T4889 T3342 T4889 -6.8295525621673375e-08
Rt18697 T3342 T5232 26640155.660585936
Gcorr6312 T3342 T6077 T3342 T6077 -9.6965587820412442e-08
Rt18698 T3343 T3569 2458664.2211239417
Rt18699 T3343 T3739 1169663.8374789031
Rt18700 T3343 T3742 1508280.2472462337
Rt18701 T3343 T4039 891165.05224070663
Rt18702 T3343 T4134 3952005.9612427321
Gcorr6313 T3343 T4827 T3343 T4827 -7.3618689349192723e-08
Gcorr6314 T3343 T5138 T3343 T5138 -6.4788566964743659e-07
Gcorr6315 T3343 T5430 T3343 T5430 -4.5154435051452326e-08
Rt18703 T3343 T5783 3336194.9302939479
Rt18704 T3343 T5808 845415.22947651835
Rt18705 T3344 T3345 6735663.1258103903
Rt18706 T3344 T3782 1655694.2659425791
Rt18707 T3344 T3827 1780517.657106797
Rt18708 T3344 T4089 971342.186913613
Gcorr6316 T3344 T5094 T3344 T5094 -1.6470676504426114e-07
Rt18709 T3344 T5102 1632813.0997959664
Gcorr6317 T3344 T5105 T3344 T5105 -1.2917970571798325e-07
Rt18710 T3344 T5108 7702007.6001289999
Rt18711 T3344 T5668 4022349.5670374068
Rt18712 T3345 T3827 206656.21463710183
Rt18713 T3345 T4002 1461404.8663068835
Rt18714 T3345 T4081 2335342.8136589201
Rt18715 T3345 T4144 1225100.6743091128
Gcorr6318 T3345 T5108 T3345 T5108 -1.2562577152617946e-06
Gcorr6319 T3345 T5633 T3345 T5633 -6.321759580529045e-07
Rt18716 T3345 T5668 747753.19004926772
Rt18717 T3345 T5999 950643.33361423574
Rt18718 T3346 T3347 2299046.6948480331
Rt18719 T3346 T3529 3819109.9626080901
Rt18720 T3346 T3530 1485936.6837815745
Rt18721 T3346 T3910 1290066.8866289717
Gcorr6320 T3346 T5090 T3346 T5090 -8.7472809181065046e-08
Rt18722 T3346 T5093 3986693.9650520785
Rt18723 T3346 T5647 2247795.3522095806
Gcorr6321 T3346 T5648 T3346 T5648 -1.4452138089531735e-07
Rt18724 T3346 T5825 7009282.9007331012
Rt18725 T3347 T3348 2104586.1243290133
Rt18726 T3347 T3349 2137080.0567814321
Rt18727 T3347 T3493 2056919.49096353
Rt18728 T3347 T3910 1203610.4691599237
Rt18729 T3347 T5098 2089048.6455040849
Gcorr6322 T3347 T5631 T3347 T5631 -1.3759287348903182e-07
Gcorr6323 T3347 T5647 T3347 T5647 -1.2961856378388153e-07
Rt18730 T3347 T5648 3457733.8915802049
Rt18731 T3347 T5886 8099082.3460615054
Rt18732 T3348 T3349 4259347.0976659767
Rt18733 T3348 T3350 1799239.0539817195
Rt18734 T3348 T3786 6137714.3936817767
Rt18735 T3348 T4043 1840326.122714082
Gcorr6324 T3348 T5272 T3348 T5272 -3.2764220176626307e-08
Gcorr6325 T3348 T5648 T3348 T5648 -1.0852768645481254e-07
Rt18736 T3348 T5886 2233924.7976025403
Rt18737 T3348 T6051 2310519.1659644125
Rt18738 T3349 T3350 1293550.4792838194
Rt18739 T3349 T3351 1997041.4923686325
Rt18740 T3349 T3493 67386344.058757529
Rt18741 T3349 T4155 788806.6717919776
Rt18742 T3349 T5097 429753556.62839323
Rt18743 T3349 T5631 2213503.9727219744
Gcorr6326 T3349 T5861 T3349 T5861 -3.0014756672889706e-08
Rt18744 T3349 T5886 4723761.3935015248
Rt18745 T3350 T3351 4765296.63784674
Rt18746 T3350 T3401 4548339.1278994735
Rt18747 T3350 T3866 1926033.7909393257
Rt18748 T3350 T4043 3175329.8010073397
Rt18749 T3350 T5272 2765977.1033665277
Rt18750 T3350 T5861 1478377.5740492288
Gcorr6327 T3350 T5886 T3350 T5886 -1.5456159870842615e-07
Rt18751 T3351 T3401 2283390.9621815444
Rt18752 T3351 T3404 5017409.7324398775
Rt18753 T3351 T3405 1952131.0175991862
Rt18754 T3351 T3823 1429152.6569835821
Gcorr6328 T3351 T4155 T3351 T4155 -5.6316086620307692e-08
Rt18755 T3351 T5097 2881322.055695619
Gcorr6329 T3351 T5383 T3351 T5383 -6.4830909547075189e-08
Rt18756 T3351 T5857 5283407.5877340939
Rt18757 T3351 T5861 2748906.0582813891
Rt18758 T3352 T3354 1499718.2589041572
Rt18759 T3352 T3451 2435598.9361574245
Rt18760 T3352 T3587 1563989.3663888492
Rt18761 T3352 T4140 1546179.7429997418
Rt18762 T3352 T5010 3377605.2072065123
Gcorr6330 T3352 T5378 T3352 T5378 -1.3200299510323484e-07
Rt18763 T3352 T5379 3125039.8188498211
Gcorr6331 T3352 T5720 T3352 T5720 -3.4437731177782935e-08
Rt18764 T3353 T3453 2112211.3367777667
Rt18765 T3353 T3568 7555168.3502572589
Rt18766 T3353 T3852 8550202.1083430611
Rt18767 T3353 T4180 1055389.0401873963
Rt18768 T3353 T5201 3819965.3691457966
Rt18769 T3353 T5252 11343735.348643785
Rt18770 T3353 T5863 3415333.5066225994
Rt18771 T3353 T6064 6159539.3103505578
Rt18772 T3354 T3451 2714497.2404942699
Rt18773 T3354 T3871 1300909.7694261894
Rt18774 T3354 T3966 1436300.3621131701
Gcorr6332 T3354 T5010 T3354 T5010 -1.9854577792928174e-08
Gcorr6333 T3354 T5294 T3354 T5294 -9.6439213381380687e-09
Rt18775 T3354 T5378 1631068.490119359
Rt18776 T3354 T5941 20155722.666608099
Rt18777 T3355 T3567 1968106.0291865722
Rt18778 T3355 T3784 932162.38820674806
Rt18779 T3355 T5172 1157265.9060367772
Rt18780 T3355 T5777 989753.15648685745
Gcorr6334 T3355 T5913 T3355 T5913 -4.8321035889938061e-07
Rt18781 T3355 T5971 258620.77182105483
Rt18782 T3356 T3468 1708058.9115877452
Rt18783 T3356 T3619 1564237.5424979914
Rt18784 T3356 T4133 133793.50152063253
Gcorr6335 T3356 T4662 T3356 T4662 -4.1357577473726284e-08
Gcorr6336 T3356 T4751 T3356 T4751 -2.2598114734231603e-06
Rt18785 T3356 T5034 366163.53715751227
Rt18786 T3356 T5603 3584657.4487113594
Gcorr6337 T3356 T5677 T3356 T5677 -1.1823295188685728e-07
Rt18787 T3357 T3488 1607447.6000898683
Rt18788 T3357 T3697 1502448.3428333767
Rt18789 T3357 T4161 1053712.5058349718
Rt18790 T3357 T4759 54799197.319139056
Rt18791 T3357 T4941 10436999.875637904
Rt18792 T3357 T4942 641309.77313833439
Gcorr6338 T3357 T4991 T3357 T4991 -5.6067251277277789e-08
Gcorr6339 T3357 T5131 T3357 T5131 -1.0271661482321373e-06
Rt18793 T3358 T3400 2216825.3262494612
Rt18794 T3358 T3460 2065557.5572840394
Rt18795 T3358 T3547 7334515.0376781086
Rt18796 T3358 T3908 110942381.53089553
Rt18797 T3358 T4158 993914.19904602878
Rt18798 T3358 T4539 3489694.4201390292
Rt18799 T3358 T4541 25082040.307743892
Gcorr6340 T3358 T4550 T3358 T4550 -8.1775730222430366e-08
Rt18800 T3358 T5610 2303603.6484745131
Rt18801 T3359 T3670 1510672.1759551775
Rt18802 T3359 T3785 4705301.5715295617
Rt18803 T3359 T3805 1094622.2621010791
Rt18804 T3359 T3959 1122205.4699037191
Rt18805 T3359 T4754 5357864.9536045427
Gcorr6341 T3359 T5457 T3359 T5457 -1.1182626919073887e-07
Rt18806 T3359 T5630 11345224.951998416
Rt18807 T3359 T5723 2158596.2872059708
Gcorr6342 T3359 T6008 T3359 T6008 -9.0755941286476396e-08
Rt18808 T3360 T3361 1966248.3690516069
Rt18809 T3360 T3362 11896299.581384886
Rt18810 T3360 T3724 3123741.4416122101
Rt18811 T3360 T3918 1040473.0656898229
Rt18812 T3360 T4625 2498516.1403904213
Gcorr6343 T3360 T4712 T3360 T4712 -7.4108317901178525e-08
Rt18813 T3360 T4713 3265601.984268039
Rt18814 T3360 T5991 13038290.977862673
Rt18815 T3361 T3362 1428206.9346580859
Rt18816 T3361 T3363 3802544.6572691249
Rt18817 T3361 T3366 7350395.7238672124
Rt18818 T3361 T3970 733638.23471578304
Rt18819 T3361 T4712 3107646.1416256325
Gcorr6344 T3361 T4713 T3361 T4713 -2.4328969977040708e-08
Rt18820 T3361 T4843 1071897.7302390286
Gcorr6345 T3361 T6032 T3361 T6032 -4.4951651602186592e-07
Rt18821 T3362 T3363 1853452.3366736067
Rt18822 T3362 T3364 2385591.2757670786
Rt18823 T3362 T3666 2509010.5955990683
Rt18824 T3362 T3918 1258333.6329801842
Rt18825 T3362 T4713 2210836.9486008342
Gcorr6346 T3362 T4843 T3362 T4843 -1.8791666427125468e-07
Rt18826 T3362 T4865 4287641.3132162262
Rt18827 T3362 T5109 5534106.3161306735
Rt18828 T3363 T3364 4830100.579516869
Rt18829 T3363 T3365 1255090.0425372378
Rt18830 T3363 T3366 1526695.5956135599
Gcorr6347 T3363 T3621 T3363 T3621 -1.7473871559144651e-07
Rt18831 T3363 T4843 4967064.8399645695
Rt18832 T3363 T4865 2394707.3591642431
Rt18833 T3363 T5135 2180701.6148530506
Rt18834 T3364 T3365 147533.82092381633
Rt18835 T3364 T3367 965129.21212890022
Rt18836 T3364 T3368 5573961.4191095047
Rt18837 T3364 T3666 1208706.9734920533
Gcorr6348 T3364 T4030 T3364 T4030 -3.1300570831791414e-09
Rt18838 T3364 T4865 2007125.8526640276
Gcorr6349 T3364 T5109 T3364 T5109 -1.9264543656407289e-07
Rt18839 T3364 T5110 299898.83094066719
Gcorr6350 T3364 T5176 T3364 T5176 -6.0565069503294869e-07
Gcorr6351 T3364 T5826 T3364 T5826 -2.0776449271706012e-06
Rt18840 T3365 T3367 906301.27768864878
Rt18841 T3365 T3500 1350022.2104282391
Rt18842 T3365 T3621 386417.48471393058
Gcorr6352 T3365 T4865 T3365 T4865 -1.4265336172305201e-07
Gcorr6353 T3365 T5110 T3365 T5110 -2.0497233161632795e-06
Rt18843 T3365 T5135 23705093.831177987
Gcorr6354 T3365 T5176 T3365 T5176 -2.5650227621564956e-07
Rt18844 T3365 T5826 221269.7325053775
Gcorr6355 T3365 T5827 T3365 T5827 -1.0793640468296874e-06
Rt18845 T3366 T3621 2007634.8448496426
Rt18846 T3366 T3855 10337169.133240649
Rt18847 T3366 T3970 619939.51134752925
Gcorr6356 T3366 T4166 T3366 T4166 -3.5885265956648184e-08
Rt18848 T3366 T4843 2498695.7361416891
Rt18849 T3366 T5135 12413648.810022561
Rt18850 T3366 T5136 865566.98027208447
Gcorr6357 T3366 T6032 T3366 T6032 -3.4722429334873418e-07
Rt18851 T3367 T3368 684663.88830488827
Rt18852 T3367 T3369 429454.14960673318
Rt18853 T3367 T3500 1994548.7685783289
Rt18854 T3367 T3825 975179.03153936169
Gcorr6358 T3367 T5110 T3367 T5110 -5.565934248658868e-07
Gcorr6359 T3367 T5174 T3367 T5174 -6.178748039012885e-07
Rt18855 T3367 T5176 278113.83032947424
Gcorr6360 T3367 T5675 T3367 T5675 -9.9245075236318441e-08
Gcorr6361 T3367 T5826 T3367 T5826 -2.835693162971066e-07
Gcorr6362 T3367 T5966 T3367 T5966 -1.0505548655496198e-06
Rt18856 T3368 T3369 4621151.388975733
Rt18857 T3368 T4029 3939135.9116118727
Rt18858 T3368 T4030 1462822.7075939158
Rt18859 T3368 T4192 901464.35606764769
Rt18860 T3368 T5110 2918208.861937766
Gcorr6363 T3368 T5173 T3368 T5173 -1.1572357545369616e-07
Rt18861 T3368 T5174 961327.5258030385
Gcorr6364 T3368 T5176 T3368 T5176 -6.0961891259458277e-07
Rt18862 T3369 T3677 4141578.6593762306
Rt18863 T3369 T3678 901220.15984062897
Rt18864 T3369 T3825 1111425.904201651
Rt18865 T3369 T4029 3690726.926359266
Rt18866 T3369 T5174 4766586.1079108715
Gcorr6365 T3369 T5176 T3369 T5176 -1.0951126771600874e-06
Rt18867 T3369 T5187 30113213.53795696
Gcorr6366 T3369 T5646 T3369 T5646 -3.1665631588097568e-07
Rt18868 T3369 T5966 528420.15097994893
Rt18869 T3370 T3446 902218.19955842057
Rt18870 T3370 T3705 118608155.48200403
Rt18871 T3370 T3855 1265865.5417681276
Rt18872 T3370 T4166 733048.25753411232
Gcorr6367 T3370 T4229 T3370 T4229 -6.6388229117140107e-07
Rt18873 T3370 T5410 20608593.706112225
Rt18874 T3370 T5799 2309968.2562073474
Rt18875 T3370 T5816 4030693.3068536152
Rt18876 T3370 T5891 486294.87467331468
Gcorr6368 T3371 T3610 T3371 T3610 -2.1302001943471142e-07
Rt18877 T3371 T3824 1193286.777267738
Gcorr6369 T3371 T3888 T3371 T3888 -1.8720107777958935e-08
Rt18878 T3371 T4011 408981.01489700604
Rt18879 T3371 T4216 2023402.2675517073
Gcorr6370 T3371 T5296 T3371 T5296 -7.8899635781178812e-07
Rt18880 T3371 T5643 459590.44876290607
Rt18881 T3371 T6033 2009010.3804815186
Gcorr6371 T3372 T3373 T3372 T3373 -1.5715877849336543e-07
Rt18882 T3372 T3374 9366717.6712530404
Rt18883 T3372 T3772 2950254.010185461
Rt18884 T3372 T4124 947617.50338525744
Rt18885 T3372 T4202 2278704.8657796765
Gcorr6372 T3372 T4227 T3372 T4227 -7.7253136532023391e-07
Rt18886 T3372 T5177 112306925.14831401
Rt18887 T3372 T5376 442269.44919890462
Rt18888 T3372 T6013 3057939.6445610132
Rt18889 T3373 T3769 6038209.2898241822
Rt18890 T3373 T3770 26599372.431394883
Rt18891 T3373 T3772 426889.78846405662
Rt18892 T3373 T3817 624621.11027456378
Rt18893 T3373 T4124 1946446.5240220565
Rt18894 T3373 T4926 1364143.1618022446
Gcorr6373 T3373 T5119 T3373 T5119 -4.355890872715302e-07
Rt18895 T3373 T5177 972320.39662936295
Gcorr6374 T3373 T5217 T3373 T5217 -4.457349497317062e-07
Rt18896 T3374 T3375 6425969.3189824065
Rt18897 T3374 T3376 673125.60576209857
Rt18898 T3374 T3380 5704473.2572940132
Rt18899 T3374 T3772 764628.82071513892
Gcorr6375 T3374 T5217 T3374 T5217 -1.2100111487507273e-07
Rt18900 T3374 T5376 5537609.2576738801
Rt18901 T3374 T5782 851244.56853015092
Gcorr6376 T3374 T5785 T3374 T5785 -6.6094269895026962e-07
Rt18902 T3374 T6068 1385823.875583234
Rt18903 T3375 T3376 1114803.769230772
Rt18904 T3375 T3377 1984384.010866781
Rt18905 T3375 T3378 4097317.1714064884
Rt18906 T3375 T3963 959341.82788553205
Rt18907 T3375 T4227 99488104.111434013
Rt18908 T3375 T5276 1104495.0154139143
Rt18909 T3375 T5782 2036893.3238631734
Gcorr6377 T3375 T5785 T3375 T5785 -3.897033359476418e-07
Rt18910 T3375 T5877 2073022.6671548577
Gcorr6378 T3375 T6083 T3375 T6083 -3.6129723347091406e-07
Rt18911 T3376 T3377 2657942.3664893932
Rt18912 T3376 T3380 3001704.3090336886
Rt18913 T3376 T3383 6184188.2245893404
Rt18914 T3376 T3695 796002.04076283798
Rt18915 T3376 T4131 2425929.4768998334
Rt18916 T3376 T4958 4894183.9767266633
Gcorr6379 T3376 T5510 T3376 T5510 -2.0529034827625508e-07
Gcorr6380 T3376 T5511 T3376 T5511 -1.7003252182656054e-07
Gcorr6381 T3376 T5782 T3376 T5782 -5.0485782413113757e-07
Rt18917 T3376 T5785 499826.23306017037
Gcorr6382 T3376 T5877 T3376 T5877 -1.4105477218703116e-07
Gcorr6383 T3376 T6068 T3376 T6068 -2.8756579724898653e-07
Rt18918 T3377 T3378 1405442.3877053719
Rt18919 T3377 T3379 1641444.2922829345
Rt18920 T3377 T3383 2283595.3490284826
Rt18921 T3377 T3519 788512.65423274064
Gcorr6384 T3377 T4782 T3377 T4782 -2.0323822663536188e-07
Gcorr6385 T3377 T4834 T3377 T4834 -4.3267472744744041e-07
Rt18922 T3377 T4958 7799994.2401577299
Gcorr6386 T3377 T5276 T3377 T5276 -1.9884851182544124e-07
Rt18923 T3377 T5744 774365.17305806221
Rt18924 T3377 T5877 4617896.6186796268
Rt18925 T3378 T3379 2214466.1914419695
Rt18926 T3378 T3381 3883792.2106830827
Rt18927 T3378 T3382 1344165.8023311344
Rt18928 T3378 T3963 15316364.644695194
Rt18929 T3378 T5276 1759389.5568609356
Gcorr6387 T3378 T5744 T3378 T5744 -1.4811407381620158e-07
Rt18930 T3378 T5878 1939466.2280404922
Rt18931 T3379 T3381 2190927.2146679466
Rt18932 T3379 T3464 43137247.347288378
Rt18933 T3379 T3519 5509873.4891417548
Rt18934 T3379 T3528 10208510.0426386
Rt18935 T3379 T4110 1204206.9860927118
Rt18936 T3379 T4834 1602770.7783674477
Rt18937 T3379 T5594 5067003.4467623346
Gcorr6388 T3379 T5744 T3379 T5744 -1.708118807516038e-07
Rt18938 T3379 T5878 7082341.0477853082
Rt18939 T3380 T3695 2972954.3548996914
Rt18940 T3380 T3770 2938269.4701725333
Rt18941 T3380 T3772 1782959.8749130466
Rt18942 T3380 T3819 1159181.3549672009
Gcorr6389 T3380 T4838 T3380 T4838 -1.2387439684456032e-07
Rt18943 T3380 T5510 2590906.8695469657
Rt18944 T3380 T6060 3998811.1809823303
Rt18945 T3380 T6068 6861133.2552491603
Rt18946 T3381 T3382 1800379.3595578077
Rt18947 T3381 T3464 2243065.4240580099
Rt18948 T3381 T3465 2254989.9839752028
Rt18949 T3381 T4093 4496194.2108587194
Rt18950 T3381 T5277 1884748.1716467396
Rt18951 T3381 T5594 6354963.0189118152
Rt18952 T3381 T5878 4259233.1543552382
Gcorr6390 T3381 T5962 T3381 T5962 -4.4302231392016926e-08
Rt18953 T3382 T3963 708234.77719211741
Rt18954 T3382 T3984 3873674.1725521134
Rt18955 T3382 T4093 615496.08982759423
Rt18956 T3382 T5275 617888.67432722042
Gcorr6391 T3382 T5276 T3382 T5276 -3.2729778777219252e-08
Gcorr6392 T3382 T5277 T3382 T5277 -3.1181020747400174e-08
Rt18957 T3382 T5878 8348719.7414133595
Gcorr6393 T3382 T6083 T3382 T6083 -4.8585052835744556e-07
Rt18958 T3383 T3519 4485728.2900095098
Rt18959 T3383 T3716 1770137.360947432
Rt18960 T3383 T3860 5267881.2403108878
Rt18961 T3383 T4131 384566.06107000739
Rt18962 T3383 T4780 3001058.7554879584
Rt18963 T3383 T4782 13799312.819407236
Rt18964 T3383 T4958 1385211.4390848407
Gcorr6394 T3383 T5511 T3383 T5511 -6.2554351863998398e-07
Rt18965 T3384 T3520 2208154.3128207591
Rt18966 T3384 T3610 1748088.9756568982
Gcorr6395 T3384 T3979 T3384 T3979 -5.2955187601319042e-07
Rt18967 T3384 T4066 684450.64235861553
Rt18968 T3384 T4920 27677662.781534731
Rt18969 T3384 T5115 1206631.8064747241
Gcorr6396 T3384 T5256 T3384 T5256 -5.8150896206299275e-07
Gcorr6397 T3384 T5343 T3384 T5343 -5.6520419295201047e-07
Rt18970 T3384 T5917 324752.67197762989
Gcorr6398 T3385 T3386 T3385 T3386 -2.2687335226919597e-07
Rt18971 T3385 T3387 1464698.5699192204
Gcorr6399 T3385 T3783 T3385 T3783 -8.2321038763465516e-08
Rt18972 T3385 T4135 751473.25404140085
Rt18973 T3385 T4208 776881.78111882543
Rt18974 T3385 T5183 2225875.8731571278
Rt18975 T3385 T5564 1952820.2338038238
Gcorr6400 T3385 T6044 T3385 T6044 -3.5843720344832002e-07
Rt18976 T3386 T3602 1888930.7822264417
Rt18977 T3386 T3761 3454196.80046076
Rt18978 T3386 T3783 845568.74225572497
Rt18979 T3386 T4041 3187009.2318796827
Rt18980 T3386 T4135 957220.5257512203
Rt18981 T3386 T4981 9281035.79468593
Rt18982 T3386 T5564 5550379.5041640764
Rt18983 T3386 T5959 1440782.3502209021
Gcorr6401 T3386 T6024 T3386 T6024 -1.2397391305235275e-07
Rt18984 T3387 T3388 2264838.3676143731
Rt18985 T3387 T3389 7374954.1376805278
Rt18986 T3387 T3393 1862435.5672721558
Rt18987 T3387 T3783 363116.36574309453
Gcorr6402 T3387 T4208 T3387 T4208 -3.9493775669035613e-07
Rt18988 T3387 T5068 22124088.775972992
Rt18989 T3387 T5557 2166412.587463669
Gcorr6403 T3387 T5564 T3387 T5564 -4.2487479906536612e-07
Gcorr6404 T3387 T5840 T3387 T5840 -8.9204901074482382e-08
Gcorr6405 T3387 T6024 T3387 T6024 -5.4971768707949627e-07
Rt18990 T3387 T6044 442143.0117218424
Rt18991 T3388 T3389 1112206.4858863761
Rt18992 T3388 T3390 4342810.9360312279
Rt18993 T3388 T3391 388458.85230339516
Rt18994 T3388 T3967 2729661.6170929545
Rt18995 T3388 T5002 1276334.3471027205
Gcorr6406 T3388 T5218 T3388 T5218 -7.0616806933574789e-07
Rt18996 T3388 T5557 22505082.035850003
Gcorr6407 T3388 T5839 T3388 T5839 -4.1113164893814362e-07
Rt18997 T3388 T5840 696687.67345306266
Rt18998 T3389 T3390 1540346.063713908
Rt18999 T3389 T3393 2765175.9085102146
Rt19000 T3389 T3395 2006684.6189506473
Rt19001 T3389 T3721 2572167.7983657862
Rt19002 T3389 T4084 2780157.7585875997
Gcorr6408 T3389 T4970 T3389 T4970 -1.8804670695139321e-07
Gcorr6409 T3389 T5002 T3389 T5002 -4.9481365359737315e-07
Rt19003 T3389 T5556 5879923.7391522368
Rt19004 T3389 T5557 3186209.6105358559
Rt19005 T3389 T5839 903990.74576870073
Rt19006 T3390 T3391 732991.01336665277
Rt19007 T3390 T3392 6524281.9708072878
Rt19008 T3390 T3395 2390910.3404563395
Rt19009 T3390 T3538 1662665.5200656066
Rt19010 T3390 T4967 2011826.080181411
Rt19011 T3390 T4968 5643151.0516988263
Rt19012 T3390 T5002 1201869.5881579306
Gcorr6410 T3390 T5218 T3390 T5218 -5.2449119279733704e-07
Gcorr6411 T3390 T5839 T3390 T5839 -1.7547727786473634e-07
Rt19013 T3391 T3392 1515291.2570971958
Rt19014 T3391 T3394 3412949.8655743008
Rt19015 T3391 T3396 1108894.9722169973
Rt19016 T3391 T3967 791040.3403690753
Gcorr6412 T3391 T4967 T3391 T4967 -5.0039750987300009e-07
Gcorr6413 T3391 T5002 T3391 T5002 -3.8385627546124034e-07
Rt19017 T3391 T5218 344386.72270015109
Gcorr6414 T3391 T5840 T3391 T5840 -6.3824376555582633e-07
Gcorr6415 T3391 T5912 T3391 T5912 -4.3395055793892072e-07
Rt19018 T3392 T3394 2380284.0235704668
Rt19019 T3392 T3538 2306205.1021931046
Rt19020 T3392 T3583 6920532.3392641125
Rt19021 T3392 T3702 1327957.6134196941
Rt19022 T3392 T3981 54177635.67258925
Rt19023 T3392 T4964 40553138.081993192
Rt19024 T3392 T4967 2336376.6725351266
Gcorr6416 T3392 T5218 T3392 T5218 -1.1813154915700588e-07
Rt19025 T3392 T5881 2020895.4040619461
Rt19026 T3393 T3721 1667316.0404037202
Rt19027 T3393 T3722 1648514.1258807322
Rt19028 T3393 T3723 602869.48122066504
Rt19029 T3393 T3783 854834.94818044198
Rt19030 T3393 T4975 35452712.288321346
Gcorr6417 T3393 T4977 T3393 T4977 -4.4283794244018721e-07
Rt19031 T3393 T5068 620066.50967305712
Rt19032 T3393 T5556 15946625.513620615
Gcorr6418 T3393 T5557 T3393 T5557 -1.0921898856045923e-07
Gcorr6419 T3393 T6024 T3393 T6024 -5.276852134125172e-07
Rt19033 T3394 T3396 253459.37880593806
Rt19034 T3394 T3583 1780717.1594890922
Rt19035 T3394 T4105 810664.4086535736
Gcorr6420 T3394 T4224 T3394 T4224 -6.193894078238188e-07
Rt19036 T3394 T5218 2372990.8666269574
Rt19037 T3394 T5835 665280.96687601064
Rt19038 T3394 T5881 25217620.371467981
Gcorr6421 T3394 T5912 T3394 T5912 -5.6555085725630165e-07
Rt19039 T3395 T3538 1838502.8444016329
Rt19040 T3395 T3745 2079553.355230367
Rt19041 T3395 T3746 4797789.3970149402
Rt19042 T3395 T4084 1695568.8212522806
Rt19043 T3395 T4968 4494718.8374994034
Rt19044 T3395 T4969 10394733.05555445
Rt19045 T3395 T4970 3300342.9278669474
Gcorr6422 T3395 T5839 T3395 T5839 -9.1926749677453791e-08
Rt19046 T3396 T3967 3560291.5085840523
Rt19047 T3396 T4007 1540727.2892406823
Gcorr6423 T3396 T4105 T3396 T4105 -7.6255972751119908e-08
Rt19048 T3396 T4224 1126861.9087513317
Gcorr6424 T3396 T5218 T3396 T5218 -5.1432301816721421e-07
Gcorr6425 T3396 T5835 T3396 T5835 -7.5834070116334888e-07
Rt19049 T3396 T5912 582481.32698065042
Rt19050 T3397 T3515 1516210.2628640756
Rt19051 T3397 T4049 991325.46321984089
Rt19052 T3397 T4112 392063.18013226142
Rt19053 T3397 T5282 1215469.8909850998
Rt19054 T3397 T5284 1201753.5718513755
Gcorr6426 T3397 T5608 T3397 T5608 -9.367413149256553e-07
Rt19055 T3397 T5843 1473128.2022949702
Rt19056 T3398 T3528 1447129.7843092491
Rt19057 T3398 T3760 1495187.1242219566
Rt19058 T3398 T3851 2916896.0023467354
Gcorr6427 T3398 T4783 T3398 T4783 -4.3980724367313568e-07
Rt19059 T3398 T4943 720851.86861093703
Gcorr6428 T3398 T5666 T3398 T5666 -4.5769215088857709e-07
Gcorr6429 T3398 T5734 T3398 T5734 -1.239289812327009e-07
Gcorr6430 T3399 T3702 T3399 T3702 -3.0040429857412433e-08
Rt19060 T3399 T3759 4162542.2692359411
Rt19061 T3399 T3981 2281710.4397379542
Rt19062 T3399 T4085 1064977.359280901
Rt19063 T3399 T4965 1705198.6085122691
Gcorr6431 T3399 T5333 T3399 T5333 -3.9818652947289807e-09
Gcorr6432 T3399 T5334 T3399 T5334 -1.7407654053434116e-07
Rt19064 T3400 T3793 1821173.2151918432
Gcorr6433 T3400 T3794 T3400 T3794 -3.2170634045622002e-08
Rt19065 T3400 T3908 1099642.1103826917
Rt19066 T3400 T4197 898546.44866253331
Rt19067 T3400 T4538 2438376.3809119822
Gcorr6434 T3400 T4539 T3400 T4539 -1.0032327100553349e-07
Rt19068 T3400 T4550 3008959.6390664401
Gcorr6435 T3400 T4743 T3400 T4743 -9.1742520529606115e-08
Rt19069 T3401 T3823 3709978.0370122571
Rt19070 T3401 T3866 1915643.5198593705
Rt19071 T3401 T4033 674567.29851341352
Gcorr6436 T3401 T4226 T3401 T4226 -5.7142959900399297e-07
Rt19072 T3401 T5271 14833184.859579885
Rt19073 T3401 T5383 675091.15979446459
Rt19074 T3401 T5861 3855868.4900727766
Rt19075 T3402 T3427 31281412.816238888
Rt19076 T3402 T3921 1156742.6716619455
Rt19077 T3402 T4136 928507.75657711271
Gcorr6437 T3402 T5042 T3402 T5042 -2.050927199911882e-07
Rt19078 T3402 T5301 1875093.3970297272
Rt19079 T3402 T5761 585893.00490572723
Rt19080 T3403 T3707 20270784.758529823
Rt19081 T3403 T3846 17864612.771556493
Rt19082 T3403 T3921 2222072.3274164139
Rt19083 T3403 T4068 3073783.9132687375
Rt19084 T3403 T4126 995192.07432511088
Rt19085 T3403 T4136 550762.75423476729
Rt19086 T3403 T4863 30242928.020051535
Rt19087 T3403 T5042 1324844.9566957392
Rt19088 T3403 T5245 2091122.0679497418
Gcorr6438 T3403 T5301 T3403 T5301 -5.0181365969734126e-07
Rt19089 T3404 T3405 2064075.7188484445
Rt19090 T3404 T3406 1779036.2416876706
Gcorr6439 T3404 T3741 T3404 T3741 -4.3763000468585753e-08
Rt19091 T3404 T4119 1119462.2052161281
Rt19092 T3404 T4155 996440.44934816635
Gcorr6440 T3404 T5082 T3404 T5082 -5.7189070533106257e-09
Rt19093 T3404 T5083 6234397.7760740696
Rt19094 T3404 T5084 5773497.0204537623
Rt19095 T3404 T5097 5273538.8029829832
Rt19096 T3405 T3406 1779696.983417602
Rt19097 T3405 T3474 3954674.9297947632
Rt19098 T3405 T3475 1588577.863206953
Rt19099 T3405 T3823 1689779.8760009799
Rt19100 T3405 T5083 6350036.4690909209
Gcorr6441 T3405 T5097 T3405 T5097 -1.5499653460582462e-07
Rt19101 T3405 T5101 2805409.7138490025
Gcorr6442 T3405 T5819 T3405 T5819 -1.6998672062874924e-07
Rt19102 T3405 T5857 2390382.6344317077
Rt19103 T3406 T3474 1594539.2029128566
Rt19104 T3406 T3741 2238521.5162181188
Rt19105 T3406 T3849 1177788.4924146845
Rt19106 T3406 T5081 4043239.2916980516
Rt19107 T3406 T5082 5834420.8722534208
Rt19108 T3406 T5083 6071392.1252000416
Gcorr6443 T3406 T5101 T3406 T5101 -1.6780191282959615e-07
Rt19109 T3407 T3647 1908606.8163401766
Rt19110 T3407 T3954 2658040.9789422094
Rt19111 T3407 T4164 347078.36347559065
Gcorr6444 T3407 T4428 T3407 T4428 -1.2182971814519657e-07
Rt19112 T3407 T4908 4200874.3974998938
Rt19113 T3407 T4909 1008379.2227383619
Gcorr6445 T3407 T4910 T3407 T4910 -5.2936312877411785e-07
Gcorr6446 T3407 T4912 T3407 T4912 -1.9208091282271334e-07
Rt19114 T3408 T3457 2219874.9898165595
Rt19115 T3408 T4058 3447442.3932602247
Rt19116 T3408 T4076 1553672.5977694199
Rt19117 T3408 T4749 2109661.2355929427
Rt19118 T3408 T4986 1577928.7146178032
Rt19119 T3408 T4987 2398514.432390199
Rt19120 T3409 T3410 1659105.4431714446
Rt19121 T3409 T3412 4091230.1324241864
Rt19122 T3409 T3740 1439017.5229229785
Gcorr6447 T3409 T4792 T3409 T4792 -1.3493707627276872e-07
Rt19123 T3409 T4795 2316196.9212341458
Gcorr6448 T3409 T4847 T3409 T4847 -8.3070661210913935e-08
Rt19124 T3409 T5449 5487670.808771858
Rt19125 T3410 T3411 1727600.4497348217
Rt19126 T3410 T3412 1719792.1913465811
Rt19127 T3410 T3413 1688488.0809287303
Rt19128 T3410 T3707 3579159.2020835904
Gcorr6449 T3410 T4795 T3410 T4795 -1.1806661432214755e-07
Rt19129 T3410 T4846 2339269.8197453977
Rt19130 T3410 T4847 4149451.4866398377
Gcorr6450 T3410 T4848 T3410 T4848 -8.8693764345500429e-08
Rt19131 T3411 T3413 3331565.1389924739
Rt19132 T3411 T3414 1724787.4840423421
Rt19133 T3411 T3415 2008962.4711254616
Rt19134 T3411 T3592 3113826.9942254084
Gcorr6451 T3411 T4847 T3411 T4847 -1.0737241622870865e-07
Rt19135 T3411 T4848 2279743.3571594493
Rt19136 T3411 T4849 4290594.0780465798
Gcorr6452 T3411 T4850 T3411 T4850 -8.6065578183612115e-08
Rt19137 T3412 T3707 1764992.9285972239
Rt19138 T3412 T3740 1928870.9556599453
Rt19139 T3412 T3957 1249595.1069256898
Rt19140 T3412 T4068 2757528.1625642525
Gcorr6453 T3412 T4793 T3412 T4793 -1.5192064606059418e-07
Rt19141 T3412 T4795 4684536.9034826979
Rt19142 T3412 T4796 2291907.9560403829
Gcorr6454 T3412 T4846 T3412 T4846 -8.6217982402521716e-08
Rt19143 T3413 T3414 1309927.4073400355
Rt19144 T3413 T3707 1827315.4695163546
Rt19145 T3413 T3846 4685056.8165635755
Rt19146 T3413 T4126 1966874.5801341201
Gcorr6455 T3413 T4846 T3413 T4846 -1.1044906648020933e-07
Rt19147 T3413 T4848 3943329.8313343576
Gcorr6456 T3413 T5206 T3413 T5206 -3.0653432495889783e-08
Rt19148 T3413 T5772 2405736.6277887798
Rt19149 T3414 T3415 3836630.322031626
Rt19150 T3414 T3416 1752172.7236595941
Rt19151 T3414 T3417 1461486.157024469
Rt19152 T3414 T3846 158586269.67529547
Gcorr6457 T3414 T4848 T3414 T4848 -1.1158218443552011e-07
Rt19153 T3414 T4850 3578960.4379863292
Rt19154 T3414 T5206 1874735.4672660637
Gcorr6458 T3414 T5801 T3414 T5801 -5.5442600235927244e-08
Rt19155 T3415 T3416 1776669.3720584977
Rt19156 T3415 T3592 1518536.362677969
Rt19157 T3415 T3600 1687925.83840936
Rt19158 T3415 T3818 3645256.9224031502
Gcorr6459 T3415 T4849 T3415 T4849 -1.1300350556089513e-07
Rt19159 T3415 T4850 2385056.2594198864
Rt19160 T3415 T4851 3466837.8391373465
Gcorr6460 T3415 T4852 T3415 T4852 -8.541328421233902e-08
Rt19161 T3416 T3417 3569195.4627808244
Rt19162 T3416 T3418 1832788.6119256222
Rt19163 T3416 T3419 2664964.3647336941
Rt19164 T3416 T3600 3020078.8997652358
Gcorr6461 T3416 T4850 T3416 T4850 -1.1144372776069582e-07
Rt19165 T3416 T4852 3272368.2113484764
Gcorr6462 T3416 T5006 T3416 T5006 -4.1353790242751305e-08
Rt19166 T3416 T5801 2095786.4658883885
Rt19167 T3417 T3418 1700219.9813727944
Rt19168 T3417 T3434 1422888.170554867
Rt19169 T3417 T3846 1590755.5647568307
Gcorr6463 T3417 T5206 T3417 T5206 -3.8404612487779918e-08
Rt19170 T3417 T5771 15957861.285724988
Rt19171 T3417 T5801 2376779.4837454353
Rt19172 T3417 T5996 4002403.69965488
Rt19173 T3418 T3419 2058324.9156227012
Rt19174 T3418 T3420 1470603.4404495663
Rt19175 T3418 T3434 5409159.7570992392
Rt19176 T3418 T3952 694241.99714014935
Rt19177 T3418 T5006 1147664.7829846211
Gcorr6464 T3418 T5253 T3418 T5253 -2.0612590087615604e-07
Gcorr6465 T3418 T5602 T3418 T5602 -4.9985426819008879e-08
Rt19178 T3418 T5771 2219699.6548058493
Gcorr6466 T3418 T5801 T3418 T5801 -1.3746831219223494e-07
Gcorr6467 T3418 T6027 T3418 T6027 -1.0350173549213741e-07
Rt19179 T3419 T3420 4869499.5633517634
Rt19180 T3419 T3421 2212058.6279670652
Rt19181 T3419 T3511 2032699.0862478404
Rt19182 T3419 T3600 1476630.8044585935
Rt19183 T3419 T4063 13899979.626265399
Gcorr6468 T3419 T4852 T3419 T4852 -1.5422480155753907e-07
Rt19184 T3419 T4938 1793228.0443991232
Rt19185 T3419 T5006 7525593.7846052907
Gcorr6469 T3419 T5040 T3419 T5040 -1.3462978644708347e-07
Rt19186 T3419 T6027 2601228.7111110822
Rt19187 T3420 T3421 1970107.5638508329
Rt19188 T3420 T3458 1656776.3781910762
Rt19189 T3420 T3463 5522420.552730687
Rt19190 T3420 T3952 2984216.0571191185
Rt19191 T3420 T5602 1291635.3885002886
Gcorr6470 T3420 T5907 T3420 T5907 -1.4896316011695628e-07
Rt19192 T3420 T6027 4307674.2358186347
Rt19193 T3421 T3458 4764233.7422766406
Rt19194 T3421 T3459 2483825.3808922176
Rt19195 T3421 T3494 4660733.6784167625
Rt19196 T3421 T3511 3962004.4960092283
Rt19197 T3421 T4152 3514953.9966474851
Rt19198 T3421 T5040 2079870.1311103243
Rt19199 T3421 T5906 10217139.980474252
Rt19200 T3421 T5907 3230942.2583116931
Gcorr6471 T3421 T6027 T3421 T6027 -7.6054318827160459e-08
Rt19201 T3422 T3423 2024893.8646279182
Rt19202 T3422 T3433 27536372.088643558
Rt19203 T3422 T3507 1653876.4741403349
Gcorr6472 T3422 T4156 T3422 T4156 -8.7700748649148777e-08
Rt19204 T3422 T4163 488750.466150522
Rt19205 T3422 T4530 4575280.9939126708
Rt19206 T3422 T5436 1740862.4614673012
Gcorr6473 T3422 T5537 T3422 T5537 -6.8276283562260328e-10
Gcorr6474 T3422 T5718 T3422 T5718 -3.4835522501242515e-07
Rt19207 T3422 T6020 4959234.3931134734
Rt19208 T3423 T3507 1620450.2034956976
Rt19209 T3423 T3983 1243263.9425016581
Rt19210 T3423 T4067 7283289.9585888078
Rt19211 T3423 T4147 1270597.6887773038
Gcorr6475 T3423 T4531 T3423 T4531 -7.9638046712522378e-09
Rt19212 T3423 T4534 236473637.0074639
Rt19213 T3423 T5537 1859322.025366303
Rt19214 T3423 T6002 15576194.78670427
Gcorr6476 T3423 T6020 T3423 T6020 -1.1667795974029679e-07
Rt19215 T3424 T3500 3546645.5709156077
Rt19216 T3424 T3621 1816993.2966539038
Rt19217 T3424 T4190 1898419.6247109955
Rt19218 T3424 T4220 646056.9067008174
Rt19219 T3424 T5214 1352281.5865650021
Rt19220 T3424 T5827 3277001.3094413448
Rt19221 T3425 T3594 1478481.1608476394
Rt19222 T3425 T3747 3312746.2571943766
Rt19223 T3425 T4151 1024101.8002372286
Rt19224 T3425 T4643 3396177.6811342477
Rt19225 T3425 T4724 5449103.9047413515
Rt19226 T3425 T5692 25724981.901037645
Rt19227 T3426 T3442 3135249.1447272035
Rt19228 T3426 T3843 4431432.7566599352
Rt19229 T3426 T3927 1969518.6758136735
Rt19230 T3426 T4047 1020645.6804862744
Gcorr6477 T3426 T4302 T3426 T4302 -6.7345064097177661e-08
Rt19231 T3426 T4305 1094910.5287965664
Gcorr6478 T3426 T6017 T3426 T6017 -1.1569191912788843e-07
Rt19232 T3427 T3678 680722.77043929347
Gcorr6479 T3427 T3679 T3427 T3679 -6.8962585408497928e-08
Rt19233 T3427 T3825 995625.35221436399
Rt19234 T3427 T3921 1076905.6680564957
Rt19235 T3427 T5043 645622.27733447449
Rt19236 T3427 T5348 9459435.5411130749
Gcorr6480 T3427 T5645 T3427 T5645 -7.4554304047568656e-07
Rt19237 T3427 T5646 4053258.1918071732
Rt19238 T3427 T5761 5049860.9874875527
Rt19239 T3428 T3429 1159004.575071523
Rt19240 T3428 T3717 8426339.8153074775
Rt19241 T3428 T3718 1527340.0604712225
Rt19242 T3428 T4073 84404.588069138961
Rt19243 T3428 T4307 6879707.361523415
Gcorr6481 T3428 T5208 T3428 T5208 -3.730754251432576e-06
Rt19244 T3428 T5360 221909.68324166766
Gcorr6482 T3428 T5943 T3428 T5943 -2.6127114475541429e-07
Rt19245 T3429 T3573 1631801.015876818
Rt19246 T3429 T3717 1378289.6004238052
Rt19247 T3429 T3907 838160.25074709195
Gcorr6483 T3429 T4309 T3429 T4309 -1.017073460001655e-07
Gcorr6484 T3429 T4313 T3429 T4313 -1.5035475181391774e-07
Gcorr6485 T3429 T5360 T3429 T5360 -4.28143390381984e-07
Rt19248 T3429 T5943 911402.57220852235
Rt19249 T3430 T3951 1280434.917620803
Rt19250 T3430 T3978 1773291.6437435329
Rt19251 T3430 T3979 704218.62694696686
Rt19252 T3430 T4213 509975.65013311268
Rt19253 T3430 T5162 7403836.008873268
Rt19254 T3430 T5804 563769.65068872692
Rt19255 T3430 T6011 885553.15532392578
Rt19256 T3431 T3549 1220005.1390360186
Rt19257 T3431 T3564 2051897.5089494125
Rt19258 T3431 T3982 980641.18868216476
Rt19259 T3431 T4064 3253171.2549419948
Gcorr6486 T3431 T4088 T3431 T4088 -2.727382831383312e-08
Rt19260 T3431 T5192 1335942.4171866197
Gcorr6487 T3431 T5195 T3431 T5195 -1.7321241405676071e-07
Rt19261 T3431 T5303 3089524.4439736847
Gcorr6488 T3431 T5356 T3431 T5356 -1.3346304281362698e-07
Rt19262 T3432 T3537 3384863.4207809563
Rt19263 T3432 T3684 705191.29829535738
Rt19264 T3432 T3808 830670.30045542866
Rt19265 T3432 T4185 466667.60910449561
Gcorr6489 T3432 T4518 T3432 T4518 -2.2861096820929856e-07
Gcorr6490 T3432 T4520 T3432 T4520 -4.7247206683352973e-07
Gcorr6491 T3432 T4592 T3432 T4592 -2.8282661902415549e-07
Gcorr6492 T3432 T4647 T3432 T4647 -5.0716766420264724e-07
Rt19266 T3432 T5467 498400.69988515205
Rt19267 T3432 T5468 20030474.475902695
Rt19268 T3432 T5743 12924824.756905055
Gcorr6493 T3433 T3537 T3433 T3537 -8.0618069008396571e-09
Rt19269 T3433 T3692 3205445.4951087227
Rt19270 T3433 T4163 503351.47581668873
Rt19271 T3433 T4191 742284.03881770559
Rt19272 T3433 T5380 1970654.399683974
Rt19273 T3433 T5436 17103573.128885359
Gcorr6494 T3433 T5718 T3433 T5718 -2.5054294358728018e-07
Rt19274 T3433 T5767 8731834.9966428876
Rt19275 T3434 T3846 11435551.03568284
Rt19276 T3434 T3952 1197233.34612848
Rt19277 T3434 T4198 394509.45896059886
Rt19278 T3434 T4210 1282359.797473459
Gcorr6495 T3434 T5253 T3434 T5253 -4.5284552595240491e-07
Rt19279 T3434 T5771 735622.54642304126
Gcorr6496 T3434 T5996 T3434 T5996 -1.2668961824273012e-07
Rt19280 T3435 T3548 2735105.795330877
Rt19281 T3435 T3696 3634568.0085016694
Rt19282 T3435 T4177 1090711.0119062476
Rt19283 T3435 T4636 4088675.9427253189
Rt19284 T3435 T5469 11304407.217004362
Rt19285 T3435 T5470 3158712.1955412538
Gcorr6497 T3435 T5694 T3435 T5694 -1.1172266155518859e-07
Rt19286 T3436 T3839 3751097.1339285318
Rt19287 T3436 T3987 1854445.4206010706
Rt19288 T3436 T3998 1448151.3132269254
Gcorr6498 T3436 T5017 T3436 T5017 -2.1591961126354094e-07
Gcorr6499 T3436 T5310 T3436 T5310 -3.7191177178326203e-08
Rt19289 T3436 T5401 2240939.9246350606
Rt19290 T3436 T5758 1136178.1638046997
Rt19291 T3436 T5953 1962684.839380445
Rt19292 T3437 T3438 35633508.745029807
Gcorr6500 T3437 T3461 T3437 T3461 -1.3532514547698297e-07
Rt19293 T3437 T3882 1334948.0234259495
Rt19294 T3437 T4141 1221841.2357624099
Rt19295 T3437 T4170 6243068.0631273016
Rt19296 T3437 T5181 4402656.2597399047
Rt19297 T3437 T5822 6516107.7528673448
Rt19298 T3437 T5823 800055.01974602952
Rt19299 T3437 T6088 2927343.0178840542
Rt19300 T3438 T3473 17517030.564205535
Rt19301 T3438 T3882 1206111.0584562947
Rt19302 T3438 T4170 1282894.1824322483
Rt19303 T3438 T5213 5025937.626832325
Gcorr6501 T3438 T5821 T3438 T5821 -1.3730786961331006e-07
Rt19304 T3438 T5822 975692.97490377689
Rt19305 T3438 T5949 3645209.171401192
Rt19306 T3439 T3912 1527871.465733435
Rt19307 T3439 T3944 689359.40951049956
Rt19308 T3439 T4004 3772177.3205208331
Rt19309 T3439 T4044 5909790.3483679993
Rt19310 T3439 T5280 250310.78802327873
Gcorr6502 T3439 T6053 T3439 T6053 -7.9520165648147086e-08
Rt19311 T3439 T6086 11556550.413957646
Rt19312 T3440 T3441 3845603.9114606692
Rt19313 T3440 T3450 1409064.7650073443
Rt19314 T3440 T3899 2861853.3083660686
Rt19315 T3440 T3916 3510184.9506691541
Rt19316 T3440 T4262 2089031.4233586611
Rt19317 T3440 T4263 10342640.275238626
Rt19318 T3440 T4264 4149323.953471466
Gcorr6503 T3440 T4273 T3440 T4273 -1.6263255354220211e-07
Rt19319 T3441 T3899 1092317.2912539514
Rt19320 T3441 T4024 37950477.007795617
Rt19321 T3441 T4123 698339.23145865567
Rt19322 T3441 T4263 1922551.8569963288
Gcorr6504 T3441 T4265 T3441 T4265 -8.7419733831999908e-08
Gcorr6505 T3441 T4277 T3441 T4277 -9.8022524309913259e-08
Rt19323 T3441 T5661 6942850.9022987569
Rt19324 T3442 T3687 10168153.604166659
Rt19325 T3442 T3820 2506955.5940325349
Rt19326 T3442 T3890 636761.77903677325
Rt19327 T3442 T3927 1113510.0846647383
Gcorr6506 T3442 T4305 T3442 T4305 -7.3697881417473709e-08
Rt19328 T3442 T5255 1324225.8012416055
Gcorr6507 T3442 T5760 T3442 T5760 -3.3167985610892613e-07
Rt19329 T3442 T6017 4085790.060279137
Rt19330 T3443 T3605 2103133.3545222115
Rt19331 T3443 T3708 1007930.8887639121
Rt19332 T3443 T3834 1295373.9744464871
Rt19333 T3443 T3874 19923842.061300363
Gcorr6508 T3443 T4474 T3443 T4474 -2.080172736652302e-07
Rt19334 T3443 T4476 2106249.6631993009
Rt19335 T3443 T4841 2012530.7327172246
Gcorr6509 T3443 T5247 T3443 T5247 -1.4499575708324484e-07
Rt19336 T3444 T3601 2048396.5556548757
Rt19337 T3444 T3926 754327.85160448076
Rt19338 T3444 T4219 2230154.4200504003
Rt19339 T3444 T5321 254053.74728930148
Gcorr6510 T3444 T5757 T3444 T5757 -8.3869479826220084e-07
Rt19340 T3445 T3737 1571280.4556354727
Rt19341 T3445 T3880 1218169.9740343643
Rt19342 T3445 T3955 1480348.6604738995
Rt19343 T3445 T5202 1933053.0002073788
Gcorr6511 T3445 T5204 T3445 T5204 -1.2237528644840597e-07
Gcorr6512 T3445 T5649 T3445 T5649 -1.6642153516294456e-07
Rt19344 T3445 T5750 3483397.0030130432
Rt19345 T3446 T3705 923381.37892045954
Gcorr6513 T3446 T3855 T3446 T3855 -4.3520760406716509e-07
Rt19346 T3446 T4229 126179.46402096911
Rt19347 T3446 T5403 6445617.2919598827
Gcorr6514 T3446 T5799 T3446 T5799 -1.1137615142358651e-07
Gcorr6515 T3446 T5891 T3446 T5891 -6.591827114523671e-07
Rt19348 T3447 T3472 1318729.6297955995
Rt19349 T3447 T3566 1029894.4679159957
Rt19350 T3447 T3606 1537739.13216557
Gcorr6516 T3447 T3892 T3447 T3892 -2.9571937696551061e-08
Rt19351 T3447 T5126 3549768.4981484683
Gcorr6517 T3447 T5304 T3447 T5304 -9.6327131524906726e-08
Rt19352 T3447 T5305 1642873.9041860541
Gcorr6518 T3447 T5320 T3447 T5320 -1.6093813769432749e-07
Rt19353 T3447 T6046 12183357.494049156
Rt19354 T3448 T3449 1613228.5355234751
Rt19355 T3448 T3891 4528954.1655307654
Rt19356 T3448 T4109 940499.08420684189
Rt19357 T3448 T4321 3681166.8199342792
Rt19358 T3448 T4322 3119657.3990174322
Gcorr6519 T3448 T4323 T3448 T4323 -4.3876543476416937e-08
Rt19359 T3449 T3923 2515256.6084862244
Rt19360 T3449 T4016 1037239.9913287617
Gcorr6520 T3449 T4322 T3449 T4322 -1.3518508926887781e-07
Rt19361 T3449 T4323 2426092.8268795139
Rt19362 T3449 T4324 3229942.5638826224
Rt19363 T3449 T4325 12487743.251387672
Gcorr6521 T3449 T5730 T3449 T5730 -1.369441125558993e-07
Rt19364 T3450 T3901 75221685.045688137
Rt19365 T3450 T3916 564640.31708435423
Rt19366 T3450 T4169 558595.46820347093
Gcorr6522 T3450 T4262 T3450 T4262 -4.0492441021184544e-07
Rt19367 T3450 T4273 753652.22094413557
Gcorr6523 T3450 T5458 T3450 T5458 -1.743236444128573e-07
Gcorr6524 T3450 T5737 T3450 T5737 -1.6151575638934403e-07
Gcorr6525 T3450 T6014 T3450 T6014 -1.2423138578248209e-07
Rt19368 T3451 T3947 1015361.7019978315
Rt19369 T3451 T4140 823493.71162304317
Gcorr6526 T3451 T4630 T3451 T4630 -9.9466181548616338e-08
Rt19370 T3451 T5378 2808431.9582859552
Gcorr6527 T3451 T5379 T3451 T5379 -1.3303955854915072e-07
Rt19371 T3451 T5696 2831458.7006831393
Rt19372 T3452 T3513 1718847.6803686281
Rt19373 T3452 T3832 1089437.3942780294
Gcorr6528 T3452 T5007 T3452 T5007 -1.4786313088510591e-07
Rt19374 T3452 T5227 2489391.2184107923
Rt19375 T3452 T5420 5988332.0441550696
Rt19376 T3452 T6023 4678737.5572327459
Rt19377 T3453 T3568 1740347.9768991855
Rt19378 T3453 T3857 4353399.9463286679
Rt19379 T3453 T4022 928317.74496488739
Gcorr6529 T3453 T4734 T3453 T4734 -1.2882051115839393e-07
Rt19380 T3453 T5179 227167239.68136531
Rt19381 T3453 T5201 7865465.8993452266
Rt19382 T3453 T5445 1800131.4137908383
Rt19383 T3453 T5863 21327543.409479093
Gcorr6530 T3454 T3455 T3454 T3455 -3.0441083630851191e-08
Rt19384 T3454 T3896 1255943.5448534118
Rt19385 T3454 T3945 1140060.4850391715
Gcorr6531 T3454 T3946 T3454 T3946 -8.8769627222946434e-08
Rt19386 T3454 T4937 9034404.6900866739
Rt19387 T3454 T5014 782106.80534481304
Rt19388 T3454 T5687 19554453.641655136
Rt19389 T3454 T5793 3105865.8848341489
Rt19390 T3455 T3456 919382.863133915
Rt19391 T3455 T3896 1260604.6232452011
Rt19392 T3455 T4953 9696556.9569578189
Rt19393 T3455 T5014 2594395.7505186037
Rt19394 T3455 T5049 515223.3798048973
Gcorr6532 T3455 T5261 T3455 T5261 -5.3043728564748876e-08
Gcorr6533 T3455 T5892 T3455 T5892 -2.8379789040314349e-07
Gcorr6534 T3455 T5973 T3455 T5973 -3.472348567441707e-07
Rt19395 T3456 T4046 25940714.771322858
Rt19396 T3456 T5049 5176434.8824814456
Rt19397 T3456 T5576 435170.21107858885
Gcorr6535 T3456 T5892 T3456 T5892 -4.1663958341126253e-07
Rt19398 T3456 T5973 503102.95260645618
Rt19399 T3457 T3536 2418621.8919570199
Rt19400 T3457 T4058 842748.7362940677
Rt19401 T3457 T4168 4347735.3402837897
Gcorr6536 T3457 T4749 T3457 T4749 -1.211237709013901e-07
Rt19402 T3457 T4987 48279458.57165172
Rt19403 T3457 T5259 1477190.8849658675
Rt19404 T3457 T5995 1770967.6728127799
Gcorr6537 T3457 T6070 T3457 T6070 -1.2278450921451802e-07
Rt19405 T3458 T3459 1782119.1095233795
Rt19406 T3458 T3463 1508278.6010178977
Rt19407 T3458 T3761 611006.14862834523
Rt19408 T3458 T4225 1973574.1129568196
Gcorr6538 T3458 T5368 T3458 T5368 -2.0114307724509645e-07
Gcorr6539 T3458 T5602 T3458 T5602 -4.0972218443895293e-08
Gcorr6540 T3458 T5685 T3458 T5685 -1.1722504476377179e-07
Rt19409 T3458 T5907 1164588.8271943207
Rt19410 T3459 T3494 2434761.8075155751
Rt19411 T3459 T3546 1804370.086044322
Rt19412 T3459 T3602 1253692.841357067
Rt19413 T3459 T3761 3167893.9652541955
Rt19414 T3459 T5143 12900052.038892195
Gcorr6541 T3459 T5575 T3459 T5575 -1.5764370612594048e-07
Rt19415 T3459 T5685 1321925.0618347516
Rt19416 T3459 T5906 6861538.1961425161
Gcorr6542 T3459 T5907 T3459 T5907 -1.346271427614996e-07
Rt19417 T3460 T3547 3494252.6224062182
Rt19418 T3460 T3854 2489120.2298185369
Rt19419 T3460 T3996 1289645.192189991
Rt19420 T3460 T4078 2219592.6603808179
Rt19421 T3460 T4541 4055120.7246582373
Rt19422 T3460 T4543 21205250.737567674
Rt19423 T3460 T5548 2938727.175142373
Gcorr6543 T3460 T5610 T3460 T5610 -9.6945669523096781e-08
Rt19424 T3461 T3462 781034.33760327206
Rt19425 T3461 T4113 1161699.1645268248
Rt19426 T3461 T4141 1086080.3497217461
Rt19427 T3461 T5018 2156209.5506179268
Gcorr6544 T3461 T5619 T3461 T5619 -4.8392809548661587e-07
Rt19428 T3461 T5823 5015228.5939953253
Rt19429 T3461 T5922 1176340.4655072053
Rt19430 T3461 T5947 2451397.6751934071
Gcorr6545 T3462 T4113 T3462 T4113 -1.9372725523109285e-07
Rt19431 T3462 T4150 405458.57437513344
Rt19432 T3462 T5018 10782880.606672937
Gcorr6546 T3462 T5019 T3462 T5019 -1.9021930133074146e-07
Rt19433 T3462 T5619 281361.1971574566
Gcorr6547 T3462 T5817 T3462 T5817 -1.3533832061126195e-07
Rt19434 T3462 T5922 8703768.0424265359
Rt19435 T3463 T3952 1078732.5063254908
Gcorr6548 T3463 T4198 T3463 T4198 -2.2914030691453975e-07
Rt19436 T3463 T4225 862679.1828561608
Rt19437 T3463 T5253 2067980.6428464358
Rt19438 T3463 T5602 5255895.8028914761
Rt19439 T3464 T3465 2221686.8192332443
Rt19440 T3464 T3466 4512268.0535239493
Rt19441 T3464 T4110 897670.16195337463
Rt19442 T3464 T4945 2201474.2448299741
Rt19443 T3464 T5594 6172117.609912117
Gcorr6549 T3464 T5676 T3464 T5676 -1.2695839515177009e-07
Rt19444 T3464 T5962 3663612.5246362407
Rt19445 T3465 T4045 1123591.6101420377
Rt19446 T3465 T4046 5140615.4871029723
Rt19447 T3465 T4093 1391884.5900690239
Rt19448 T3465 T5277 13215589.660175294
Rt19449 T3465 T5278 3411277.0014132466
Rt19450 T3465 T5676 9149597.4239296801
Rt19451 T3465 T5962 2562862.1544694304
Rt19452 T3466 T3760 13878293.96717478
Rt19453 T3466 T3780 1125587.2730165545
Rt19454 T3466 T3851 1075565.6047062539
Gcorr6550 T3466 T4110 T3466 T4110 -7.6808205944786265e-08
Rt19455 T3466 T4944 3160156.7905710712
Rt19456 T3466 T4945 3977309.6921050921
Rt19457 T3466 T4946 4503382.3081399333
Gcorr6551 T3466 T5003 T3466 T5003 -1.4777457541091395e-07
Rt19458 T3467 T3557 2908565.7220394588
Rt19459 T3467 T3811 1212602.7320937212
Gcorr6552 T3467 T4725 T3467 T4725 -1.9237903012307358e-07
Rt19460 T3467 T4933 1551185.8154312719
Gcorr6553 T3467 T5606 T3467 T5606 -1.9058572582988407e-07
Rt19461 T3467 T5712 5109068.3950772053
Rt19462 T3467 T5780 6348963.4219216341
Rt19463 T3468 T3652 1359930.1079883238
Gcorr6554 T3468 T3903 T3468 T3903 -9.6870378082836581e-08
Rt19464 T3468 T4114 935007.60123744956
Gcorr6555 T3468 T5197 T3468 T5197 -5.588179485195776e-09
Rt19465 T3468 T5603 4349228.8407534594
Rt19466 T3468 T5677 3540075.7023523012
Rt19467 T3469 T3470 2706011.3515724223
Rt19468 T3469 T3471 34073727.226188831
Rt19469 T3469 T4174 782521.89374771726
Rt19470 T3469 T4397 3448755.2541685821
Gcorr6556 T3469 T4616 T3469 T4616 -9.5903387255459376e-08
Rt19471 T3469 T4617 497397.1240192299
Gcorr6557 T3469 T4618 T3469 T4618 -1.1539905441743832e-06
Rt19472 T3469 T5919 23726507.627594519
Rt19473 T3470 T3471 18990460.518477995
Rt19474 T3470 T3504 11221540.551078383
Rt19475 T3470 T3743 636970.78220974084
Rt19476 T3470 T4017 999858.13611301885
Gcorr6558 T3470 T4392 T3470 T4392 -5.0753735114969664e-07
Rt19477 T3470 T4395 1403844.7451278314
Rt19478 T3470 T4397 16857517.436884053
Rt19479 T3470 T5597 3498244.9982100502
Rt19480 T3470 T5919 4257526.9000206031
Rt19481 T3471 T3682 60288186.909621686
Rt19482 T3471 T3868 4110990.5152633069
Rt19483 T3471 T3961 2098134.0551393796
Rt19484 T3471 T4017 1197249.5812994291
Rt19485 T3471 T4174 1062263.2017698209
Rt19486 T3471 T4396 11299941.104905127
Rt19487 T3471 T4397 2604918.017010259
Rt19488 T3471 T4398 3547014.3370308951
Rt19489 T3472 T3841 1808292.0655513012
Rt19490 T3472 T3892 1313842.5341704816
Rt19491 T3472 T3937 1143034.6872862512
Rt19492 T3472 T5304 1996643.7867647226
Gcorr6559 T3472 T5305 T3472 T5305 -1.5389885182469728e-07
Rt19493 T3472 T5419 5807826.9390422599
Rt19494 T3472 T5578 10169606.017000867
Rt19495 T3473 T4104 1149283.1447253888
Rt19496 T3473 T4170 845888.13813976361
Rt19497 T3473 T5171 1118864.5473617383
Rt19498 T3473 T5949 751883.01374331443
Rt19499 T3474 T3475 1844110.8073864137
Rt19500 T3474 T3476 2286916.1982954969
Gcorr6560 T3474 T3849 T3474 T3849 -8.6467966583850969e-09
Rt19501 T3474 T3992 2925884.1246165601
Gcorr6561 T3474 T5078 T3474 T5078 -4.267423862304856e-07
Rt19502 T3474 T5081 3559069.5773561802
Rt19503 T3474 T5101 3202883.8499251059
Rt19504 T3474 T5529 1827459.5971714316
Gcorr6562 T3474 T5818 T3474 T5818 -1.1982509723996384e-07
Rt19505 T3475 T3476 3858312.8096099207
Rt19506 T3475 T3477 1819682.8627132
Rt19507 T3475 T3823 4995340.5325789815
Rt19508 T3475 T4052 3655725.1177346143
Gcorr6563 T3475 T5101 T3475 T5101 -9.1215269132127812e-09
Rt19509 T3475 T5818 4174138.1500326302
Rt19510 T3475 T5819 2994048.1786681064
Rt19511 T3476 T3477 1917671.7228017265
Rt19512 T3476 T3478 2212798.7336208811
Rt19513 T3476 T3674 4034040.0914507355
Rt19514 T3476 T3992 1199121.3195580423
Gcorr6564 T3476 T5529 T3476 T5529 -9.2506551731326455e-08
Rt19515 T3476 T5572 2477951.3983122441
Rt19516 T3476 T5818 3191311.2076938255
Gcorr6565 T3476 T6059 T3476 T6059 -7.6767916763094446e-08
Rt19517 T3477 T3478 4125610.1947685741
Rt19518 T3477 T3479 529795.58959208347
Rt19519 T3477 T4052 1170623.2275036529
Rt19520 T3477 T4053 4426586.8495091358
Rt19521 T3477 T5381 1729480.9248171384
Rt19522 T3477 T5818 10271394.026711181
Gcorr6566 T3477 T5819 T3477 T5819 -1.6857777096051376e-07
Gcorr6567 T3477 T5960 T3477 T5960 -8.8583902401120016e-07
Rt19523 T3477 T6059 972239.61233409878
Rt19524 T3478 T3479 1779504.043690233
Rt19525 T3478 T3480 1979006.6154639379
Rt19526 T3478 T3483 2000791.3700895852
Rt19527 T3478 T3674 1748708.5105886136
Rt19528 T3478 T4025 39510753.904318973
Rt19529 T3478 T5100 1461037.4496075551
Gcorr6568 T3478 T5572 T3478 T5572 -1.2963279002813413e-07
Rt19530 T3478 T5960 20410900.196260471
Gcorr6569 T3478 T5961 T3478 T5961 -1.282149005987841e-07
Rt19531 T3478 T6059 3094439.7921360997
Rt19532 T3479 T3480 1733392.098953489
Rt19533 T3479 T3613 1829545.0219641037
Rt19534 T3479 T3807 7458117.8815914998
Rt19535 T3479 T4053 1343812.9631685263
Rt19536 T3479 T5266 4297582.5191410724
Gcorr6570 T3479 T5351 T3479 T5351 -8.56091612616388e-08
Gcorr6571 T3479 T5381 T3479 T5381 -7.5769290015793976e-08
Rt19537 T3479 T5960 596959.62370178662
Gcorr6572 T3479 T6059 T3479 T6059 -8.6927485683225004e-07
Rt19538 T3480 T3483 4599292.3212114191
Rt19539 T3480 T3484 3325323.9786209301
Rt19540 T3480 T3585 1508181.9054145538
Rt19541 T3480 T3613 5501898.1386738755
Rt19542 T3480 T5351 3275760.9458264303
Gcorr6573 T3480 T5960 T3480 T5960 -1.2088674761917899e-07
Rt19543 T3480 T5961 1573496.9712095188
Gcorr6574 T3481 T3482 T3481 T3482 -6.4487985409168543e-08
Rt19544 T3481 T3585 609935.376588432
Rt19545 T3481 T3613 2408668.2231559833
Rt19546 T3481 T4200 5336319.9172276678
Rt19547 T3481 T4207 619265.00529020512
Gcorr6575 T3481 T5405 T3481 T5405 -5.4816074711671756e-07
Gcorr6576 T3481 T5605 T3481 T5605 -5.3128163018776927e-07
Rt19548 T3481 T5859 996190.86474894953
Rt19549 T3482 T3585 1349194.4167024626
Gcorr6577 T3482 T3586 T3482 T3586 -2.2506250553532004e-08
Rt19550 T3482 T3771 17386968.638708245
Rt19551 T3482 T3817 620833.88496945868
Rt19552 T3482 T4092 524389.21571729425
Gcorr6578 T3482 T5119 T3482 T5119 -3.8846432910567795e-07
Rt19553 T3482 T5605 9141188.2889556922
Rt19554 T3482 T5859 1228598.5181558088
Rt19555 T3482 T5927 996426.15239489661
Gcorr6579 T3482 T5938 T3482 T5938 -4.1972763821429142e-07
Rt19556 T3483 T3484 2191467.8413833315
Rt19557 T3483 T3949 1039182.5597413417
Rt19558 T3483 T4025 977661.81557005073
Gcorr6580 T3483 T5071 T3483 T5071 -6.2799836716312914e-08
Rt19559 T3483 T5072 2405669.6011524685
Gcorr6581 T3483 T5100 T3483 T5100 -7.7834702552392179e-08
Rt19560 T3483 T5961 4356549.4824074339
Rt19561 T3484 T3585 1640206.9466687359
Gcorr6582 T3484 T3586 T3484 T3586 -1.5879328084378018e-07
Rt19562 T3484 T3604 1336128.9309555741
Rt19563 T3484 T3949 8059478.8387655653
Rt19564 T3484 T4092 750312.77222074894
Gcorr6583 T3484 T4948 T3484 T4948 -1.861327364911194e-08
Rt19565 T3484 T5071 1440284.6461135827
Gcorr6584 T3484 T5605 T3484 T5605 -2.9067660157217196e-08
Gcorr6585 T3484 T5938 T3484 T5938 -1.1084485641488454e-08
Rt19566 T3484 T5961 14078700.580824483
Gcorr6586 T3485 T3486 T3485 T3486 -1.9482236979570721e-07
Rt19567 T3485 T3787 1100505.9252255752
Rt19568 T3485 T4057 1690767.9429046144
Rt19569 T3485 T4833 21304255.20911213
Rt19570 T3485 T5067 828577.63839594601
Rt19571 T3485 T5903 763129.47084907629
Rt19572 T3486 T3787 1480179.6734707581
Rt19573 T3486 T3993 1390991.4856497624
Rt19574 T3486 T4130 767942.3193245033
Rt19575 T3486 T5067 822962.70627685857
Rt19576 T3486 T5359 615175.03703631856
Rt19577 T3486 T5386 2407039.0132443449
Rt19578 T3487 T3688 5107924.8914761255
Rt19579 T3487 T3948 4582674.4944643397
Rt19580 T3487 T3989 5006301.9928173274
Gcorr6587 T3487 T4268 T3487 T4268 -4.1591459310607363e-07
Rt19581 T3487 T4270 972303.41284577164
Rt19582 T3487 T4274 1622254.6794865865
Rt19583 T3487 T5624 2405671.8099990501
Rt19584 T3487 T6037 9710080.0779878031
Rt19585 T3488 T3657 1558576.4919608128
Gcorr6588 T3488 T3902 T3488 T3902 -6.3115983309096244e-08
Rt19586 T3488 T4118 1014695.9137202413
Gcorr6589 T3488 T4759 T3488 T4759 -7.7776997675691576e-07
Gcorr6590 T3488 T4940 T3488 T4940 -1.1230520116431977e-07
Rt19587 T3488 T4941 767753.64637525845
Gcorr6591 T3488 T5123 T3488 T5123 -4.1341206566613616e-08
Rt19588 T3488 T5682 7336116.5057024127
Rt19589 T3489 T3490 4553776.3896234576
Rt19590 T3489 T3630 1970287.8035613752
Rt19591 T3489 T3751 1315779.0673950536
Rt19592 T3489 T4070 2522800.5582872573
Rt19593 T3489 T4895 4847135.7961323122
Rt19594 T3489 T4896 5229047.7515104348
Rt19595 T3489 T4901 1992870.7781091724
Gcorr6592 T3489 T4902 T3489 T4902 -1.3187762391097617e-07
Gcorr6593 T3489 T4957 T3489 T4957 -1.068982669481065e-07
Rt19596 T3490 T3645 2615008.6459341454
Rt19597 T3490 T3997 865088.08070115687
Rt19598 T3490 T4070 903654.16739482386
Rt19599 T3490 T4892 13816001.233972818
Gcorr6594 T3490 T4894 T3490 T4894 -8.5781567946054326e-08
Rt19600 T3490 T4895 1936788.7888233666
Rt19601 T3490 T5792 14004362.424834924
Rt19602 T3491 T3497 2340087.4433995034
Rt19603 T3491 T3498 5771749.2293323744
Rt19604 T3491 T3901 1256843.1324163626
Rt19605 T3491 T4127 2730562.7395862779
Rt19606 T3491 T5137 5326188.9393642452
Rt19607 T3491 T5215 8570478.7619577758
Rt19608 T3491 T5246 1663922.4732668339
Gcorr6595 T3491 T5688 T3491 T5688 -1.1997267844800123e-08
Gcorr6596 T3491 T5856 T3491 T5856 -1.1274449646124458e-07
Rt19609 T3492 T3815 1797252.8231943089
Rt19610 T3492 T4022 1204235.6242928524
Rt19611 T3492 T4178 1021356.7941990198
Rt19612 T3492 T4631 13248393.4862062
Rt19613 T3492 T4691 18824353.771315958
Rt19614 T3492 T4692 2171383.9168050578
Gcorr6597 T3492 T4733 T3492 T4733 -1.6262313812385672e-07
Rt19615 T3492 T4757 22298148.803373188
Rt19616 T3493 T3685 1333289.7532784983
Rt19617 T3493 T3910 555541.60177812609
Rt19618 T3493 T4119 929271.1735263248
Rt19619 T3493 T4155 510713.14691518841
Gcorr6598 T3493 T5084 T3493 T5084 -4.3442408066282178e-07
Rt19620 T3493 T5086 554126.71833246655
Gcorr6599 T3493 T5088 T3493 T5088 -8.0213221251162661e-07
Gcorr6600 T3493 T5098 T3493 T5098 -1.179057054086838e-07
Gcorr6601 T3493 T5631 T3493 T5631 -5.8891512920941742e-09
Rt19621 T3494 T3546 12171699.181145156
Rt19622 T3494 T3789 14892216.816206606
Rt19623 T3494 T4152 857886.46294332366
Rt19624 T3494 T4167 949592.0496121787
Rt19625 T3494 T5143 20210929.728816535
Rt19626 T3494 T5581 6724433.5392217292
Rt19627 T3494 T5906 3855658.1134419362
Gcorr6602 T3495 T3591 T3495 T3591 -4.6153200136122692e-07
Rt19628 T3495 T3946 1047186.9956811019
Rt19629 T3495 T3950 227769.85199925935
Rt19630 T3495 T4215 345638.34659984516
Gcorr6603 T3495 T5339 T3495 T5339 -2.4074231708910507e-06
Rt19631 T3495 T5926 10199308.56528732
Rt19632 T3495 T5930 292153.21599688701
Gcorr6604 T3495 T5989 T3495 T5989 -1.8759422974734139e-07
Rt19633 T3496 T3986 4791835.9925159207
Rt19634 T3496 T3987 1140016.5652214154
Rt19635 T3496 T4233 12447438.038740179
Rt19636 T3496 T5714 399506.14984726213
Rt19637 T3496 T5910 869037.32303445064
Rt19638 T3497 T3498 1884912.3811610295
Rt19639 T3497 T3555 2837669.370769674
Rt19640 T3497 T3948 1500654.4248104531
Gcorr6605 T3497 T5137 T3497 T5137 -5.7317630137462812e-08
Rt19641 T3497 T5638 2612673.5624825424
Rt19642 T3497 T5856 2274247.2270093383
Gcorr6606 T3497 T5958 T3497 T5958 -4.3323134208965576e-08
Rt19643 T3498 T3555 422804.16128284216
Rt19644 T3498 T3641 1904947.0129372412
Rt19645 T3498 T3813 3928000.1952800285
Rt19646 T3498 T4127 997888.29347389471
Gcorr6607 T3498 T4905 T3498 T4905 -5.087382452246845e-08
Rt19647 T3498 T5011 10533758.86073616
Rt19648 T3498 T5137 659918.9327368564
Gcorr6608 T3498 T5638 T3498 T5638 -1.0718191478413139e-06
Rt19649 T3499 T3800 1268691.4344308481
Rt19650 T3499 T3801 1246664.8077670122
Rt19651 T3499 T4327 13541637.477838166
Gcorr6609 T3499 T4329 T3499 T4329 -5.3357062680122867e-09
Rt19652 T3499 T4345 1045215.3380322268
Gcorr6610 T3499 T4352 T3499 T4352 -3.4994126939953032e-07
Gcorr6611 T3499 T4949 T3499 T4949 -1.5008466079207556e-07
Rt19653 T3499 T5811 9215464.4879628159
Gcorr6612 T3500 T3621 T3500 T3621 -2.3235471210224382e-07
Rt19654 T3500 T3825 3569004.6160284621
Rt19655 T3500 T4190 877313.24139284005
Rt19656 T3500 T4220 4645132.1983248144
Rt19657 T3500 T5675 923370.54638940317
Rt19658 T3500 T5826 2150622.7320359661
Gcorr6613 T3500 T5827 T3500 T5827 -6.0448116835300979e-09
Rt19659 T3501 T3502 1919266.8223463502
Rt19660 T3501 T3516 1592127.512994823
Rt19661 T3501 T3999 1008716.721286939
Gcorr6614 T3501 T4456 T3501 T4456 -1.2910171918779067e-07
Rt19662 T3501 T4459 4083552.3842508527
Rt19663 T3501 T4460 982581.29778991349
Gcorr6615 T3501 T4461 T3501 T4461 -1.1830572737755537e-07
Gcorr6616 T3501 T5699 T3501 T5699 -4.1438204009107904e-07
Rt19664 T3502 T3516 3580399.1070441599
Rt19665 T3502 T3524 1628138.808619133
Rt19666 T3502 T3734 4239641.2069978323
Rt19667 T3502 T3779 1634439.3042993976
Rt19668 T3502 T4460 40609732.567543834
Rt19669 T3502 T4461 4394695.1601624461
Rt19670 T3502 T4462 847199.60147728899
Gcorr6617 T3502 T4463 T3502 T4463 -9.570839078376591e-08
Gcorr6618 T3502 T6055 T3502 T6055 -6.9935199816174557e-07
Rt19671 T3503 T3683 675022.27509231248
Rt19672 T3503 T3694 1597469.6558448907
Rt19673 T3503 T3937 1220424.1633779395
Gcorr6619 T3503 T4513 T3503 T4513 -2.3943052478058185e-07
Gcorr6620 T3503 T4633 T3503 T4633 -5.1112283721477114e-07
Rt19674 T3503 T5059 597560.42635189183
Gcorr6621 T3503 T5323 T3503 T5323 -3.3963997284946419e-07
Rt19675 T3503 T5480 152202877.40330622
Gcorr6622 T3503 T6018 T3503 T6018 -4.9260737111575745e-08
Rt19676 T3504 T3743 708934.4143216759
Rt19677 T3504 T3847 747828.63725954259
Rt19678 T3504 T3883 1914659.3590169454
Rt19679 T3504 T4391 871977.26478946127
Gcorr6623 T3504 T4392 T3504 T4392 -4.0589419056209879e-07
Rt19680 T3504 T5597 1875018.137857785
Gcorr6624 T3504 T5705 T3504 T5705 -5.3870696591540363e-07
Rt19681 T3505 T3506 1796575.8937766086
Rt19682 T3505 T3521 2431639.8606202146
Rt19683 T3505 T3836 2336624.6052677166
Gcorr6625 T3505 T3865 T3505 T3865 -2.9107615817870425e-08
Rt19684 T3505 T5209 5355286.7512938259
Gcorr6626 T3505 T5540 T3505 T5540 -5.0555463080113369e-09
Rt19685 T3505 T5768 3203819.2290199972
Rt19686 T3505 T5866 6754254.5099550504
Rt19687 T3506 T3865 2467650.2725426587
Rt19688 T3506 T3996 1090875.8038777935
Rt19689 T3506 T4034 1252416.9257494344
Gcorr6627 T3506 T4545 T3506 T4545 -6.9660701188058339e-09
Rt19690 T3506 T4660 6885671.4757336685
Rt19691 T3506 T5540 2955462.5499396054
Gcorr6628 T3506 T5866 T3506 T5866 -4.4987463341298628e-08
Rt19692 T3507 T4067 442973.13427747344
Rt19693 T3507 T4156 934668.38873900974
Gcorr6629 T3507 T4529 T3507 T4529 -1.29660693070126e-07
Rt19694 T3507 T4530 1151165.7552495415
Gcorr6630 T3507 T4531 T3507 T4531 -3.1633744550708139e-07
Gcorr6631 T3507 T5537 T3507 T5537 -8.288408654138268e-08
Rt19695 T3508 T3828 4153220.7800302287
Rt19696 T3508 T4028 1248371.8104073999
Rt19697 T3508 T4059 1714986.1899308886
Rt19698 T3508 T4125 3637665.3704754938
Rt19699 T3508 T4924 2442798.9396523708
Rt19700 T3508 T5337 1123282.9697556705
Rt19701 T3508 T5762 2682305.5335912202
Gcorr6632 T3508 T5831 T3508 T5831 -6.2598854138343129e-08
Gcorr6633 T3508 T6082 T3508 T6082 -2.5536285584768396e-07
Gcorr6634 T3509 T3809 T3509 T3809 -7.2744666276114442e-07
Rt19702 T3509 T3840 1430848.9304056733
Rt19703 T3509 T5031 1708016.4332914122
Rt19704 T3509 T5238 23695547.212843109
Gcorr6635 T3509 T5366 T3509 T5366 -1.1359613149406238e-06
Rt19705 T3509 T5427 280821.80224585847
Rt19706 T3509 T5446 2026146.9412206677
Rt19707 T3509 T5979 3359212.4389935131
Rt19708 T3510 T3562 2671093.2713227463
Rt19709 T3510 T3917 944704.84857277025
Gcorr6636 T3510 T4928 T3510 T4928 -1.3293814868521702e-07
Rt19710 T3510 T4930 5684162.3260821328
Rt19711 T3510 T5228 1884368.7558855182
Rt19712 T3511 T3615 4511378.8149022916
Rt19713 T3511 T4063 1033079.0835668859
Rt19714 T3511 T4152 887092.12816457951
Gcorr6637 T3511 T4938 T3511 T4938 -3.6386532820305117e-08
Rt19715 T3511 T4939 3494073.3813956412
Rt19716 T3511 T5040 6903751.3423651494
Rt19717 T3512 T4012 411095.55511077412
Rt19718 T3512 T4076 2161081.0503565897
Rt19719 T3512 T5113 522918.28584191052
Gcorr6638 T3512 T5114 T3512 T5114 -1.7142386060446527e-07
Rt19720 T3512 T5235 1334296.1125293975
Gcorr6639 T3512 T5765 T3512 T5765 -8.5964292685348084e-07
Rt19721 T3512 T6019 979756.64393392066
Rt19722 T3513 T3864 2320586.9438849911
Gcorr6640 T3513 T5227 T3513 T5227 -1.0126255759223783e-07
Rt19723 T3513 T5307 2978411.1006657449
Rt19724 T3513 T5897 6134850.1068813382
Rt19725 T3513 T6023 8738728.6302477326
Rt19726 T3514 T3960 751973.00421865506
Rt19727 T3514 T4146 470670.91375596612
Rt19728 T3514 T4279 2719315.9185870448
Gcorr6641 T3514 T5026 T3514 T5026 -1.3409792646563715e-06
Gcorr6642 T3514 T5211 T3514 T5211 -1.5789328153586381e-07
Gcorr6643 T3514 T5244 T3514 T5244 -2.7995505027535121e-07
Rt19729 T3514 T5582 183608.9444916333
Gcorr6644 T3514 T5805 T3514 T5805 -9.1005946610744529e-07
Rt19730 T3515 T3867 451580.80400321615
Rt19731 T3515 T3897 2863377.4299060758
Gcorr6645 T3515 T4112 T3515 T4112 -4.4574202214857429e-07
Rt19732 T3515 T4230 20954892.19519427
Rt19733 T3515 T5282 3862047.1359417089
Rt19734 T3515 T5292 328388.1646904861
Rt19735 T3515 T5843 2164074.0973414532
Rt19736 T3516 T3524 1535421.1279204823
Rt19737 T3516 T3870 1069998.683651584
Rt19738 T3516 T4459 25928289.644397613
Rt19739 T3516 T4461 1872397.0405016474
Gcorr6646 T3516 T4464 T3516 T4464 -8.4040722784349692e-08
Rt19740 T3516 T5327 13764658.302657006
Rt19741 T3517 T3588 8711269.7746155225
Rt19742 T3517 T3625 1425437.5168609235
Rt19743 T3517 T3835 10522105.968827222
Rt19744 T3517 T4101 219229.13026409518
Gcorr6647 T3517 T4360 T3517 T4360 -1.5864261940930389e-07
Gcorr6648 T3517 T4361 T3517 T4361 -1.061195546262431e-06
Rt19745 T3517 T4362 422800.62768312031
Rt19746 T3517 T4363 9412066.0513234716
Gcorr6649 T3517 T5851 T3517 T5851 -6.0953499425764682e-07
Gcorr6650 T3518 T3567 T3518 T3567 -3.231423961997718e-07
Rt19747 T3518 T3926 583340.21494471061
Rt19748 T3518 T4006 491011.46154670737
Gcorr6651 T3518 T4219 T3518 T4219 -3.6262893067195502e-08
Rt19749 T3518 T5329 471266.8110230217
Gcorr6652 T3518 T5330 T3518 T5330 -5.4136021425065749e-07
Rt19750 T3518 T5759 1373143.3618838992
Gcorr6653 T3518 T5939 T3518 T5939 -4.2464741293621383e-07
Rt19751 T3519 T3528 1696009.4173070854
Rt19752 T3519 T3716 668576.91570630204
Gcorr6654 T3519 T4781 T3519 T4781 -4.4079033787559767e-07
Rt19753 T3519 T4782 1359747.7665543819
Rt19754 T3519 T4783 3122776.5173800229
Rt19755 T3519 T4834 2780036.9306281651
Gcorr6655 T3519 T5744 T3519 T5744 -4.089266664078817e-07
Rt19756 T3520 T3837 4939232.6998332078
Rt19757 T3520 T3979 209127.88028654648
Rt19758 T3520 T4001 1290163.0405926825
Rt19759 T3520 T4920 1679464.606561695
Rt19760 T3520 T4921 257720.89989578247
Rt19761 T3520 T5115 2574822.0777036697
Gcorr6656 T3520 T5162 T3520 T5162 -1.9875396219956026e-06
Rt19762 T3521 T3790 1274026.290229063
Rt19763 T3521 T3836 1358914.4618653199
Rt19764 T3521 T3887 2193052.7321583587
Gcorr6657 T3521 T5022 T3521 T5022 -6.5776424515720532e-08
Rt19765 T3521 T5209 3627282.8907660325
Rt19766 T3521 T5230 2326533.8407290308
Gcorr6658 T3521 T5768 T3521 T5768 -1.1721431517903198e-07
Rt19767 T3522 T3616 5400680.3210699353
Rt19768 T3522 T3928 711067.18958110921
Rt19769 T3522 T4103 1023448.8092142022
Rt19770 T3522 T5216 5282760.3742255904
Rt19771 T3522 T5396 5528848.3882865394
Gcorr6659 T3522 T5889 T3522 T5889 -2.2576298735671388e-07
Rt19772 T3522 T6062 2795378.81309612
Rt19773 T3523 T4083 601962.70767541195
Rt19774 T3523 T4175 1068094.984298653
Rt19775 T3523 T4214 35379170.33323244
Rt19776 T3523 T5367 457695.80168498337
Rt19777 T3523 T6041 30635976.192316476
Rt19778 T3524 T3779 3339448.1371055236
Rt19779 T3524 T3831 994952.70555270324
Rt19780 T3524 T3976 1224410.4334023162
Gcorr6660 T3524 T4461 T3524 T4461 -9.5016425089467486e-08
Rt19781 T3524 T4463 636377.47923570243
Rt19782 T3524 T4464 4878630.363097067
Gcorr6661 T3524 T4604 T3524 T4604 -2.7125136204934265e-07
Gcorr6662 T3524 T5680 T3524 T5680 -7.6570599517245545e-07
Rt19783 T3525 T4012 1485630.9466804997
Rt19784 T3525 T4988 1050372.9939132133
Rt19785 T3525 T5452 396264.60501276702
Gcorr6663 T3525 T5764 T3525 T5764 -6.6055197769787531e-08
Rt19786 T3525 T5765 14284547.819449136
Rt19787 T3525 T5875 1097024.4494647388
Rt19788 T3526 T3976 1583300.4104105516
Rt19789 T3526 T4189 1940272.5207745519
Gcorr6664 T3526 T4604 T3526 T4604 -1.2919220739764972e-07
Rt19790 T3526 T4605 2683885.638258683
Rt19791 T3526 T4664 3865293.6339665563
Gcorr6665 T3526 T4665 T3526 T4665 -1.1577043351379758e-07
Rt19792 T3527 T3540 1759406.0439600307
Rt19793 T3527 T3693 1260187.0710291392
Rt19794 T3527 T4054 1550775.9504573867
Rt19795 T3527 T4368 5636844.1083944915
Rt19796 T3527 T4371 26038344.90727213
Rt19797 T3527 T4380 2467105.7457019808
Gcorr6666 T3527 T5636 T3527 T5636 -1.1161223732208529e-07
Rt19798 T3528 T3851 1824473.6499883551
Rt19799 T3528 T4110 1204449.1669234291
Rt19800 T3528 T4783 2664077.581461133
Rt19801 T3528 T4834 10698629.311915884
Rt19802 T3528 T4835 7228980.4611951141
Gcorr6667 T3528 T4943 T3528 T4943 -1.5075306807497579e-07
Rt19803 T3529 T3530 1733768.5116888494
Rt19804 T3529 T3782 1479728.1372416732
Rt19805 T3529 T4019 10717228.457063725
Rt19806 T3529 T4089 1943922.4112552789
Rt19807 T3529 T5092 6175299.8482787339
Rt19808 T3529 T5093 2163696.4111352223
Rt19809 T3529 T5094 10455232.756888917
Gcorr6668 T3529 T5095 T3529 T5095 -1.8029412549035853e-07
Rt19810 T3530 T3910 9960653.5795161128
Rt19811 T3530 T4019 485472.31028130045
Rt19812 T3530 T4195 772052.82336658798
Rt19813 T3530 T5090 1021537.9410351808
Gcorr6669 T3530 T5091 T3530 T5091 -3.5705113018594539e-07
Gcorr6670 T3530 T5092 T3530 T5092 -1.331764597917493e-07
Gcorr6671 T3530 T5093 T3530 T5093 -9.884339624745345e-08
Rt19814 T3531 T3719 3206346.4252537778
Rt19815 T3531 T3834 11880460.529363737
Rt19816 T3531 T3885 1185883.7066200543
Rt19817 T3531 T5264 1813879.3240216144
Gcorr6672 T3531 T5325 T3531 T5325 -4.8702305060561673e-07
Rt19818 T3531 T5626 2885715.4378590723
Gcorr6673 T3531 T6085 T3531 T6085 -4.4214924395050891e-08
Rt19819 T3532 T3660 8837003.8442822695
Rt19820 T3532 T3861 1863417.9749111452
Rt19821 T3532 T3936 1038181.5563949924
Rt19822 T3532 T5182 8850629.4722794294
Rt19823 T3532 T5355 3768188.3842040063
Rt19824 T3532 T5494 10751739.687185368
Rt19825 T3532 T5495 5539295.4986127531
Rt19826 T3533 T3534 2147824.8055703747
Rt19827 T3533 T3535 1134188.157822507
Rt19828 T3533 T3651 1332748.8770568392
Rt19829 T3533 T4381 1286809.1583531767
Gcorr6674 T3533 T4382 T3533 T4382 -1.2503188418290314e-07
Rt19830 T3533 T4383 9550066.4484327603
Gcorr6675 T3533 T4822 T3533 T4822 -2.709420125968875e-07
Rt19831 T3533 T5722 9414551.1272425018
Rt19832 T3534 T3651 3776971.7896165275
Rt19833 T3534 T3876 1552162.2933550787
Rt19834 T3534 T3884 8049910.8402995067
Rt19835 T3534 T4382 2931890.209485638
Gcorr6676 T3534 T4383 T3534 T4383 -4.8841013438173096e-08
Rt19836 T3534 T4384 1898703.1923739035
Gcorr6677 T3534 T4385 T3534 T4385 -1.4192004864142081e-07
Rt19837 T3535 T3536 1477654.3618728777
Rt19838 T3535 T3577 2147405.1976383603
Rt19839 T3535 T3593 1591322.2530476321
Rt19840 T3535 T4378 10720510.883961665
Gcorr6678 T3535 T4381 T3535 T4381 -2.3380665865431178e-07
Rt19841 T3535 T4822 1216542.4385546076
Rt19842 T3535 T5502 17317296.798860896
Gcorr6679 T3535 T5639 T3535 T5639 -1.7988324008396341e-07
Rt19843 T3536 T3577 3243058.27815462
Rt19844 T3536 T4168 952557.37310243025
Gcorr6680 T3536 T4822 T3536 T4822 -1.6175419018193361e-07
Gcorr6681 T3536 T5259 T3536 T5259 -7.6808938626186864e-08
Rt19845 T3536 T5639 1849993.3782719173
Rt19846 T3536 T6070 3442055.7341741878
Rt19847 T3537 T3692 1437652.2540401379
Rt19848 T3537 T4185 1420873.562584922
Rt19849 T3537 T4191 493776.76524399925
Rt19850 T3537 T4592 1915706.6223065045
Rt19851 T3537 T5380 7285929.7289232751
Rt19852 T3537 T5743 7892961.0690030884
Gcorr6682 T3537 T5767 T3537 T5767 -3.6997605208004965e-07
Rt19853 T3538 T3746 1708132.3538261056
Rt19854 T3538 T3981 937811.04908357561
Gcorr6683 T3538 T4964 T3538 T4964 -1.4346550551142145e-07
Rt19855 T3538 T4966 1736968.4752417423
Rt19856 T3538 T4967 6492068.8722453099
Rt19857 T3538 T4968 7801746.410551114
Gcorr6684 T3538 T4969 T3538 T4969 -1.6566710358235868e-07
Rt19858 T3539 T4050 2580125.7728387052
Rt19859 T3539 T4109 405442.88800312683
Rt19860 T3539 T4111 843382.49333267461
Rt19861 T3539 T4318 998144.29151083645
Gcorr6685 T3539 T4319 T3539 T4319 -7.3897632354370355e-09
Gcorr6686 T3539 T4320 T3539 T4320 -7.1045038343187102e-08
Gcorr6687 T3539 T4321 T3539 T4321 -4.883526941525468e-07
Gcorr6688 T3540 T3693 T3540 T3693 -5.8900921071144008e-08
Rt19862 T3540 T3749 1934638.4082073385
Rt19863 T3540 T3826 4045499.1840762566
Rt19864 T3540 T4142 1127581.9100072756
Rt19865 T3540 T4366 3017649.8803790538
Rt19866 T3540 T4368 14335293.219218729
Gcorr6689 T3540 T4663 T3540 T4663 -1.8168987419287348e-07
Rt19867 T3540 T5636 3058648.1194483344
Rt19868 T3541 T3806 1626672.6060407367
Rt19869 T3541 T3863 1851656.631696082
Rt19870 T3541 T4096 3099646.0524491617
Rt19871 T3541 T4241 1381253.3180801901
Rt19872 T3541 T4242 5354832.3682200583
Rt19873 T3541 T4243 18004021.55861247
Rt19874 T3542 T3623 2931993.7410234623
Rt19875 T3542 T3872 1105564.1318954071
Rt19876 T3542 T4651 13912228.327177808
Gcorr6690 T3542 T4726 T3542 T4726 -2.8119539169337324e-07
Rt19877 T3542 T4788 1551515.9545611856
Rt19878 T3542 T5373 7957053.0931081306
Rt19879 T3543 T3780 1344629.054002543
Rt19880 T3543 T3936 1158698.2687003247
Rt19881 T3543 T5003 27927611.290385488
Gcorr6691 T3543 T5004 T3543 T5004 -7.2734510779160149e-08
Rt19882 T3543 T5312 1583434.1033167061
Gcorr6692 T3543 T5936 T3543 T5936 -1.9287897748775586e-07
Rt19883 T3544 T3665 666973.54971540498
Rt19884 T3544 T3991 1158182.3997563631
Gcorr6693 T3544 T4803 T3544 T4803 -1.257427999530365e-07
Gcorr6694 T3544 T4805 T3544 T4805 -1.1791617609044919e-07
Gcorr6695 T3544 T4934 T3544 T4934 -4.4497850104400238e-07
Rt19885 T3544 T5331 914342.37649462535
Rt19886 T3545 T3604 4835760.749933199
Rt19887 T3545 T3788 1576256.6617597644
Rt19888 T3545 T4010 1153233.2199406216
Gcorr6696 T3545 T4947 T3545 T4947 -1.4182618573406125e-07
Rt19889 T3545 T5069 1357994.7539198617
Rt19890 T3545 T5158 4896228.2284245929
Gcorr6697 T3545 T5707 T3545 T5707 -4.6167882451437114e-07
Rt19891 T3546 T3602 3945645.0745311738
Rt19892 T3546 T3603 1830631.9283117587
Rt19893 T3546 T3765 56762356.886351548
Rt19894 T3546 T4167 905529.73258580803
Rt19895 T3546 T4980 4304585.005512205
Rt19896 T3546 T5143 5262342.666869971
Rt19897 T3546 T5575 7057435.925298078
Rt19898 T3547 T3854 1173658.4168448588
Rt19899 T3547 T4145 1047866.7170835069
Rt19900 T3547 T4158 994106.31776978471
Rt19901 T3547 T4540 16032156.310786523
Rt19902 T3547 T4541 2544583.1728977636
Gcorr6698 T3547 T4542 T3547 T4542 -9.9220996817590093e-08
Rt19903 T3548 T3653 1386191.5053054469
Rt19904 T3548 T4583 4161658.0817304263
Gcorr6699 T3548 T4606 T3548 T4606 -1.9195561032322644e-07
Rt19905 T3548 T4636 1843435.7030777361
Gcorr6700 T3548 T5461 T3548 T5461 -6.0019584629094074e-08
Rt19906 T3549 T3550 2358615.2471204656
Rt19907 T3549 T4064 985305.50445232273
Rt19908 T3549 T4120 1439409.1484045193
Gcorr6701 T3549 T5192 T3549 T5192 -1.9420402740067459e-07
Rt19909 T3549 T5194 11391209.205698181
Rt19910 T3549 T5195 1287632.8484116851
Rt19911 T3549 T5199 22301386.439792529
Gcorr6702 T3549 T5426 T3549 T5426 -1.3280556976247197e-08
Rt19912 T3550 T3551 22792479.445229899
Rt19913 T3550 T3905 818644.68861525331
Rt19914 T3550 T4120 928715.93042641261
Rt19915 T3550 T5199 520214.18973491841
Gcorr6703 T3550 T5340 T3550 T5340 -6.8014320933671888e-07
Gcorr6704 T3550 T5426 T3550 T5426 -1.0447955152836997e-07
Rt19916 T3550 T5852 38258148.768076539
Gcorr6705 T3551 T3881 T3551 T3881 -6.104314813340444e-08
Rt19917 T3551 T3905 3645427.7710481305
Rt19918 T3551 T4087 1508854.8619499928
Rt19919 T3551 T4228 1944989.8523763663
Rt19920 T3551 T5315 2557323.0471345936
Rt19921 T3551 T5852 829759.55210031057
Rt19922 T3552 T3570 1921363.4256201936
Gcorr6706 T3552 T3969 T3552 T3969 -5.2191064300350565e-09
Gcorr6707 T3552 T4008 T3552 T4008 -4.9851653702441591e-08
Gcorr6708 T3552 T4284 T3552 T4284 -4.8756006227326456e-08
Rt19923 T3552 T4285 219464.3968285991
Rt19924 T3552 T4286 733559.65790561261
Rt19925 T3552 T4287 1908814.4644937098
Gcorr6709 T3552 T5429 T3552 T5429 -1.2339409357418587e-06
Gcorr6710 T3553 T3554 T3553 T3554 -1.1204945817125179e-07
Rt19926 T3553 T4040 494954.10390111228
Rt19927 T3553 T4138 338891.44294061017
Gcorr6711 T3553 T4911 T3553 T4911 -2.8778669739260448e-07
Gcorr6712 T3553 T4914 T3553 T4914 -4.1827204727671149e-07
Gcorr6713 T3553 T5656 T3553 T5656 -4.9865188981112865e-07
Rt19928 T3553 T5657 2734126.0463504014
Rt19929 T3553 T5896 725102.79501940787
Rt19930 T3554 T3711 4526357.6011961764
Rt19931 T3554 T4024 1294514.2668576026
Rt19932 T3554 T4138 849966.88840365235
Rt19933 T3554 T4160 493588.08452555619
Gcorr6714 T3554 T4907 T3554 T4907 -4.1485101008606289e-07
Rt19934 T3554 T5490 1959073.3397108684
Rt19935 T3554 T5656 4620856.9072364885
Rt19936 T3554 T5657 7258950.9840848139
Rt19937 T3555 T3641 3678428.0321504162
Rt19938 T3555 T3751 2578828.949658521
Rt19939 T3555 T4903 3273636.5976924337
Gcorr6715 T3555 T4904 T3555 T4904 -5.4512042305984484e-07
Rt19940 T3555 T4905 1405088.9726825382
Gcorr6716 T3555 T5137 T3555 T5137 -1.0676982375800223e-06
Rt19941 T3555 T5638 892749.05732033821
Rt19942 T3556 T4088 1807940.3040883779
Gcorr6717 T3556 T4247 T3556 T4247 -1.3463465090008084e-07
Rt19943 T3556 T4746 4231351.8717117775
Rt19944 T3556 T5567 2601848.7797943954
Rt19945 T3557 T3675 1490867.1020054969
Gcorr6718 T3557 T4648 T3557 T4648 -1.8624454906575955e-07
Rt19946 T3557 T4650 7464689.6205588477
Rt19947 T3557 T4933 2018829.8061458166
Rt19948 T3557 T5474 1795125.6846441191
Gcorr6719 T3557 T5606 T3557 T5606 -4.9632862598683996e-07
Rt19949 T3558 T3559 1751974.3235843135
Rt19950 T3558 T3852 3228470.802613399
Rt19951 T3558 T4472 10085874.681346864
Rt19952 T3558 T4598 4542477.8089373792
Rt19953 T3558 T4709 8929671.5485794786
Rt19954 T3559 T3563 1283377.96445531
Rt19955 T3559 T3852 2332704.2469743034
Gcorr6720 T3559 T4117 T3559 T4117 -4.9734703993352777e-08
Gcorr6721 T3559 T4472 T3559 T4472 -1.6973092029223349e-07
Rt19956 T3559 T4597 2097976.2208006768
Rt19957 T3559 T4598 11775217.699921815
Gcorr6722 T3559 T4686 T3559 T4686 -4.9141705875459571e-09
Rt19958 T3559 T5787 3389991.9089942602
Rt19959 T3560 T3561 3308525.3728586161
Rt19960 T3560 T3607 1758627.1203837136
Rt19961 T3560 T4603 8892381.4157182984
Rt19962 T3560 T4653 6203456.7669361411
Rt19963 T3560 T4678 6235978.7026757039
Rt19964 T3561 T3607 1967558.3838727265
Rt19965 T3561 T4039 1046064.3577767104
Rt19966 T3561 T4678 2522056.6468155282
Rt19967 T3561 T4721 6700440.612846531
Rt19968 T3561 T4827 6105354.6817509932
Gcorr6723 T3561 T5552 T3561 T5552 -1.2675892131658474e-07
Rt19969 T3562 T3859 1640962.7721745484
Rt19970 T3562 T5228 9152165.3331203777
Rt19971 T3562 T5229 13607528.752243962
Rt19972 T3562 T5442 2868841.463419083
Gcorr6724 T3562 T6042 T3562 T6042 -4.9337024070832106e-08
Rt19973 T3563 T3672 4247870.3024749598
Rt19974 T3563 T4116 1472254.4927569323
Rt19975 T3563 T4117 996023.48745878914
Rt19976 T3563 T4471 10208077.161477901
Rt19977 T3563 T4597 7338415.5606363518
Rt19978 T3563 T4685 2931099.8574995566
Gcorr6725 T3563 T4686 T3563 T4686 -1.4806171725337839e-07
Rt19979 T3564 T3763 722714.5496664911
Rt19980 T3564 T3982 2194240.7629331443
Rt19981 T3564 T5152 3777091.8505453635
Rt19982 T3564 T5189 11559744.810666012
Gcorr6726 T3564 T5192 T3564 T5192 -1.4076531460172745e-07
Rt19983 T3564 T5356 1735132.7632374594
Gcorr6727 T3564 T5701 T3564 T5701 -3.3955417685705303e-07
Rt19984 T3565 T3762 2704089.2857776131
Rt19985 T3565 T4061 1180242.3167624632
Gcorr6728 T3565 T4683 T3565 T4683 -1.0822819613207444e-07
Rt19986 T3565 T5531 2446996.7502672714
Rt19987 T3565 T5532 3762559.337006751
Gcorr6729 T3565 T5664 T3565 T5664 -1.1594393647375665e-07
Rt19988 T3566 T3609 2085651.715339219
Rt19989 T3566 T3698 2303347.5575777213
Rt19990 T3566 T3964 1989155.9916676274
Gcorr6730 T3566 T5126 T3566 T5126 -8.2320108966043227e-08
Rt19991 T3566 T5320 1026265.3928197266
Gcorr6731 T3566 T5756 T3566 T5756 -7.6020539703540231e-08
Gcorr6732 T3566 T6046 T3566 T6046 -3.5359141042565588e-07
Rt19992 T3566 T6066 53777436.21305228
Rt19993 T3567 T4006 1977403.6297031345
Rt19994 T3567 T5168 2401766.7956871302
Rt19995 T3567 T5172 1005633.6023858737
Rt19996 T3567 T5759 989190.28551272338
Gcorr6733 T3567 T5777 T3567 T5777 -5.7810909565210853e-08
Rt19997 T3568 T3857 1244770.2088693599
Rt19998 T3568 T4173 995348.70215019071
Rt19999 T3568 T4180 997921.59399329161
Gcorr6734 T3568 T4883 T3568 T4883 -7.9470427700023547e-08
Gcorr6735 T3568 T5179 T3568 T5179 -5.9317584017969065e-08
Rt20000 T3568 T5863 4098460.0282935561
Rt20001 T3568 T5888 4797141.2455383195
Rt20002 T3569 T3839 19602229.782770816
Rt20003 T3569 T3941 520963.21078058233
Rt20004 T3569 T4134 1768265.1377405894
Gcorr6736 T3569 T5015 T3569 T5015 -4.8346343309556641e-07
Rt20005 T3569 T5016 1172417.4124547832
Rt20006 T3569 T5430 3105014.7766704131
Gcorr6737 T3569 T5783 T3569 T5783 -4.2435615515230313e-08
Rt20007 T3570 T3571 5827490.0836768458
Rt20008 T3570 T3830 864740.26541181467
Rt20009 T3570 T4008 6175753.3151505543
Rt20010 T3570 T4284 300655.30114127026
Rt20011 T3570 T4286 6155686.2187413722
Rt20012 T3570 T4299 3566980.9025197341
Rt20013 T3571 T3572 2456731.1504035383
Rt20014 T3571 T3830 1428737.2186261902
Rt20015 T3571 T3894 1847429.2130750322
Rt20016 T3571 T3934 2514391.7823841432
Rt20017 T3571 T4299 379500.30000645126
Rt20018 T3571 T5945 5267098.6947188322
Gcorr6738 T3571 T6006 T3571 T6006 -7.6293078928590201e-08
Rt20019 T3572 T3589 3465242.1447938676
Rt20020 T3572 T3787 5750594.8323927447
Rt20021 T3572 T3894 1280869.2082144336
Gcorr6739 T3572 T4299 T3572 T4299 -6.7631333261645019e-08
Rt20022 T3572 T5358 426594.64077543997
Rt20023 T3572 T5796 1076967.0821846614
Gcorr6740 T3572 T5935 T3572 T5935 -8.0855498717800176e-08
Rt20024 T3572 T6006 1397650.5514868989
Rt20025 T3573 T3574 1762125.6231300356
Rt20026 T3573 T3754 1590959.4910767858
Gcorr6741 T3573 T3907 T3573 T3907 -3.4782813837381918e-08
Rt20027 T3573 T4062 5762394.1655642632
Rt20028 T3573 T4309 2482485.5726037016
Rt20029 T3573 T4310 25133239.650609039
Rt20030 T3573 T4311 5883990.6657695435
Gcorr6742 T3573 T4313 T3573 T4313 -3.8546694615998262e-08
Rt20031 T3574 T3911 1036276.1737053648
Rt20032 T3574 T4062 1062855.2417617782
Rt20033 T3574 T4157 1037267.3474404592
Gcorr6743 T3574 T4310 T3574 T4310 -1.178756870439386e-07
Rt20034 T3574 T4311 2945604.0121293981
Rt20035 T3574 T4312 4452052.8696353305
Gcorr6744 T3574 T5423 T3574 T5423 -1.2155608066380422e-07
Rt20036 T3575 T3576 19663512.186630096
Rt20037 T3575 T3680 4338255.4382058298
Rt20038 T3575 T3989 1423672.495681857
Rt20039 T3575 T4269 910676.23269010719
Rt20040 T3575 T4271 27321201.134104144
Gcorr6745 T3575 T4816 T3575 T4816 -9.6123490672549491e-08
Rt20041 T3575 T5915 1452530.1332057759
Rt20042 T3576 T3680 1150769.0780178425
Rt20043 T3576 T3925 3977247.1723242928
Rt20044 T3576 T4031 1128311.6022421166
Gcorr6746 T3576 T4466 T3576 T4466 -3.9057130056522071e-08
Gcorr6747 T3576 T4816 T3576 T4816 -4.6432486914829599e-07
Rt20045 T3576 T5660 1065892.2661605119
Rt20046 T3576 T5915 735218.47037630051
Rt20047 T3577 T3593 3760121.276201257
Rt20048 T3577 T3898 698988.9160441329
Rt20049 T3577 T4054 2051772.7960599449
Gcorr6748 T3577 T4373 T3577 T4373 -4.6093303150590893e-07
Rt20050 T3577 T5502 2873880.2632670938
Rt20051 T3577 T5611 2439484.5027840235
Rt20052 T3577 T5639 6077615.5562738925
Rt20053 T3578 T3583 3424041.2165267426
Rt20054 T3578 T4104 1198320.4532868692
Rt20055 T3578 T4105 1153141.5068365498
Rt20056 T3578 T5111 1379810.5908031515
Rt20057 T3578 T5834 3009860.7619148698
Gcorr6749 T3578 T5835 T3578 T5835 -1.4056743419593982e-07
Rt20058 T3578 T5870 25249788.165408235
Rt20059 T3579 T3676 1454630.6592685294
Rt20060 T3579 T4065 1169847.1767625569
Rt20061 T3579 T4762 9584744.9465015307
Rt20062 T3579 T4763 11657747.461523959
Rt20063 T3579 T4870 2580140.2393763643
Gcorr6750 T3579 T5454 T3579 T5454 -1.4335474289325987e-07
Rt20064 T3580 T3661 9068584.847603891
Rt20065 T3580 T3895 2161845.3128965767
Rt20066 T3580 T3991 1023170.326170497
Rt20067 T3580 T4800 46141429.55455067
Rt20068 T3580 T4802 2079727.4358758416
Rt20069 T3580 T4803 12000229.807650462
Rt20070 T3580 T4804 21646937.161945723
Rt20071 T3581 T3841 1134575.6026183602
Gcorr6751 T3581 T4824 T3581 T4824 -1.2747546074526861e-07
Rt20072 T3581 T4825 1717893.0202410365
Rt20073 T3581 T4955 1059354.4331949588
Gcorr6752 T3581 T5009 T3581 T5009 -1.7042770407144606e-08
Rt20074 T3582 T3853 1608507.0641600925
Rt20075 T3582 T3887 4050777.1342411586
Rt20076 T3582 T4091 1243419.1514956497
Gcorr6753 T3582 T4555 T3582 T4555 -1.5962318138928067e-07
Rt20077 T3582 T5485 3129900.0828828048
Rt20078 T3582 T5784 3423088.3712291224
Gcorr6754 T3582 T5858 T3582 T5858 -5.9162224098886149e-08
Rt20079 T3583 T3584 1763522.2535947522
Rt20080 T3583 T3702 1575533.0378421862
Gcorr6755 T3583 T4105 T3583 T4105 -1.2570789090942788e-07
Gcorr6756 T3583 T4860 T3583 T4860 -5.1752819107045112e-07
Rt20081 T3583 T4963 913467.32540286682
Gcorr6757 T3583 T5834 T3583 T5834 -2.2501673574362414e-08
Rt20082 T3583 T5835 3077178.7661173446
Rt20083 T3583 T5881 8455021.4686525762
Rt20084 T3584 T3665 1291441.4937065893
Rt20085 T3584 T3702 2733681.9187108255
Gcorr6758 T3584 T3759 T3584 T3759 -2.0269348129171022e-08
Rt20086 T3584 T4085 890713.67722083791
Rt20087 T3584 T4860 2225340.0898696599
Rt20088 T3584 T4934 6337177.9887004392
Rt20089 T3584 T4935 7744783.2457890427
Gcorr6759 T3584 T4963 T3584 T4963 -1.256767937190422e-07
Rt20090 T3585 T3613 1786326.8338070018
Rt20091 T3585 T4092 3430824.1360067576
Gcorr6760 T3585 T4207 T3585 T4207 -2.1919614342384048e-07
Rt20092 T3585 T5351 5226911.4319166504
Rt20093 T3585 T5605 708588.01390358561
Gcorr6761 T3585 T5859 T3585 T5859 -4.2213105696933434e-07
Gcorr6762 T3585 T5961 T3585 T5961 -1.4876280867920336e-07
Rt20094 T3586 T3604 7428418.6854434181
Rt20095 T3586 T3771 1391492.3291070613
Rt20096 T3586 T3919 4143857.9180155867
Rt20097 T3586 T4010 1054911.4355758121
Rt20098 T3586 T4092 420436.51028772083
Rt20099 T3586 T4927 1050704.7330087649
Rt20100 T3586 T4948 4935594.8606001893
Gcorr6763 T3586 T5927 T3586 T5927 -1.4497377533604546e-07
Gcorr6764 T3586 T5938 T3586 T5938 -3.9767717625404892e-07
Rt20101 T3587 T4009 595624.26623171323
Gcorr6765 T3587 T4140 T3587 T4140 -9.4794330032769859e-09
Rt20102 T3587 T4427 58414287.797239065
Rt20103 T3587 T4655 20565418.699085671
Gcorr6766 T3587 T5379 T3587 T5379 -2.4565476248009118e-07
Rt20104 T3587 T5720 1610529.5038715096
Rt20105 T3588 T3971 3192575.4826596449
Rt20106 T3588 T4097 959593.89990394784
Rt20107 T3588 T4101 720592.54223948508
Rt20108 T3588 T4359 7225059.6329775052
Rt20109 T3588 T4360 1802730.5029651497
Gcorr6767 T3588 T4361 T3588 T4361 -2.0738858369882055e-07
Rt20110 T3589 T3787 2486399.1752089662
Rt20111 T3589 T4932 1137871.5876810644
Rt20112 T3589 T5716 23381009.655257713
Rt20113 T3589 T5796 1198566.9256398834
Rt20114 T3589 T5935 2942490.0495458571
Gcorr6768 T3590 T3856 T3590 T3856 -1.6480530237294449e-07
Rt20115 T3590 T3906 2916951.5119983787
Rt20116 T3590 T4196 1207373.3636941002
Rt20117 T3590 T4840 8319832.4368643025
Rt20118 T3590 T5134 782364.62407480355
Rt20119 T3590 T5838 1829605.9250343293
Gcorr6769 T3590 T5902 T3590 T5902 -1.2648891432264154e-07
Rt20120 T3591 T3950 702486.0213341068
Rt20121 T3591 T4129 398012.14655692742
Gcorr6770 T3591 T5250 T3591 T5250 -5.8135410378357695e-07
Gcorr6771 T3591 T5251 T3591 T5251 -3.7834857771304025e-07
Rt20122 T3591 T5339 318637.57485383761
Gcorr6772 T3591 T5369 T3591 T5369 -5.169946748605132e-07
Rt20123 T3591 T5930 15724293.204444287
Rt20124 T3592 T3818 1441499.4151251677
Rt20125 T3592 T4849 2165651.5063064038
Gcorr6773 T3592 T4851 T3592 T4851 -1.0717977770102409e-07
Rt20126 T3592 T5045 12468644.006531978
Rt20127 T3592 T5397 203824803.37417698
Rt20128 T3593 T3898 1389990.1651210478
Rt20129 T3593 T4375 7103541.1499562468
Rt20130 T3593 T4378 8517784.425507199
Rt20131 T3593 T5502 5392908.4566992689
Rt20132 T3594 T3655 1791555.7191755241
Rt20133 T3594 T4172 930226.97695637657
Gcorr6774 T3594 T4641 T3594 T4641 -1.1664218142824468e-07
Rt20134 T3594 T4642 1007514.1798393553
Rt20135 T3594 T4643 12919259.307419285
Gcorr6775 T3594 T4724 T3594 T4724 -1.0316982485798623e-07
Gcorr6776 T3594 T5637 T3594 T5637 -4.6803337902333191e-07
Rt20136 T3595 T3764 3575984.2691941066
Rt20137 T3595 T3972 2782463.6540680309
Rt20138 T3595 T4018 1151499.3079177067
Rt20139 T3595 T4246 8990802.3674871325
Rt20140 T3595 T4694 2288272.8424979588
Gcorr6777 T3595 T5651 T3595 T5651 -1.4112041592455603e-07
Rt20141 T3596 T3755 3076209.2352134972
Rt20142 T3596 T4020 2539876.4532242771
Rt20143 T3596 T4021 1493888.7155298379
Gcorr6778 T3596 T4674 T3596 T4674 -2.541656488334945e-07
Rt20144 T3596 T4676 1976698.1270941421
Rt20145 T3596 T4677 10130188.320529768
Rt20146 T3596 T5867 13687021.332026504
Rt20147 T3597 T3598 1797325.6496714777
Rt20148 T3597 T3599 4554860.2041754881
Rt20149 T3597 T3913 1362953.6269410155
Rt20150 T3597 T4355 8499598.5243064333
Rt20151 T3597 T4357 12711112.133043878
Gcorr6779 T3597 T4369 T3597 T4369 -1.6854516034296203e-07
Rt20152 T3597 T5622 2629638.3778015897
Rt20153 T3598 T3599 1220886.0892277241
Rt20154 T3598 T3802 1532219.1643508107
Rt20155 T3598 T3953 1240799.2423053009
Gcorr6780 T3598 T4353 T3598 T4353 -1.2660096137991267e-08
Rt20156 T3598 T4355 3004315.7619175934
Rt20157 T3598 T4356 2927573.9949037153
Gcorr6781 T3598 T4357 T3598 T4357 -1.3770984084659448e-07
Rt20158 T3599 T3913 1307047.1350691447
Rt20159 T3599 T4097 1043983.6727692713
Gcorr6782 T3599 T4356 T3599 T4356 -4.4899598016208924e-08
Rt20160 T3599 T4357 2398905.4998640935
Rt20161 T3599 T4358 12305103.922637912
Rt20162 T3599 T4359 63656507.859828204
Rt20163 T3600 T3818 13357827.895556007
Rt20164 T3600 T4063 1067186.1838770953
Rt20165 T3600 T4851 37069834.954887643
Rt20166 T3600 T4852 2205397.9590619211
Rt20167 T3600 T4853 9150229.683925407
Gcorr6783 T3600 T4938 T3600 T4938 -9.2047801753455484e-08
Rt20168 T3601 T4186 1834144.6150786292
Rt20169 T3601 T4900 1020770.3256295561
Rt20170 T3601 T5321 34974612.106550708
Rt20171 T3601 T5757 1486887.0205510464
Rt20172 T3601 T5890 246076411.67022437
Rt20173 T3602 T3603 6505749.6211745013
Rt20174 T3602 T3761 952278.3340451332
Rt20175 T3602 T4041 912577.53476091707
Rt20176 T3602 T4981 6761304.7312652785
Gcorr6784 T3602 T5368 T3602 T5368 -1.179532758181223e-08
Rt20177 T3602 T5575 1411403.6648459234
Gcorr6785 T3602 T5685 T3602 T5685 -1.0360248132553941e-07
Gcorr6786 T3602 T5959 T3602 T5959 -1.6488817405065136e-07
Rt20178 T3603 T3765 1880612.1093537158
Rt20179 T3603 T3773 1770199.7371364916
Rt20180 T3603 T3975 2357916.0890695397
Rt20181 T3603 T4041 1207198.3198072945
Rt20182 T3603 T4978 1866470.1767172795
Gcorr6787 T3603 T4979 T3603 T4979 -2.2889121360246284e-07
Rt20183 T3603 T4980 9950629.3022676483
Rt20184 T3603 T5575 13419341.810847552
Rt20185 T3604 T3949 1252760.9251540005
Rt20186 T3604 T4010 1254031.3164822028
Rt20187 T3604 T4948 2155568.5667302241
Rt20188 T3604 T5069 20815867.85972948
Rt20189 T3604 T5070 11595848.878710883
Gcorr6788 T3604 T5071 T3604 T5071 -1.4610993157820874e-07
Rt20190 T3605 T3708 2701515.6060514506
Rt20191 T3605 T3875 1026424.1025229929
Rt20192 T3605 T4048 1082182.3216501006
Rt20193 T3605 T4476 4833239.6745596714
Gcorr6789 T3605 T4477 T3605 T4477 -1.7099747250424583e-07
Rt20194 T3605 T4478 1831835.838823877
Rt20195 T3605 T5247 3591292.6809339952
Gcorr6790 T3605 T5983 T3605 T5983 -3.4365917566542894e-07
Rt20196 T3606 T3892 1328737.9090693975
Rt20197 T3606 T4055 1108945.5358096643
Rt20198 T3606 T5305 5742829.8691915218
Rt20199 T3606 T5488 20412613.910477087
Rt20200 T3606 T6046 12687881.460263854
Rt20201 T3606 T6049 16395722.468785016
Rt20202 T3607 T3959 785218.75358000095
Gcorr6791 T3607 T4653 T3607 T4653 -1.5213101373513198e-07
Rt20203 T3607 T4678 19330163.474738356
Rt20204 T3607 T4679 587176.55308501981
Gcorr6792 T3607 T4721 T3607 T4721 -1.5958054310327435e-07
Gcorr6793 T3607 T4722 T3607 T4722 -3.9921422404441561e-07
Gcorr6794 T3607 T5630 T3607 T5630 -4.8700308644350076e-07
Rt20205 T3608 T3614 1624690.6920270263
Rt20206 T3608 T3684 3344867.4608123824
Gcorr6795 T3608 T4514 T3608 T4514 -1.309236330537951e-07
Rt20207 T3608 T4515 16697923.069706911
Rt20208 T3608 T4516 2121284.4168009483
Rt20209 T3608 T4517 23215636.667341445
Rt20210 T3609 T3698 1590272.1997581925
Rt20211 T3609 T4023 1149491.7372067459
Rt20212 T3609 T5243 11062837.803229742
Gcorr6796 T3609 T5559 T3609 T5559 -3.2947607707412699e-09
Rt20213 T3609 T5756 4445180.0262549138
Rt20214 T3609 T6066 6128058.0460947733
Rt20215 T3610 T3888 1938511.2144516311
Rt20216 T3610 T4066 17400547.150368076
Rt20217 T3610 T4216 1426187.0722967803
Rt20218 T3610 T5343 473817.49343069235
Gcorr6797 T3610 T5917 T3610 T5917 -4.7361967273749716e-08
Rt20219 T3610 T6033 1813921.7742704195
Rt20220 T3611 T3612 1677437.4185129565
Rt20221 T3611 T3677 1646054.0871034197
Rt20222 T3611 T4794 3198087.9505967922
Gcorr6798 T3611 T5459 T3611 T5459 -8.5131501373296606e-08
Rt20223 T3611 T5802 3748040.5566704241
Gcorr6799 T3611 T5972 T3611 T5972 -9.1292964154784191e-08
Rt20224 T3612 T3677 8343867.1905953102
Rt20225 T3612 T3678 1492959.5925205252
Rt20226 T3612 T3679 1867100.3318024857
Rt20227 T3612 T3957 1200254.8536426262
Rt20228 T3612 T4794 12450503.563629778
Rt20229 T3612 T5644 5185774.8117911806
Gcorr6800 T3612 T5645 T3612 T5645 -1.6285872625676324e-07
Rt20230 T3612 T5972 2691370.0735626137
Rt20231 T3613 T3807 1329430.5989058046
Rt20232 T3613 T4207 1527385.4367575138
Rt20233 T3613 T5266 2210047.9386323444
Rt20234 T3613 T5351 2077903.5062008162
Rt20235 T3614 T3683 2671548.4086575042
Rt20236 T3614 T3684 1755046.2471114264
Rt20237 T3614 T3736 3115546.7736662156
Rt20238 T3614 T4514 3892908.3066221108
Gcorr6801 T3614 T4516 T3614 T4516 -9.6687517812247045e-08
Gcorr6802 T3614 T4633 T3614 T4633 -1.2468293349758371e-07
Rt20239 T3614 T5583 2132869.8161475714
Rt20240 T3615 T4063 196891.9433130188
Rt20241 T3615 T4152 6060006.5402867999
Gcorr6803 T3615 T4853 T3615 T4853 -1.9028540403849008e-06
Gcorr6804 T3615 T4939 T3615 T4939 -2.0697550926024643e-08
Rt20242 T3615 T5184 444166.05910139933
Rt20243 T3615 T6031 11501618.810620869
Rt20244 T3616 T3617 1542587.3437693359
Rt20245 T3616 T3928 1899374.6752235843
Rt20246 T3616 T4082 963170.9794979837
Gcorr6805 T3616 T4983 T3616 T4983 -1.4442781955950746e-07
Rt20247 T3616 T5216 2093495.4959293497
Rt20248 T3616 T5233 2443249.8411025382
Gcorr6806 T3616 T5300 T3616 T5300 -1.6749968046715258e-07
Rt20249 T3617 T3618 1866671.9193881911
Rt20250 T3617 T3628 5480728.5249742903
Rt20251 T3617 T3650 1049615.5828734902
Rt20252 T3617 T3928 239034.81276468816
Gcorr6807 T3617 T5233 T3617 T5233 -5.3164213127274976e-07
Rt20253 T3617 T5300 328125.94646467548
Gcorr6808 T3617 T5778 T3617 T5778 -5.3854333736264064e-08
Gcorr6809 T3617 T5889 T3617 T5889 -1.6746672713823843e-06
Rt20254 T3617 T5981 466333972.87905365
Gcorr6810 T3617 T6026 T3617 T6026 -2.7145347910392192e-07
Rt20255 T3618 T3650 8257347.4606698304
Rt20256 T3618 T3893 1235614.1805825722
Rt20257 T3618 T4035 1440070.7491330421
Gcorr6811 T3618 T4454 T3618 T4454 -1.3683509389550424e-07
Rt20258 T3618 T4613 5809589.0811160514
Rt20259 T3618 T5778 2555669.5386940045
Rt20260 T3618 T6026 7827075.4402418006
Rt20261 T3619 T3659 2001754.8948013647
Rt20262 T3619 T4133 1211448.9565482715
Rt20263 T3619 T4176 4566753.5070164138
Rt20264 T3619 T4646 5910108.3242531773
Gcorr6812 T3619 T4661 T3619 T4661 -1.2564516532981581e-07
Rt20265 T3619 T4662 2606574.1611381834
Rt20266 T3619 T4817 9971142.8828319646
Gcorr6813 T3619 T5603 T3619 T5603 -1.1268107772225438e-07
Rt20267 T3620 T3853 1629450.0115258761
Rt20268 T3620 T4091 1215093.7174979951
Gcorr6814 T3620 T5231 T3620 T5231 -8.4285075969338719e-08
Rt20269 T3620 T5478 9967088.5063550808
Rt20270 T3620 T5858 18838737.475790877
Rt20271 T3620 T5968 2492013.541973487
Rt20272 T3621 T3855 580424.92595143162
Rt20273 T3621 T5135 2103980.8384951334
Gcorr6815 T3621 T5136 T3621 T5136 -4.7885524778774867e-08
Gcorr6816 T3621 T5214 T3621 T5214 -7.8144049962958413e-08
Gcorr6817 T3621 T5826 T3621 T5826 -1.0705334863665204e-06
Rt20274 T3621 T5827 343634.93326272076
Rt20275 T3622 T3796 2217427.361247546
Rt20276 T3622 T3974 710403.71929012181
Rt20277 T3622 T4099 1847383.5757351106
Gcorr6818 T3622 T4845 T3622 T4845 -3.7273922250536476e-07
Gcorr6819 T3622 T5407 T3622 T5407 -2.6985272771312073e-07
Gcorr6820 T3622 T5408 T3622 T5408 -3.5981716480473375e-07
Rt20278 T3622 T5869 694654.64509322133
Rt20279 T3623 T3667 1729454.0601962367
Gcorr6821 T3623 T5254 T3623 T5254 -2.2730076676061743e-07
Rt20280 T3623 T5373 1880702.8112364034
Rt20281 T3623 T5665 82331541.509525046
Rt20282 T3623 T5752 6553508.7385502951
Rt20283 T3624 T3793 1878234.8979036112
Rt20284 T3624 T4057 1226202.872127726
Rt20285 T3624 T4744 1753039.4998986935
Rt20286 T3624 T4745 3804232.5403414886
Rt20287 T3624 T4768 1887162.6667753756
Gcorr6822 T3624 T4769 T3624 T4769 -1.3190191769312855e-07
Rt20288 T3625 T3826 1563305.8451943111
Rt20289 T3625 T3835 8832875.7250735369
Rt20290 T3625 T4142 1485455.9162603815
Gcorr6823 T3625 T4362 T3625 T4362 -9.3699414551491549e-08
Rt20291 T3625 T4363 6083815.5909155877
Rt20292 T3625 T4364 1683643.1342963297
Gcorr6824 T3625 T4365 T3625 T4365 -1.5611508247078372e-07
Rt20293 T3626 T3940 4994654.3653718587
Rt20294 T3626 T4023 1013413.7326396747
Rt20295 T3626 T4148 708483.57999572589
Rt20296 T3626 T4480 5128514.0830496745
Gcorr6825 T3626 T4482 T3626 T4482 -1.6166059151821466e-07
Rt20297 T3626 T4483 1939262.8116072346
Gcorr6826 T3626 T5243 T3626 T5243 -1.4102994498612412e-07
Rt20298 T3627 T3893 1698491.0990169288
Rt20299 T3627 T3999 919342.35731393308
Gcorr6827 T3627 T4453 T3627 T4453 -1.8470580613032306e-07
Rt20300 T3627 T4454 18365892.567798898
Rt20301 T3627 T4455 1321261.2501803495
Gcorr6828 T3627 T4456 T3627 T4456 -2.35886209146183e-07
Rt20302 T3628 T3650 1980553.7161118286
Rt20303 T3628 T3928 603153.61925256986
Rt20304 T3628 T4449 44183587.895394564
Rt20305 T3628 T4450 2328839.6329167639
Gcorr6829 T3628 T5889 T3628 T5889 -4.8042781557607154e-07
Rt20306 T3628 T5981 2255630.6295291544
Rt20307 T3629 T3711 3791493.5812236792
Rt20308 T3629 T3899 1525654.2490811823
Gcorr6830 T3629 T4257 T3629 T4257 -1.4102098048488937e-07
Rt20309 T3629 T4258 2562771.6929027364
Gcorr6831 T3629 T4261 T3629 T4261 -7.8055469905696623e-08
Rt20310 T3629 T5489 4070124.2144233105
Rt20311 T3630 T3751 3695520.4372862466
Gcorr6832 T3630 T4896 T3630 T4896 -7.8959802512734252e-08
Rt20312 T3630 T4902 1150899.2199700489
Gcorr6833 T3630 T5116 T3630 T5116 -3.7551358678585095e-07
Rt20313 T3630 T5393 22441707.135619868
Rt20314 T3631 T3646 1297952.8905183657
Rt20315 T3631 T3838 3129872.6534633897
Rt20316 T3631 T5142 1120604.8163521588
Gcorr6834 T3631 T5239 T3631 T5239 -1.2459392262727411e-07
Gcorr6835 T3631 T5273 T3631 T5273 -5.813451557863307e-07
Rt20317 T3631 T5738 3893491.4362872373
Rt20318 T3632 T3633 7159766.1113724308
Rt20319 T3632 T3994 2827077.2022072696
Rt20320 T3632 T4159 1146150.929049796
Rt20321 T3632 T4609 9255121.6896636374
Rt20322 T3632 T4699 22259172.524368826
Rt20323 T3632 T4701 2422014.8111649845
Gcorr6836 T3632 T5453 T3632 T5453 -1.9442881425182659e-07
Rt20324 T3633 T3634 1301541.9606852685
Rt20325 T3633 T3635 1828853.0134433033
Rt20326 T3633 T3639 2179938.9579066033
Rt20327 T3633 T4159 868416.8163892033
Rt20328 T3633 T4699 1684425.9875097382
Gcorr6837 T3633 T4700 T3633 T4700 -1.6289832481058974e-07
Gcorr6838 T3633 T4715 T3633 T4715 -1.1930603834132077e-07
Rt20329 T3633 T5652 9083414.9865057115
Rt20330 T3634 T3635 3268588.1743949004
Rt20331 T3634 T3636 766235.61311063205
Rt20332 T3634 T3638 4215402.4712252552
Rt20333 T3634 T3648 1695760.770221299
Rt20334 T3634 T4610 11737346.536968878
Gcorr6839 T3634 T4699 T3634 T4699 -1.8813342410483564e-07
Rt20335 T3634 T4700 1327034.2672532713
Rt20336 T3634 T4702 3732020.7695295238
Gcorr6840 T3634 T4703 T3634 T4703 -4.4371838357308022e-07
Rt20337 T3635 T3636 1784057.8588390646
Rt20338 T3635 T3637 1658055.8143666564
Rt20339 T3635 T3639 1553604.1513681735
Gcorr6841 T3635 T3730 T3635 T3730 -5.0119760621760529e-08
Rt20340 T3635 T4700 8905771.8521426171
Rt20341 T3635 T4730 5050267.3053118493
Rt20342 T3635 T5652 5312259.2465983992
Rt20343 T3635 T6076 9220575.1080078799
Rt20344 T3636 T3637 2122436.2567577814
Rt20345 T3636 T3638 1170492.7233903029
Rt20346 T3636 T3640 4423323.7540614419
Rt20347 T3636 T4153 1120098.2300045367
Gcorr6842 T3636 T4700 T3636 T4700 -2.1462268669227166e-07
Gcorr6843 T3636 T4702 T3636 T4702 -4.3801749165289115e-07
Rt20348 T3636 T4703 813053.80315072928
Rt20349 T3636 T4730 17674414.94629088
Gcorr6844 T3636 T6063 T3636 T6063 -1.2403301797326187e-07
Rt20350 T3637 T3730 1986823.9599398633
Gcorr6845 T3637 T3829 T3637 T3829 -1.123443320019655e-07
Rt20351 T3637 T4032 1559952.1053903257
Rt20352 T3637 T4153 1040900.0335962462
Rt20353 T3637 T4730 3648381.5979995499
Gcorr6846 T3637 T5447 T3637 T5447 -1.414187676941011e-07
Rt20354 T3637 T5844 1535002.1084187902
Gcorr6847 T3637 T6063 T3637 T6063 -3.4212418338918704e-08
Rt20355 T3637 T6076 9704694.1446277555
Rt20356 T3638 T3640 2248871.5705700042
Rt20357 T3638 T3648 4047703.3015945237
Rt20358 T3638 T3756 1165021.3646022917
Rt20359 T3638 T3877 1510862.3458418355
Rt20360 T3638 T4702 1436287.3473478633
Gcorr6848 T3638 T4703 T3638 T4703 -1.9711210799158083e-07
Rt20361 T3638 T4704 11278803.137424598
Gcorr6849 T3638 T5178 T3638 T5178 -1.1867047025019105e-07
Rt20362 T3639 T3729 1562329.9319644382
Rt20363 T3639 T3730 1835930.5034215224
Rt20364 T3639 T4159 3697018.9324505208
Rt20365 T3639 T4715 6604642.5946197975
Rt20366 T3639 T5652 6659335.9185333271
Rt20367 T3639 T5800 2225662.7407934666
Gcorr6850 T3639 T6076 T3639 T6076 -2.2239974686789677e-08
Rt20368 T3640 T3877 1123876.8738102713
Rt20369 T3640 T4153 1321840.6649725148
Rt20370 T3640 T4154 935134.02328844648
Rt20371 T3640 T4703 17927652.767895944
Rt20372 T3640 T4704 4644906.460769265
Rt20373 T3640 T4731 3442020.9814404137
Gcorr6851 T3640 T4732 T3640 T4732 -9.3665213007495517e-08
Rt20374 T3641 T3813 1565363.1672111242
Gcorr6852 T3641 T4904 T3641 T4904 -9.5690542894002816e-08
Rt20375 T3641 T4905 2847017.1820506952
Rt20376 T3641 T4906 3022943.8102460569
Gcorr6853 T3641 T5011 T3641 T5011 -1.4519084451221616e-07
Rt20377 T3642 T3758 1944479.7014129139
Rt20378 T3642 T3929 2647906.5379591645
Rt20379 T3642 T5066 12684827.183231637
Rt20380 T3642 T5234 3986145.8547698129
Rt20381 T3642 T5599 491948.70653566008
Gcorr6854 T3642 T5855 T3642 T5855 -1.9533937872739396e-06
Rt20382 T3643 T3649 2410515.4935917095
Rt20383 T3643 T3980 974117.5554883033
Gcorr6855 T3643 T4103 T3643 T4103 -7.7811386808380708e-08
Gcorr6856 T3643 T4993 T3643 T4993 -2.596381642437165e-08
Rt20384 T3643 T5236 5426126.3301046863
Rt20385 T3643 T5237 3529261.380715894
Rt20386 T3644 T3645 1960480.6643128882
Rt20387 T3644 T4070 1123777.6931109608
Gcorr6857 T3644 T4894 T3644 T4894 -1.8505450386433865e-08
Rt20388 T3644 T5001 2698147.440450151
Rt20389 T3644 T5273 19516845.64456914
Rt20390 T3645 T3838 2203028.8481943281
Rt20391 T3645 T3997 868796.14526703523
Rt20392 T3645 T4070 4279010.3927030955
Rt20393 T3645 T4891 2003931.0936991444
Gcorr6858 T3645 T4892 T3645 T4892 -1.5072218271142587e-07
Rt20394 T3645 T4894 3312447.2397901318
Gcorr6859 T3645 T5273 T3645 T5273 -1.503860256372894e-07
Rt20395 T3646 T4132 1063805.7065186745
Gcorr6860 T3646 T5142 T3646 T5142 -1.3128688976529771e-07
Rt20396 T3646 T5232 2508720.789689058
Rt20397 T3646 T5239 3512089.4267565659
Rt20398 T3646 T5311 31983011.148009676
Gcorr6861 T3646 T6077 T3646 T6077 -1.5440040652242085e-07
Rt20399 T3647 T3954 1334071.5873409407
Rt20400 T3647 T4160 1861541.8192996024
Gcorr6862 T3647 T4257 T3647 T4257 -1.3899142889390743e-07
Rt20401 T3647 T4428 2539335.8002105802
Rt20402 T3647 T4907 4598619.7194307046
Gcorr6863 T3647 T4908 T3647 T4908 -1.036094785984632e-07
Rt20403 T3648 T3756 1857220.7661818899
Gcorr6864 T3648 T4421 T3648 T4421 -4.0275229153813404e-07
Rt20404 T3648 T4610 2682645.7593498747
Rt20405 T3648 T4702 9686327.8184876386
Rt20406 T3648 T5412 2794146.5425917832
Rt20407 T3649 T4103 869739.98801181198
Rt20408 T3649 T5237 1810387.9815633001
Gcorr6865 T3649 T5392 T3649 T5392 -1.8413201800417506e-07
Gcorr6866 T3649 T5396 T3649 T5396 -4.9593942758242443e-08
Rt20409 T3649 T5466 46616222.612997368
Rt20410 T3650 T4449 15485038.165755412
Rt20411 T3650 T4452 4733987.8345190287
Gcorr6867 T3650 T5300 T3650 T5300 -2.7699692464209853e-07
Rt20412 T3650 T5778 5628326.9112566328
Rt20413 T3650 T5981 3399258.7454845291
Rt20414 T3651 T3876 1263005.2857160273
Rt20415 T3651 T4379 3021974.3307374767
Gcorr6868 T3651 T4381 T3651 T4381 -1.049199106853222e-07
Rt20416 T3651 T4382 2996093.0125464126
Gcorr6869 T3651 T5438 T3651 T5438 -1.2139867533951029e-07
Rt20417 T3652 T3903 1226089.9662700607
Rt20418 T3652 T4114 6458751.5417692345
Rt20419 T3652 T4880 6687939.2162156776
Rt20420 T3652 T5197 3919457.5805968852
Rt20421 T3652 T5588 8363474.3472407777
Gcorr6870 T3652 T5677 T3652 T5677 -1.2597385435878684e-07
Rt20422 T3653 T3832 2150234.1792344013
Rt20423 T3653 T4579 3774820.3701746841
Gcorr6871 T3653 T4583 T3653 T4583 -6.704417873774358e-08
Gcorr6872 T3653 T4585 T3653 T4585 -1.2724328319497424e-07
Rt20424 T3653 T5461 2587246.3500242773
Rt20425 T3654 T3659 6920355.3617428821
Rt20426 T3654 T3747 3886274.3748234068
Rt20427 T3654 T4176 476698.76681388769
Rt20428 T3654 T4644 1313861.1387613018
Gcorr6873 T3654 T4646 T3654 T4646 -4.6270309188301149e-07
Rt20429 T3654 T5353 3783891.32525917
Gcorr6874 T3654 T5451 T3654 T5451 -1.7963358241971819e-07
Rt20430 T3655 T3811 1764380.5983234697
Rt20431 T3655 T4172 1903153.6896009175
Gcorr6875 T3655 T4642 T3655 T4642 -1.610633389638039e-07
Rt20432 T3655 T5050 1593468.4080243567
Gcorr6876 T3655 T5606 T3655 T5606 -1.8130512033709228e-07
Rt20433 T3655 T5637 4837785.7499562176
Rt20434 T3656 T3658 1368925.3738911208
Rt20435 T3656 T3697 1388159.7557520196
Rt20436 T3656 T4681 15988474.38908428
Rt20437 T3656 T4719 2158623.478525768
Rt20438 T3656 T4758 11808778.217152638
Gcorr6877 T3656 T4759 T3656 T4759 -1.3192168472821672e-07
Rt20439 T3657 T3902 997801.02753616229
Rt20440 T3657 T4118 6317772.3217214113
Gcorr6878 T3657 T5123 T3657 T5123 -7.9035419274636077e-08
Rt20441 T3657 T5520 3384829.1007899377
Rt20442 T3657 T5682 5519267.4900311604
Rt20443 T3658 T3696 1365016.3459343861
Gcorr6879 T3658 T4607 T3658 T4607 -4.7462728515125198e-07
Rt20444 T3658 T4680 1010431.0422748645
Rt20445 T3658 T4681 27423500.271052405
Rt20446 T3658 T4719 16999220.942516353
Gcorr6880 T3658 T4720 T3658 T4720 -1.3816119110912732e-07
Rt20447 T3659 T4176 935747.00788551115
Gcorr6881 T3659 T4646 T3659 T4646 -8.4254263706761852e-08
Rt20448 T3659 T4817 3134306.4556973898
Rt20449 T3659 T5353 1810679.4749417994
Gcorr6882 T3659 T5354 T3659 T5354 -4.0004023130165429e-07
Rt20450 T3660 T3861 1394070.2977953278
Rt20451 T3660 T4409 3792830.0954318
Gcorr6883 T3660 T4425 T3660 T4425 -1.4583980703588881e-07
Gcorr6884 T3660 T4595 T3660 T4595 -6.9004196337569943e-08
Rt20452 T3660 T5494 2446303.4294346073
Rt20453 T3661 T3895 1383017.5103693269
Rt20454 T3661 T4798 3716531.0117938654
Gcorr6885 T3661 T4799 T3661 T4799 -1.0840054037000084e-07
Rt20455 T3661 T4800 2183188.9757611263
Gcorr6886 T3661 T5394 T3661 T5394 -1.6264443446578326e-07
Gcorr6887 T3662 T3900 T3662 T3900 -2.9689134920250951e-07
Rt20456 T3662 T4015 575337.93399598275
Rt20457 T3662 T4074 570674.80234763899
Rt20458 T3662 T4296 655428.40350440098
Rt20459 T3662 T4300 1692537.1891320094
Rt20460 T3662 T5120 1641494.2048124748
Gcorr6888 T3662 T5987 T3662 T5987 -5.4540282430099811e-07
Rt20461 T3663 T3782 1512278.5619064523
Rt20462 T3663 T3827 1487152.7452329365
Gcorr6889 T3663 T5108 T3663 T5108 -7.1273832445891702e-08
Gcorr6890 T3663 T5129 T3663 T5129 -1.4256868268425732e-07
Rt20463 T3663 T5499 3206478.7583500361
Rt20464 T3663 T5736 3502380.4171983493
Rt20465 T3664 T3666 1335509.7923714714
Rt20466 T3664 T3918 1432351.665163595
Gcorr6891 T3664 T5109 T3664 T5109 -8.6536608393662106e-08
Rt20467 T3664 T5345 4296886.5014397427
Rt20468 T3664 T5346 5069214.1176791219
Rt20469 T3664 T5726 26119083.538324032
Gcorr6892 T3665 T3991 T3665 T3991 -1.0039282384019682e-08
Rt20470 T3665 T4805 1804347.9580051207
Gcorr6893 T3665 T4859 T3665 T4859 -1.5460899578553239e-07
Rt20471 T3665 T4860 7898824.4334968217
Rt20472 T3665 T4934 2372434.0344441333
Gcorr6894 T3665 T5331 T3665 T5331 -4.2793141889249649e-07
Rt20473 T3666 T3918 13030016.923552481
Rt20474 T3666 T4030 51332.687186148585
Rt20475 T3666 T5109 150602.81211141957
Gcorr6895 T3666 T5110 T3666 T5110 -2.8225423214210982e-07
Gcorr6896 T3666 T5173 T3666 T5173 -5.8585403889103676e-06
Gcorr6897 T3666 T5345 T3666 T5345 -1.7134581423647489e-09
Rt20476 T3667 T4069 1437801.1123647655
Rt20477 T3667 T4951 9745520.3519534133
Rt20478 T3667 T5254 34023141.4600811
Rt20479 T3667 T5752 6630753.4184400663
Rt20480 T3667 T5884 8979605.0423105098
Rt20481 T3668 T3895 2718064.5936998297
Rt20482 T3668 T4086 515501.41014708794
Rt20483 T3668 T4095 1166987.0752474465
Gcorr6898 T3668 T4801 T3668 T4801 -9.8282589019739572e-08
Rt20484 T3668 T4866 1202318.9480536231
Rt20485 T3668 T5372 23260597.281736318
Rt20486 T3668 T5980 7751916.5875325194
Gcorr6899 T3668 T6080 T3668 T6080 -5.3592322035872013e-07
Rt20487 T3669 T3672 2107695.1644559265
Rt20488 T3669 T3757 2032633.6694249846
Rt20489 T3669 T4116 2187008.2397691072
Rt20490 T3669 T4469 8124446.0705639087
Rt20491 T3669 T4632 5505216.7984454846
Rt20492 T3669 T5504 12906752.739106936
Rt20493 T3670 T3785 729234.88104081061
Rt20494 T3670 T3805 3175115.4602885693
Rt20495 T3670 T5455 30342234.665345091
Gcorr6900 T3670 T5456 T3670 T5456 -1.9351149898462548e-07
Rt20496 T3670 T5457 935925.05460135685
Gcorr6901 T3670 T5723 T3670 T5723 -3.6202141783923486e-07
Gcorr6902 T3670 T5916 T3670 T5916 -1.2742988499843164e-07
Rt20497 T3671 T3949 1058432.5321299385
Rt20498 T3671 T4025 3134568.9183877483
Gcorr6903 T3671 T5070 T3671 T5070 -2.2589097265213167e-07
Rt20499 T3671 T5073 1298362.9621271014
Gcorr6904 T3671 T5107 T3671 T5107 -2.3706608651111202e-07
Rt20500 T3671 T5418 11276490.785432711
Rt20501 T3672 T4116 962154.14076760015
Rt20502 T3672 T4469 3417324.6800545836
Gcorr6905 T3672 T4470 T3672 T4470 -1.5034015745970473e-07
Rt20503 T3672 T4471 2396698.3478216189
Gcorr6906 T3672 T5504 T3672 T5504 -1.8046388964704128e-07
Rt20504 T3673 T3674 1987773.5051433516
Rt20505 T3673 T3992 2693794.3383433949
Rt20506 T3673 T5075 11690312.024848063
Rt20507 T3673 T5076 2148594.1926336973
Rt20508 T3673 T5077 3545126.8772010347
Gcorr6907 T3673 T5078 T3673 T5078 -4.4118457132907372e-07
Rt20509 T3674 T3992 1871150.6610509362
Rt20510 T3674 T4025 1117192.5517352358
Rt20511 T3674 T5074 2291257.1930275718
Gcorr6908 T3674 T5075 T3674 T5075 -2.1189188262858021e-07
Rt20512 T3674 T5076 14109648.192117875
Gcorr6909 T3674 T5100 T3674 T5100 -9.5626053835931077e-08
Rt20513 T3674 T5572 3924599.2631519134
Rt20514 T3675 T3872 1825251.1779677342
Rt20515 T3675 T4648 7283824.2103914227
Rt20516 T3675 T4649 9080874.493896544
Rt20517 T3675 T4650 5344459.2234177627
Rt20518 T3676 T3914 1821126.3910028443
Gcorr6910 T3676 T4705 T3676 T4705 -1.5559773280676452e-07
Rt20519 T3676 T4706 8200297.1304073706
Rt20520 T3676 T4762 2599553.2990872688
Rt20521 T3676 T4763 13556780.418519972
Rt20522 T3677 T3678 1571482.1144202088
Rt20523 T3677 T4029 1134477.4374515337
Rt20524 T3677 T5187 3087822.5739659825
Rt20525 T3677 T5802 17313681.139607668
Rt20526 T3677 T5972 10698598.349610681
Rt20527 T3678 T3679 1204065.9118062819
Gcorr6911 T3678 T3825 T3678 T3825 -7.8517660461796036e-08
Gcorr6912 T3678 T5043 T3678 T5043 -7.515005682119671e-07
Rt20528 T3678 T5187 38231352.699603207
Rt20529 T3678 T5645 635847.00315079803
Rt20530 T3678 T5646 36336497.720188953
Gcorr6913 T3678 T5966 T3678 T5966 -6.982922580497017e-08
Gcorr6914 T3678 T5972 T3678 T5972 -1.0788491154932649e-08
Rt20531 T3679 T3921 1273159.6686443121
Rt20532 T3679 T3957 30170501.646433
Rt20533 T3679 T4068 1024081.6832204828
Rt20534 T3679 T4864 2393566.2742750579
Rt20535 T3679 T5043 16727018.203666218
Rt20536 T3679 T5644 12090494.630360169
Rt20537 T3679 T5645 8571043.3815685008
Rt20538 T3680 T3989 7734220.8373851441
Gcorr6915 T3680 T4031 T3680 T4031 -6.3187299157732231e-07
Rt20539 T3680 T4271 710128.04480041156
Rt20540 T3680 T4275 1243368.9661316108
Rt20541 T3680 T4466 713492.441640442
Rt20542 T3680 T5915 10363931.36911056
Gcorr6916 T3681 T3798 T3681 T3798 -5.8617414914741373e-07
Rt20543 T3681 T3985 1474649.2057435906
Rt20544 T3681 T4003 1350650.4505025337
Gcorr6917 T3681 T4223 T3681 T4223 -2.5449416931057297e-07
Rt20545 T3681 T5210 2015460.8903368602
Rt20546 T3681 T5828 664821.72649437946
Rt20547 T3681 T5829 1458088.0156268158
Gcorr6918 T3681 T6001 T3681 T6001 -1.4599340702883366e-07
Rt20548 T3682 T3961 907729.67463523464
Rt20549 T3682 T4017 1316578.1605263778
Gcorr6919 T3682 T4394 T3682 T4394 -1.4923330490428606e-07
Rt20550 T3682 T4396 5803780.542315769
Rt20551 T3682 T5437 2844459.4767121081
Rt20552 T3683 T3873 1230278.4076782628
Rt20553 T3683 T4513 2097181.0203875606
Rt20554 T3683 T4514 20687618.748123724
Rt20555 T3683 T4633 2711330.6454215548
Gcorr6920 T3683 T5059 T3683 T5059 -4.2612715138636794e-07
Rt20556 T3684 T3736 3486890.8351004981
Rt20557 T3684 T4516 4854004.5394657506
Rt20558 T3684 T4518 14641917.98486788
Rt20559 T3684 T4647 971180.94462768012
Gcorr6921 T3684 T5467 T3684 T5467 -6.4440178239649626e-07
Rt20560 T3684 T5583 45372130.644236125
Gcorr6922 T3684 T6025 T3684 T6025 -1.2684414286216366e-07
Gcorr6923 T3685 T3910 T3685 T3910 -3.3656560037377625e-09
Rt20561 T3685 T4119 4443600.7674920512
Rt20562 T3685 T5085 45196131.219475552
Rt20563 T3685 T5086 14113266.569133122
Rt20564 T3685 T5087 2788579.2414341494
Rt20565 T3685 T5088 150295964.74646521
Rt20566 T3686 T3732 1857466.1367687723
Rt20567 T3686 T3733 2067252.5739020358
Rt20568 T3686 T4333 8948933.5327620991
Gcorr6924 T3686 T4335 T3686 T4335 -1.6947106123550735e-07
Rt20569 T3686 T4337 2396469.1120612873
Rt20570 T3686 T5325 23099365.442535724
Rt20571 T3687 T3820 768953.92279528524
Gcorr6925 T3687 T4335 T3687 T4335 -4.259506209323596e-07
Rt20572 T3687 T5255 57636901.192380436
Rt20573 T3687 T5413 837455.26863847324
Gcorr6926 T3687 T5920 T3687 T5920 -3.6131504879234892e-07
Gcorr6927 T3688 T4121 T3688 T4121 -1.0246990588619216e-07
Rt20574 T3688 T5624 600624.6944420177
Gcorr6928 T3688 T5671 T3688 T5671 -5.8824122955760316e-07
Rt20575 T3688 T5672 1912945.5289509194
Rt20576 T3688 T5789 4767274.7058009235
Rt20577 T3689 T3690 1517595.4169822102
Rt20578 T3689 T4014 799188.91552395129
Gcorr6929 T3689 T4026 T3689 T4026 -5.5712030841068385e-08
Rt20579 T3689 T4950 877907.8797659101
Gcorr6930 T3689 T4992 T3689 T4992 -3.3295632323827099e-07
Rt20580 T3689 T5038 5585353.9189294353
Rt20581 T3689 T5163 5300102.6611819956
Rt20582 T3689 T5641 4632036.1812930964
Rt20583 T3690 T3753 533832.68110779754
Gcorr6931 T3690 T4014 T3690 T4014 -1.9028296328468371e-07
Rt20584 T3690 T4106 1251161.8587385244
Rt20585 T3690 T4992 2848636.8260726207
Rt20586 T3690 T5163 418376.59559358098
Rt20587 T3690 T5240 3685441.2827807982
Gcorr6932 T3690 T5642 T3690 T5642 -6.3409611805937965e-07
Rt20588 T3690 T5894 1267323732.0070951
Rt20589 T3691 T4191 873345.07957221882
Rt20590 T3691 T4522 6741361.5636506509
Rt20591 T3691 T4524 6755260.2768515535
Rt20592 T3691 T5767 139614774.98629016
Gcorr6933 T3692 T5133 T3692 T5133 -5.8048436293116239e-07
Rt20593 T3692 T5207 1281665.5036786464
Rt20594 T3692 T5380 2058589.0427775483
Gcorr6934 T3692 T5743 T3692 T5743 -1.1243576193138729e-07
Rt20595 T3693 T4368 7559180.9176340038
Rt20596 T3693 T4370 5941839.0421449598
Rt20597 T3693 T4371 7299540.1376993982
Rt20598 T3694 T3892 1505573.0350166119
Rt20599 T3694 T3937 14915005.41850245
Rt20600 T3694 T4005 1181157.2267906379
Rt20601 T3694 T4652 14259050.318485193
Rt20602 T3694 T5480 5283196.3693760019
Rt20603 T3694 T6018 6736462.1182231791
Rt20604 T3695 T3752 4138421.4447716707
Rt20605 T3695 T3819 2258535.6189830671
Rt20606 T3695 T4131 1631491.6579256726
Rt20607 T3695 T5509 8221408.8370164372
Rt20608 T3695 T5510 2447742.9573191032
Rt20609 T3695 T5511 2879217.401534148
Gcorr6935 T3695 T5785 T3695 T5785 -4.2579435094336278e-07
Rt20610 T3696 T4177 554806.37141347385
Gcorr6936 T3696 T4680 T3696 T4680 -1.1297266331362333e-07
Rt20611 T3696 T4720 2157650.4438005909
Rt20612 T3696 T5469 2226558.467639585
Gcorr6937 T3696 T5739 T3696 T5739 -4.3057040323483094e-07
Rt20613 T3697 T4161 1262412.6860807959
Gcorr6938 T3697 T4719 T3697 T4719 -4.76789462197869e-08
Rt20614 T3697 T4759 2896765.9997522025
Gcorr6939 T3697 T4942 T3697 T4942 -1.4170151902191127e-07
Rt20615 T3697 T5596 4297111.4603229472
Rt20616 T3698 T3964 1117929.6528027889
Rt20617 T3698 T5041 1581348.3831014147
Gcorr6940 T3698 T5320 T3698 T5320 -1.9389724730358937e-07
Gcorr6941 T3698 T5559 T3698 T5559 -2.2258408284767482e-07
Rt20618 T3698 T5756 5749531.1303661559
Rt20619 T3699 T3797 7487333.4803795693
Rt20620 T3699 T4002 811880.36001386354
Rt20621 T3699 T4081 1108050.0003477545
Gcorr6942 T3699 T4657 T3699 T4657 -1.8320799319006253e-07
Rt20622 T3699 T4658 304366840.89730096
Gcorr6943 T3699 T4687 T3699 T4687 -4.0954014199831095e-07
Rt20623 T3699 T5632 790776.23238801211
Gcorr6944 T3699 T5999 T3699 T5999 -2.7624742845123424e-07
Gcorr6945 T3700 T3861 T3700 T3861 -2.5061661052392913e-08
Rt20624 T3700 T4051 563792.4265301401
Rt20625 T3700 T4069 703848.11675412511
Rt20626 T3700 T5344 1043241.0068097262
Gcorr6946 T3700 T5491 T3700 T5491 -1.5174485175521392e-07
Gcorr6947 T3700 T5884 T3700 T5884 -1.7678391798353852e-07
Gcorr6948 T3700 T6073 T3700 T6073 -1.9474668293337202e-07
Rt20627 T3701 T3883 1954476.9181294299
Rt20628 T3701 T3884 3122651.6130079771
Rt20629 T3701 T4386 16391948.774058172
Rt20630 T3701 T4388 2568387.4533958812
Rt20631 T3701 T4389 2563021.4522052286
Gcorr6949 T3701 T5417 T3701 T5417 -4.6265086788698495e-07
Rt20632 T3702 T3981 1142387.6596044877
Rt20633 T3702 T4085 1051270.7143255286
Rt20634 T3702 T4935 13826628.642398829
Rt20635 T3702 T4963 8101780.616092924
Rt20636 T3702 T4964 2082965.9217706295
Gcorr6950 T3702 T4965 T3702 T4965 -4.9831870981322958e-08
Gcorr6951 T3702 T5881 T3702 T5881 -1.6106575450110247e-07
Rt20637 T3703 T3915 1069443.5503876891
Rt20638 T3703 T4013 896437.6373534255
Rt20639 T3703 T5285 9525109.6192621905
Rt20640 T3703 T5319 925315.343732993
Gcorr6952 T3703 T5729 T3703 T5729 -6.3240690232742159e-08
Gcorr6953 T3703 T5882 T3703 T5882 -4.2300846882137836e-07
Rt20641 T3704 T3794 13639535.524737932
Rt20642 T3704 T3845 1460706.6533899519
Rt20643 T3704 T3908 1373609.6228400001
Rt20644 T3704 T4535 13650173.425435744
Rt20645 T3704 T4536 3323110.3316810387
Rt20646 T3704 T4537 5953859.2608162966
Gcorr6954 T3704 T5440 T3704 T5440 -1.2227104977247773e-07
Rt20647 T3705 T3706 569305.11273158656
Rt20648 T3705 T4229 4432381.5118380832
Gcorr6955 T3705 T5403 T3705 T5403 -2.3208480673106245e-07
Rt20649 T3705 T5404 286875.57268354762
Gcorr6956 T3705 T5435 T3705 T5435 -1.2426480131302054e-06
Rt20650 T3705 T5891 1442540.8149533798
Gcorr6957 T3706 T3781 T3706 T3781 -8.1106606744406517e-07
Gcorr6958 T3706 T3973 T3706 T3973 -3.8124240398165854e-07
Gcorr6959 T3706 T3986 T3706 T3986 -1.5098481660350551e-07
Rt20651 T3706 T4000 669470.95079763466
Rt20652 T3706 T5404 940423.41817521595
Rt20653 T3706 T5411 503095.23502856877
Rt20654 T3706 T5435 480833.06850250065
Rt20655 T3707 T4068 1112124.1528312454
Rt20656 T3707 T4126 1182341.491167
Gcorr6960 T3707 T4796 T3707 T4796 -1.3707024342235403e-07
Rt20657 T3707 T4846 3759310.6491957381
Rt20658 T3707 T4863 2297733.5299543436
Gcorr6961 T3707 T5772 T3707 T5772 -8.5977281029699202e-08
Rt20659 T3708 T3874 1333261.3141988507
Rt20660 T3708 T3875 1105200.6703983992
Rt20661 T3708 T4071 938452.40579142864
Gcorr6962 T3708 T4841 T3708 T4841 -3.3640640908164861e-07
Rt20662 T3708 T5247 789510.41730673984
Gcorr6963 T3708 T5918 T3708 T5918 -3.105461662207497e-07
Gcorr6964 T3708 T5983 T3708 T5983 -2.2117961394373187e-07
Rt20663 T3709 T3710 668354.69972598646
Rt20664 T3709 T3988 1929454.0079924851
Rt20665 T3709 T5200 2971563.4270183379
Rt20666 T3709 T6038 1994448.9416717042
Rt20667 T3709 T6039 325632.98767595401
Gcorr6965 T3710 T3778 T3710 T3778 -1.0481193789384782e-07
Gcorr6966 T3710 T3863 T3710 T3863 -1.8475499097563577e-07
Rt20668 T3710 T4231 469734.71284047834
Rt20669 T3710 T4240 8887377.7456529271
Rt20670 T3710 T5200 632566.64806585107
Gcorr6967 T3710 T6039 T3710 T6039 -8.2302811736342672e-07
Rt20671 T3711 T3899 1281425.5769324799
Rt20672 T3711 T4024 1273303.46901108
Rt20673 T3711 T4160 726690.0994249885
Gcorr6968 T3711 T4907 T3711 T4907 -5.0666286939465599e-07
Rt20674 T3711 T5489 1403362.4227409088
Rt20675 T3711 T5490 4661994.8052584091
Gcorr6969 T3711 T5661 T3711 T5661 -1.8077537951599664e-08
Rt20676 T3712 T3856 2478172.8813649626
Rt20677 T3712 T4108 1061611.2798457481
Rt20678 T3712 T5335 2598302.3611462875
Rt20679 T3712 T5899 1483779.500023505
Rt20680 T3712 T6012 446526.04597755155
Rt20681 T3713 T3714 1314504.7058571274
Rt20682 T3713 T3941 2416415.5040096538
Gcorr6970 T3713 T4602 T3713 T4602 -1.3586789090618179e-07
Rt20683 T3713 T5015 3368763.2072521001
Gcorr6971 T3713 T5431 T3713 T5431 -7.2866706765992451e-07
Rt20684 T3713 T5432 1057318.3168821635
Rt20685 T3714 T3744 3105854.0349050728
Rt20686 T3714 T3941 7169982.9180305246
Rt20687 T3714 T4602 1078002.2579348418
Gcorr6972 T3714 T4707 T3714 T4707 -5.1657262398565144e-07
Rt20688 T3714 T4708 9460680.7620996255
Gcorr6973 T3714 T5015 T3714 T5015 -2.3360352733566397e-10
Gcorr6974 T3715 T3862 T3715 T3862 -2.8478688727765172e-07
Rt20689 T3715 T3906 600015.07268271758
Rt20690 T3715 T4212 428222.29735393228
Rt20691 T3715 T5703 5698870.7095732046
Rt20692 T3715 T5872 4220995.8353765029
Rt20693 T3715 T5902 3047990.0128366598
Rt20694 T3716 T3860 441183.93215668882
Gcorr6975 T3716 T4779 T3716 T4779 -6.7912228370716391e-07
Gcorr6976 T3716 T4780 T3716 T4780 -7.4536990524558641e-08
Rt20695 T3716 T4781 590085.63642671111
Gcorr6977 T3716 T4782 T3716 T4782 -1.3839013035810349e-07
Gcorr6978 T3716 T4783 T3716 T4783 -3.923862515075902e-07
Rt20696 T3717 T3907 823718.8787596483
Gcorr6979 T3717 T4313 T3717 T4313 -3.8903089790489955e-07
Rt20697 T3717 T4729 2010967.1032530596
Rt20698 T3717 T5360 5166358.3910657559
Rt20699 T3717 T5943 8074733.8375040451
Gcorr6980 T3717 T5982 T3717 T5982 -9.654090987407124e-09
Rt20700 T3718 T3842 5324672.2440559417
Rt20701 T3718 T3890 1099150.9266642758
Rt20702 T3718 T4073 2304983.518584915
Rt20703 T3718 T5208 3818868.4287248445
Rt20704 T3718 T5360 21318857.706410997
Rt20705 T3718 T5361 1948105.874781227
Gcorr6981 T3718 T5760 T3718 T5760 -1.0025809667749606e-07
Gcorr6982 T3718 T5982 T3718 T5982 -2.8673676166729202e-07
Rt20706 T3719 T3733 1616735.9327494502
Rt20707 T3719 T3834 9460262.341157658
Rt20708 T3719 T4334 1898677.4621024162
Gcorr6983 T3719 T4474 T3719 T4474 -4.2435514413991744e-07
Rt20709 T3719 T5264 1893318.2349925267
Gcorr6984 T3719 T5325 T3719 T5325 -1.5230245443205604e-07
Rt20710 T3720 T3848 1507237.7362733809
Rt20711 T3720 T3943 1975408.9263760499
Rt20712 T3720 T4102 3310357.5990914614
Gcorr6985 T3720 T4612 T3720 T4612 -9.0426511291031024e-08
Rt20713 T3720 T4696 2487254.0599524057
Rt20714 T3720 T4697 3652214.033793814
Gcorr6986 T3720 T4717 T3720 T4717 -1.3552503373868299e-07
Rt20715 T3721 T3722 1322046.7896955996
Gcorr6987 T3721 T3775 T3721 T3775 -4.6655006806230575e-09
Rt20716 T3721 T4084 114237.55327087357
Gcorr6988 T3721 T4970 T3721 T4970 -3.0670172877559178e-06
Rt20717 T3721 T4972 3056964.9300639173
Gcorr6989 T3721 T4975 T3721 T4975 -1.1550389654637751e-07
Rt20718 T3721 T5556 301976.3094472001
Rt20719 T3722 T3723 3986487.4199909279
Rt20720 T3722 T3775 546206.64444429229
Rt20721 T3722 T3975 2070181.0482692127
Gcorr6990 T3722 T4972 T3722 T4972 -3.0882012363558584e-07
Gcorr6991 T3722 T4974 T3722 T4974 -2.7832502883574146e-07
Rt20722 T3722 T4975 1015311.0234860232
Rt20723 T3722 T4976 40395157.213399842
Rt20724 T3722 T4977 101183186.90533835
Rt20725 T3723 T3783 2965827.2972334577
Rt20726 T3723 T3975 975485.03968039225
Rt20727 T3723 T4041 389040.76010526565
Rt20728 T3723 T4977 676878.73765671765
Gcorr6992 T3723 T4978 T3723 T4978 -2.769659364340669e-07
Gcorr6993 T3723 T4981 T3723 T4981 -5.1613333936686388e-07
Gcorr6994 T3723 T5068 T3723 T5068 -6.0301980060443723e-07
Rt20729 T3723 T6024 3233479.487473411
Gcorr6995 T3724 T4594 T3724 T4594 -3.4990596380095892e-07
Rt20730 T3724 T4599 941385.97627769259
Gcorr6996 T3724 T4600 T3724 T4600 -2.1871245198374489e-07
Rt20731 T3724 T4625 24483357.350892115
Gcorr6997 T3724 T5991 T3724 T5991 -5.533293526450935e-08
Rt20732 T3725 T3726 2039466.1905178507
Rt20733 T3725 T4042 1279887.811478043
Rt20734 T3725 T5287 412613.78428697056
Rt20735 T3725 T5288 3789813.3052077158
Rt20736 T3725 T5293 7113723.4757697247
Gcorr6998 T3725 T6015 T3725 T6015 -1.7349870021226516e-06
Rt20737 T3726 T3727 2049461.5783300111
Rt20738 T3726 T4049 11927032.76343601
Rt20739 T3726 T4112 1762976.7084069678
Rt20740 T3726 T5284 108985522.89034271
Rt20741 T3726 T5287 2261155.433061651
Rt20742 T3726 T5608 1348049.2361050872
Rt20743 T3726 T6015 1863281.4293046808
Rt20744 T3727 T3728 4762961.957160648
Gcorr6999 T3727 T4112 T3727 T4112 -1.5439005410817617e-07
Rt20745 T3727 T4235 18474839.042240292
Rt20746 T3727 T5291 270957.88604410709
Rt20747 T3727 T5608 3168600.8209723621
Rt20748 T3727 T6015 9794165.2031408418
Rt20749 T3728 T3821 43720005.828389317
Rt20750 T3728 T4222 456641.19044222467
Rt20751 T3728 T5291 878193.0881712269
Gcorr7000 T3728 T5293 T3728 T5293 -8.5719627072025874e-07
Gcorr7001 T3729 T4715 T3729 T4715 -1.3352722710747409e-07
Rt20752 T3729 T4723 1082968.0130302336
Gcorr7002 T3729 T4786 T3729 T4786 -2.8575067056371681e-07
Gcorr7003 T3729 T4857 T3729 T4857 -1.4865972767864258e-07
Rt20753 T3729 T5800 7523448.0709579494
Rt20754 T3730 T3731 1594754.8359986423
Rt20755 T3730 T4032 2546327.3543243278
Gcorr7004 T3730 T4857 T3730 T4857 -7.5530227023362934e-08
Rt20756 T3730 T5447 1433645.7427676297
Rt20757 T3730 T5800 20004176.660111614
Rt20758 T3730 T6076 4248546.3361205719
Rt20759 T3731 T4032 3943023.8533028904
Gcorr7005 T3731 T4857 T3731 T4857 -6.5250021953096319e-07
Gcorr7006 T3731 T4887 T3731 T4887 -1.4083575851401595e-08
Rt20760 T3731 T5347 461570.25397638651
Rt20761 T3731 T5447 8215944.507585112
Rt20762 T3731 T5627 4052551.6363432854
Gcorr7007 T3731 T5905 T3731 T5905 -9.489576737109111e-08
Rt20763 T3732 T3733 5320236.815072882
Rt20764 T3732 T3820 1365093.7307845769
Gcorr7008 T3732 T3927 T3732 T3927 -5.6317748575210546e-08
Rt20765 T3732 T4187 1040987.2887771156
Rt20766 T3732 T4331 4405167.8069648342
Rt20767 T3732 T4333 6338633.3801391507
Rt20768 T3732 T4335 11996329.534839494
Rt20769 T3733 T4187 950748.12533436681
Gcorr7009 T3733 T4332 T3733 T4332 -1.4162237574965175e-07
Rt20770 T3733 T4333 2836132.7665002118
Rt20771 T3733 T4334 6553679.6401591096
Rt20772 T3733 T5325 28452611.630300168
Rt20773 T3734 T3735 1712835.0750423542
Rt20774 T3734 T3779 1666762.8997521792
Rt20775 T3734 T4462 4101082.2304162425
Rt20776 T3734 T4465 5666609.9575169794
Rt20777 T3734 T4614 1037688.2831233165
Gcorr7010 T3734 T4619 T3734 T4619 -1.4022230303042842e-07
Gcorr7011 T3734 T6055 T3734 T6055 -3.5366685897016099e-07
Rt20778 T3735 T3840 1587791.2737470567
Rt20779 T3735 T4181 1083101.0600864578
Gcorr7012 T3735 T4614 T3735 T4614 -3.0537412145846464e-08
Rt20780 T3735 T4619 1486267.5638574124
Rt20781 T3735 T4755 1630095.2934139043
Rt20782 T3735 T4756 3218830.0021939813
Rt20783 T3736 T4090 1523851.5377970987
Rt20784 T3736 T5324 3815918.4188429439
Rt20785 T3736 T5583 11325191.619087333
Rt20786 T3736 T6025 4609995.9597556116
Rt20787 T3737 T3738 2578850.9638187452
Rt20788 T3737 T3955 3069163.7727135858
Rt20789 T3737 T4923 5177105.8487592759
Gcorr7013 T3737 T5202 T3737 T5202 -1.2490093232540476e-07
Rt20790 T3737 T5204 2799423.0530372411
Rt20791 T3737 T5260 9179283.4848028701
Rt20792 T3738 T3931 3212732.4924288499
Rt20793 T3738 T3955 1553674.9848022277
Rt20794 T3738 T5204 11388310.655746114
Gcorr7014 T3738 T5260 T3738 T5260 -2.345486993919883e-07
Rt20795 T3738 T5710 1063053.4642588433
Gcorr7015 T3738 T6028 T3738 T6028 -1.3474154768215849e-07
Rt20796 T3739 T3742 2187663.8777496307
Rt20797 T3739 T4134 1018265.2882449247
Gcorr7016 T3739 T4877 T3739 T4877 -1.466286364767646e-07
Rt20798 T3739 T5138 1369180.1501421626
Rt20799 T3739 T5430 16906187.293043103
Rt20800 T3739 T5431 5115554.0492260363
Gcorr7017 T3739 T5808 T3739 T5808 -4.5578268655987059e-07
Rt20801 T3740 T3957 3260399.5600139531
Rt20802 T3740 T4792 13683962.859385369
Rt20803 T3740 T4793 3076909.7668442042
Gcorr7018 T3740 T4795 T3740 T4795 -4.7616038109609306e-08
Rt20804 T3741 T3849 1318300.7632175935
Rt20805 T3741 T4119 6735472.3607047424
Gcorr7019 T3741 T5080 T3741 T5080 -1.5043159151247683e-07
Rt20806 T3741 T5082 1195669.6347278114
Gcorr7020 T3741 T5085 T3741 T5085 -5.0169905336900657e-07
Rt20807 T3741 T5587 3845676.2819794132
Rt20808 T3742 T4039 1496295.2817479956
Rt20809 T3742 T4727 21410995.065394118
Rt20810 T3742 T5138 1866285.7381748676
Rt20811 T3742 T5552 12380435.880511656
Gcorr7021 T3742 T5808 T3742 T5808 -2.9122871168132681e-07
Rt20812 T3743 T3883 804072.15887796343
Rt20813 T3743 T3909 1270561.8448817898
Rt20814 T3743 T4017 3494610.1040642085
Gcorr7022 T3743 T4389 T3743 T4389 -5.307272139385414e-07
Gcorr7023 T3743 T4391 T3743 T4391 -4.9738980353208583e-07
Rt20815 T3743 T4392 434454.04360390472
Gcorr7024 T3743 T4394 T3743 T4394 -2.5933032286718629e-08
Gcorr7025 T3743 T4395 T3743 T4395 -3.60709736024245e-07
Gcorr7026 T3743 T5597 T3743 T5597 -3.1315010652096511e-07
Rt20816 T3744 T3858 983757.11666627892
Rt20817 T3744 T4149 1380044.0664845856
Gcorr7027 T3744 T4499 T3744 T4499 -1.4478713320702869e-07
Rt20818 T3744 T4601 1366033.4416179948
Rt20819 T3744 T4602 4058414.619507506
Gcorr7028 T3744 T4707 T3744 T4707 -5.0800351920249255e-07
Rt20820 T3745 T3746 2557700.5104851122
Rt20821 T3745 T4084 1053909.595647875
Rt20822 T3745 T4969 2902445.5680141882
Gcorr7029 T3745 T4970 T3745 T4970 -1.6848986426448768e-07
Rt20823 T3745 T4971 1658338.5912821884
Gcorr7030 T3745 T5433 T3745 T5433 -4.4057244397314731e-07
Gcorr7031 T3746 T4966 T3746 T4966 -1.6264932404000065e-07
Rt20824 T3746 T4969 1500915.7026151025
Rt20825 T3746 T5374 17208034.962302223
Gcorr7032 T3746 T5433 T3746 T5433 -1.4838474140862709e-07
Rt20826 T3747 T4151 1213478.4595637326
Rt20827 T3747 T4176 2063126.7750444082
Rt20828 T3747 T4643 6857961.0447738478
Rt20829 T3747 T4644 12531384.68365325
Rt20830 T3747 T4645 5879277.3174222978
Rt20831 T3748 T3900 2364596.8136285711
Gcorr7033 T3748 T4293 T3748 T4293 -1.5295055523774405e-07
Rt20832 T3748 T4297 1271377.3118268643
Rt20833 T3748 T5349 10540314.311660862
Rt20834 T3748 T5634 2316870.2935985932
Rt20835 T3748 T6034 460605.95972621389
Rt20836 T3749 T4115 1157837.9452460774
Rt20837 T3749 T4142 1840911.6899173814
Rt20838 T3749 T4663 1869228.9007958029
Gcorr7034 T3749 T5636 T3749 T5636 -1.3035526513056045e-07
Rt20839 T3749 T5976 6202342.942158117
Rt20840 T3750 T3868 1397728.196474554
Rt20841 T3750 T4056 394297.47263635177
Rt20842 T3750 T4400 1043296.9937655927
Gcorr7035 T3750 T4402 T3750 T4402 -1.4852438450502513e-07
Gcorr7036 T3750 T4403 T3750 T4403 -3.2201490601575557e-07
Gcorr7037 T3750 T5653 T3750 T5653 -1.51065267989171e-07
Rt20843 T3751 T4901 6015203.8948816685
Rt20844 T3751 T4902 10837138.120684769
Rt20845 T3751 T4903 1696964.0202894164
Gcorr7038 T3751 T5670 T3751 T5670 -4.6050715382953524e-07
Rt20846 T3752 T3819 1739861.7945872105
Rt20847 T3752 T4775 3258180.4053378953
Rt20848 T3752 T4776 20280187.558229458
Gcorr7039 T3752 T4778 T3752 T4778 -4.1822306954628597e-07
Rt20849 T3752 T5509 2175689.8782899184
Rt20850 T3753 T3924 21057666.184923686
Gcorr7040 T3753 T5163 T3753 T5163 -5.8263736887701618e-07
Rt20851 T3753 T5642 414628.15366950544
Rt20852 T3753 T5894 721332.35440323176
Rt20853 T3754 T4062 2352259.3523417157
Rt20854 T3754 T4075 1439082.8306839752
Rt20855 T3754 T4308 2508574.3695635591
Gcorr7041 T3754 T4309 T3754 T4309 -1.2397805553936068e-07
Rt20856 T3754 T4310 2889416.7466149288
Gcorr7042 T3754 T5909 T3754 T5909 -6.9239921223002528e-08
Rt20857 T3755 T4021 1945297.2263463615
Gcorr7043 T3755 T4674 T3755 T4674 -4.2348296400044775e-07
Rt20858 T3755 T4675 2462586.7512918175
Rt20859 T3755 T4676 3000883.4497512477
Rt20860 T3755 T4741 12933901.627707742
Rt20861 T3756 T3877 7396967.3012131816
Gcorr7044 T3756 T4702 T3756 T4702 -1.3034116095233724e-07
Rt20862 T3756 T5178 1735235.5219683202
Rt20863 T3756 T5412 8020455.2075673919
Gcorr7045 T3756 T5609 T3756 T5609 -1.5290813284209859e-07
Rt20864 T3757 T3914 2090058.7795663713
Rt20865 T3757 T4116 3896208.3454276756
Gcorr7046 T3757 T4165 T3757 T4165 -3.3469877767580005e-08
Gcorr7047 T3757 T4632 T3757 T4632 -1.4081288024214824e-07
Rt20866 T3757 T5342 20402388.046821915
Rt20867 T3757 T5504 9488342.6015402991
Rt20868 T3757 T5895 1988064.5214742548
Rt20869 T3758 T3929 3904576.6375156548
Rt20870 T3758 T3980 1768898.9872512121
Rt20871 T3758 T4162 116250358.78898761
Rt20872 T3758 T4872 1666952.9585235866
Gcorr7048 T3758 T4993 T3758 T4993 -2.3085924938064508e-07
Rt20873 T3758 T5066 10022635.286786137
Rt20874 T3758 T5234 13195096.320712244
Rt20875 T3759 T4085 406292.41661853634
Rt20876 T3759 T4934 10764085.228667945
Gcorr7049 T3759 T4935 T3759 T4935 -5.1894067583855497e-07
Rt20877 T3759 T5333 1278008.4693199235
Rt20878 T3760 T3851 1775746.3531771251
Rt20879 T3760 T4943 75243029.2847161
Rt20880 T3760 T4944 9748744.5088417996
Gcorr7050 T3760 T5734 T3760 T5734 -4.5675288180147695e-07
Rt20881 T3760 T5814 1381235.793206376
Rt20882 T3761 T4135 4610791.0024127932
Gcorr7051 T3761 T4225 T3761 T4225 -4.4260573731580942e-07
Rt20883 T3761 T5368 668235.54193443584
Gcorr7052 T3761 T5685 T3761 T5685 -2.9646294049505639e-08
Gcorr7053 T3761 T5959 T3761 T5959 -1.3918703999196401e-07
Rt20884 T3762 T4061 2332792.1528716972
Gcorr7054 T3762 T4667 T3762 T4667 -5.2060785255923759e-08
Rt20885 T3762 T4669 3798150.9131852351
Rt20886 T3762 T5531 8366189.0447788471
Rt20887 T3763 T3982 3332622.3532592491
Gcorr7055 T3763 T5152 T3763 T5152 -3.435228299560501e-07
Gcorr7056 T3763 T5356 T3763 T5356 -1.5666075556689637e-07
Rt20888 T3763 T5701 933084.97746243211
Gcorr7057 T3763 T6009 T3763 T6009 -2.3248500738968437e-07
Rt20889 T3764 T3972 1388833.3262199126
Gcorr7058 T3764 T4248 T3764 T4248 -5.3804721434000073e-08
Rt20890 T3764 T4694 9551611.4272673689
Rt20891 T3764 T5563 3031022.09634603
Rt20892 T3765 T3773 2304323.9924267279
Rt20893 T3765 T4979 5813854.5276117828
Rt20894 T3765 T4980 7292034.3844607584
Rt20895 T3765 T4985 9150684.9020698629
Rt20896 T3766 T3767 3629078.7872042395
Rt20897 T3766 T3768 4851918.9048263999
Rt20898 T3766 T3774 1121022.9137494024
Gcorr7059 T3766 T4810 T3766 T4810 -1.6288212970217526e-07
Rt20899 T3766 T4812 1414750.8360064009
Rt20900 T3766 T5156 3460629.8107848023
Gcorr7060 T3766 T5399 T3766 T5399 -4.7914996707000726e-07
Rt20901 T3767 T3768 1932078.1690967293
Rt20902 T3767 T3769 1794258.2792859182
Rt20903 T3767 T3771 1418513.986784054
Rt20904 T3767 T3919 2410241.369943751
Rt20905 T3767 T4812 12525292.534511385
Rt20906 T3767 T4813 8455781.005920399
Rt20907 T3767 T4814 2408056.447762996
Gcorr7061 T3767 T4925 T3767 T4925 -1.8337271597338862e-07
Rt20908 T3768 T3769 3489919.7440501624
Rt20909 T3768 T3770 854440.18125669658
Rt20910 T3768 T3774 1701789.5161699257
Rt20911 T3768 T4137 2012799.4786274272
Rt20912 T3768 T4811 2424165.7938581002
Rt20913 T3768 T4812 15286477.168245664
Rt20914 T3768 T4813 2977323.6551035391
Gcorr7062 T3768 T5654 T3768 T5654 -4.1062442044762795e-07
Rt20915 T3769 T3770 750280.88632747415
Rt20916 T3769 T3771 2493831.993247624
Rt20917 T3769 T3817 3754115.3533088639
Rt20918 T3769 T4813 2044643.4688421115
Rt20919 T3769 T4925 8709906.5215293635
Rt20920 T3769 T4926 2655295.8885410847
Gcorr7063 T3769 T5654 T3769 T5654 -3.6254383187342691e-07
Rt20921 T3770 T3772 1005941.560961955
Rt20922 T3770 T3819 5980685.9876289843
Rt20923 T3770 T4137 637979.55052843876
Gcorr7064 T3770 T4811 T3770 T4811 -6.895281162281848e-07
Gcorr7065 T3770 T4813 T3770 T4813 -4.5039283677620777e-07
Gcorr7066 T3770 T4838 T3770 T4838 -2.3005158881739173e-08
Gcorr7067 T3770 T4926 T3770 T4926 -1.0707131507295117e-07
Rt20924 T3770 T5654 497699.22863389488
Gcorr7068 T3770 T6060 T3770 T6060 -8.9254937283275185e-08
Rt20925 T3771 T3817 1684580.5060477161
Rt20926 T3771 T3919 2315421.6856524195
Gcorr7069 T3771 T4814 T3771 T4814 -1.4318210171477782e-07
Rt20927 T3771 T4925 1725015.1046148993
Rt20928 T3771 T4927 13260835.329618396
Rt20929 T3771 T5927 9442531.8947074711
Gcorr7070 T3772 T4926 T3772 T4926 -1.9475931242709333e-07
Gcorr7071 T3772 T5177 T3772 T5177 -3.0491372226420667e-07
Rt20930 T3772 T5217 680077.1992697136
Gcorr7072 T3772 T5376 T3772 T5376 -1.0065442246941566e-07
Gcorr7073 T3772 T5654 T3772 T5654 -1.2467397498664386e-07
Rt20931 T3772 T6060 5115092.1907223482
Gcorr7074 T3772 T6068 T3772 T6068 -1.8260169400490888e-07
Rt20932 T3773 T3975 599650.04166625836
Gcorr7075 T3773 T4976 T3773 T4976 -1.2727114147122535e-07
Gcorr7076 T3773 T4978 T3773 T4978 -4.922783901362804e-07
Rt20933 T3773 T4979 1082993.0232579401
Rt20934 T3773 T5530 18493115.962778974
Rt20935 T3774 T4137 1677218.4492721674
Gcorr7077 T3774 T4776 T3774 T4776 -2.6514674476162038e-07
Rt20936 T3774 T4810 1531047.0521611585
Rt20937 T3774 T4811 16793109.794042505
Gcorr7078 T3774 T4812 T3774 T4812 -1.342402243199293e-07
Rt20938 T3775 T4972 2173850.2200428564
Gcorr7079 T3775 T4973 T3775 T4973 -4.3562260093624054e-07
Rt20939 T3775 T4974 1276622.7151276295
Gcorr7080 T3775 T4975 T3775 T4975 -4.2967412398517093e-07
Rt20940 T3776 T3821 163325307.76713556
Rt20941 T3776 T3822 720231.41412715684
Gcorr7081 T3776 T5155 T3776 T5155 -2.0933255058843897e-07
Gcorr7082 T3776 T5251 T3776 T5251 -5.5375956441945194e-07
Rt20942 T3776 T5377 1727886.0524007471
Rt20943 T3776 T5868 217485.47090641403
Gcorr7083 T3776 T6047 T3776 T6047 -4.2505551599009248e-07
Rt20944 T3777 T3886 2655497.0975107253
Gcorr7084 T3777 T4037 T3777 T4037 -6.6403754774081677e-07
Rt20945 T3777 T4080 1059320.7828832243
Rt20946 T3777 T4236 20503127.097778361
Rt20947 T3777 T5625 227793.14577218445
Rt20948 T3777 T5786 3680292.4948617443
Rt20949 T3777 T6000 8524178.2230024319
Gcorr7085 T3778 T3810 T3778 T3810 -2.0624571976880452e-07
Rt20950 T3778 T4231 728676.58379406109
Rt20951 T3778 T4237 401769.14833290275
Gcorr7086 T3778 T4239 T3778 T4239 -1.9244936110703695e-07
Rt20952 T3779 T3831 424865.0011096563
Gcorr7087 T3779 T4462 T3779 T4462 -1.0367928790290818e-07
Rt20953 T3779 T4463 3151321.3515867097
Rt20954 T3779 T4465 905539.18804641371
Gcorr7088 T3779 T5680 T3779 T5680 -4.1216707107091167e-07
Gcorr7089 T3779 T5681 T3779 T5681 -3.5848449499365299e-07
Gcorr7090 T3780 T3936 T3780 T3936 -1.9277039286090374e-08
Rt20955 T3780 T4946 5268990.2055794476
Rt20956 T3780 T5003 4111327.4343282366
Rt20957 T3780 T5004 9628146.0468528755
Rt20958 T3781 T4107 766580.25387817761
Gcorr7091 T3781 T5403 T3781 T5403 -7.3705224701576434e-07
Rt20959 T3781 T5435 430932.05724606762
Rt20960 T3781 T5965 1753092.8820874752
Rt20961 T3781 T6074 372581.80061410525
Rt20962 T3782 T3827 13236656.53749967
Rt20963 T3782 T4089 2499131.9604027714
Gcorr7092 T3782 T5092 T3782 T5092 -6.3730678960523054e-07
Rt20964 T3782 T5094 919215.68201834231
Rt20965 T3782 T5108 13499115.391784748
Gcorr7093 T3782 T5499 T3782 T5499 -8.2374664516781492e-08
Rt20966 T3783 T4041 1249582.1605715684
Gcorr7094 T3783 T4981 T3783 T4981 -6.1293321480057762e-07
Gcorr7095 T3783 T5068 T3783 T5068 -4.7011114359086666e-07
Rt20967 T3783 T5564 1684913.940933093
Rt20968 T3783 T6024 474955.24769331136
Gcorr7096 T3783 T6044 T3783 T6044 -7.7411224333377976e-07
Gcorr7097 T3784 T3886 T3784 T3886 -6.4835535925906253e-08
Rt20969 T3784 T4128 1905349.927100166
Rt20970 T3784 T4232 5056885.4283542521
Gcorr7098 T3784 T5172 T3784 T5172 -6.6236247242839351e-07
Gcorr7099 T3784 T5265 T3784 T5265 -7.0410592715103565e-08
Rt20971 T3784 T5711 1781795.6000547777
Rt20972 T3784 T5913 341068.54944569006
Gcorr7100 T3784 T5971 T3784 T5971 -2.6902229030825356e-07
Rt20973 T3785 T4065 1554953.9558467979
Rt20974 T3785 T5456 1714264.11894146
Gcorr7101 T3785 T5457 T3785 T5457 -4.3184542032779768e-07
Gcorr7102 T3785 T5715 T3785 T5715 -2.0050310641717518e-07
Rt20975 T3785 T5723 2920038.1308772629
Rt20976 T3785 T6022 4846710.4807014093
Rt20977 T3786 T4043 1262580.0595231256
Rt20978 T3786 T4083 2839547.9640502566
Gcorr7103 T3786 T5121 T3786 T5121 -2.2190143771125221e-07
Rt20979 T3786 T5706 1047842.6547811631
Rt20980 T3786 T6051 4480909.3391148066
Gcorr7104 T3787 T4932 T3787 T4932 -1.8822804328833455e-07
Gcorr7105 T3787 T5067 T3787 T5067 -4.524138295828767e-07
Gcorr7106 T3787 T5358 T3787 T5358 -6.3854462322131117e-07
Rt20981 T3787 T5359 870341.66750834906
Rt20982 T3787 T5903 1275929.955568759
Rt20983 T3787 T5935 356987.71379314346
Rt20984 T3788 T3919 1770011.5487848283
Rt20985 T3788 T4010 3402607.7908495921
Rt20986 T3788 T4947 7168776.7282033637
Rt20987 T3788 T5158 9935918.2745693941
Rt20988 T3788 T5399 13494604.196381558
Rt20989 T3789 T4152 47942958.907944851
Rt20990 T3789 T4167 1234026.6117834998
Rt20991 T3789 T5063 3231218.299761266
Gcorr7107 T3789 T5186 T3789 T5186 -1.7150364057223014e-07
Rt20992 T3789 T5248 7803505.1011725934
Rt20993 T3789 T5581 10572781.071538502
Gcorr7108 T3790 T5021 T3790 T5021 -9.0157032027571625e-08
Rt20994 T3790 T5022 687733.80586490605
Gcorr7109 T3790 T5165 T3790 T5165 -3.7605207614943545e-08
Gcorr7110 T3790 T5209 T3790 T5209 -7.1942917905649447e-07
Rt20995 T3791 T4027 1665812.8101806128
Rt20996 T3791 T4038 1585820.9471908368
Rt20997 T3791 T4077 3811658.4180878713
Gcorr7111 T3791 T4917 T3791 T4917 -6.5251888776853156e-08
Gcorr7112 T3791 T5190 T3791 T5190 -9.4431784616942408e-08
Rt20998 T3791 T5678 4164782.5440747696
Rt20999 T3791 T5993 2516520.7827794743
Rt21000 T3792 T4026 317060.7258855211
Gcorr7113 T3792 T4828 T3792 T4828 -8.8913031043407699e-09
Gcorr7114 T3792 T5038 T3792 T5038 -2.0970062986155875e-07
Rt21001 T3792 T5937 629490.01389617531
Gcorr7115 T3792 T6005 T3792 T6005 -9.5744589274827649e-07
Rt21002 T3793 T4197 4598260.3840874657
Gcorr7116 T3793 T4550 T3793 T4550 -1.1079951993170681e-07
Rt21003 T3793 T4743 1315608.9563192239
Rt21004 T3793 T4744 5562986.4976273496
Rt21005 T3793 T4745 8887926.2572002728
Gcorr7117 T3793 T5984 T3793 T5984 -1.5220107004013985e-07
Rt21006 T3794 T3845 1309225.302270164
Rt21007 T3794 T3908 2561509.5468260529
Rt21008 T3794 T3983 396122.85344962729
Rt21009 T3794 T4147 32960694.018636782
Rt21010 T3794 T4197 969141.97822724981
Gcorr7118 T3794 T4533 T3794 T4533 -3.529236644776114e-07
Gcorr7119 T3794 T4534 T3794 T4534 -4.0859184773597079e-07
Rt21011 T3794 T4535 966212.4973433105
Gcorr7120 T3794 T4538 T3794 T4538 -3.7241552451745401e-08
Rt21012 T3794 T5635 3284637.91471519
Rt21013 T3795 T3796 696117.4418032692
Rt21014 T3795 T3974 1062093.6391691628
Rt21015 T3795 T4098 7470071.4533605054
Gcorr7121 T3795 T5408 T3795 T5408 -3.8177837409981516e-07
Rt21016 T3795 T5505 10613248.180328216
Gcorr7122 T3795 T5538 T3795 T5538 -2.3148019418499885e-07
Rt21017 T3795 T6057 1192302.2130019083
Rt21018 T3796 T3974 2339686.1639081277
Gcorr7123 T3796 T5408 T3796 T5408 -7.1910593822100248e-08
Gcorr7124 T3796 T5526 T3796 T5526 -5.2850558631325877e-07
Rt21019 T3796 T5538 1124412.5209398856
Rt21020 T3796 T5869 2609347.3717448707
Gcorr7125 T3796 T6057 T3796 T6057 -3.4116818301416753e-07
Rt21021 T3797 T4002 863207.00849689543
Rt21022 T3797 T4658 1427473.5376975194
Rt21023 T3797 T5424 4259265.0192323355
Gcorr7126 T3797 T5633 T3797 T5633 -2.1946205393736736e-07
Gcorr7127 T3797 T5824 T3797 T5824 -3.902754686096185e-07
Rt21024 T3798 T4037 1313813.1291316773
Gcorr7128 T3798 T4223 T3798 T4223 -9.2356029937566392e-08
Gcorr7129 T3798 T5317 T3798 T5317 -5.254688011045606e-07
Rt21025 T3798 T5798 70196.196707384996
Rt21026 T3798 T5828 3565412.0952442121
Rt21027 T3799 T3810 350595.54855319473
Rt21028 T3799 T3962 30402937.64532965
Rt21029 T3799 T4221 230993.19131171395
Gcorr7130 T3799 T5986 T3799 T5986 -1.5801375613073577e-06
Rt21030 T3799 T6061 2555948.3676091377
Rt21031 T3800 T3802 4163129.4949796051
Rt21032 T3800 T3889 1054271.9841692839
Rt21033 T3800 T4329 12004468.52026022
Rt21034 T3800 T4345 5272589.589660964
Rt21035 T3800 T4346 1426848.1970506446
Gcorr7131 T3800 T4352 T3800 T4352 -4.5535621090710991e-07
Gcorr7132 T3800 T5365 T3800 T5365 -1.4239512649570407e-07
Rt21036 T3801 T4016 2892888.9889988662
Rt21037 T3801 T4139 703014.25682406744
Gcorr7133 T3801 T4326 T3801 T4326 -4.1434625861042555e-07
Rt21038 T3801 T4327 1221088.368617408
Gcorr7134 T3801 T4328 T3801 T4328 -1.0617663695356758e-07
Rt21039 T3801 T4329 6480546.0288568046
Rt21040 T3802 T3889 1643009.979464917
Gcorr7135 T3802 T3953 T3802 T3953 -7.6584616549205341e-08
Rt21041 T3802 T4182 4624859.6477369191
Rt21042 T3802 T4346 13361023.545229351
Rt21043 T3802 T4353 2835901.8832056001
Rt21044 T3802 T4354 4230233.1383345239
Gcorr7136 T3802 T4355 T3802 T4355 -1.4466833419545497e-07
Rt21045 T3803 T3935 613560.30638492736
Gcorr7137 T3803 T5290 T3803 T5290 -7.6980745429299638e-08
Gcorr7138 T3803 T5713 T3803 T5713 -3.7392801078951803e-07
Gcorr7139 T3803 T5719 T3803 T5719 -4.7163587139232635e-07
Rt21046 T3803 T5795 722152.19041833305
Rt21047 T3804 T3843 2062343.2798481162
Rt21048 T3804 T4074 966142.85825422266
Rt21049 T3804 T4300 7269441.093091704
Rt21050 T3804 T4301 993014.34858627466
Rt21051 T3804 T4302 3536839.8803350204
Rt21052 T3805 T3959 6725865.9880735036
Gcorr7140 T3805 T5457 T3805 T5457 -8.5442834252018639e-08
Gcorr7141 T3805 T5516 T3805 T5516 -4.2791507125458824e-07
Gcorr7142 T3805 T5630 T3805 T5630 -1.4058844407868387e-07
Rt21053 T3805 T6008 965309.07845226664
Rt21054 T3806 T4243 2336795.2726053931
Rt21055 T3807 T4053 1115956.8338741476
Rt21056 T3807 T4201 1826483.3515997836
Gcorr7143 T3807 T4226 T3807 T4226 -2.0173745193496669e-07
Rt21057 T3807 T5266 633281.25233372662
Rt21058 T3808 T4185 3828669.9101941204
Rt21059 T3808 T4518 8581396.0235893708
Rt21060 T3808 T4519 14464969.386821987
Rt21061 T3808 T4520 1525585.8211139641
Gcorr7144 T3808 T5467 T3808 T5467 -4.6540147397693315e-07
Gcorr7145 T3809 T3837 T3809 T3837 -5.8699525596988162e-07
Rt21062 T3809 T4031 720811.98248213332
Rt21063 T3809 T5032 1975600.1827301192
Rt21064 T3809 T5446 453943.02624865633
Rt21065 T3809 T5549 476447.98691945669
Rt21066 T3810 T3938 487894.61348669848
Gcorr7146 T3810 T4221 T3810 T4221 -1.5039162354333878e-06
Rt21067 T3810 T4237 512336.90683537466
Rt21068 T3810 T5986 325351.85879906401
Gcorr7147 T3810 T6029 T3810 T6029 -9.0886529635548543e-07
Rt21069 T3811 T5606 6974863.4247516356
Rt21070 T3811 T5637 5180395.4103224576
Rt21071 T3811 T5712 4442978.7705997983
Gcorr7148 T3811 T6040 T3811 T6040 -1.2224053543217275e-07
Rt21072 T3812 T3850 1317159.1855487572
Rt21073 T3812 T4589 3314859.882445191
Rt21074 T3812 T4590 8187107.2839256003
Rt21075 T3812 T4591 6936995.1018067524
Gcorr7149 T3812 T5450 T3812 T5450 -1.6111987889104863e-07
Rt21076 T3813 T4127 1317049.3401707588
Gcorr7150 T3813 T4906 T3813 T4906 -1.0444396425386923e-07
Rt21077 T3813 T5011 2701471.7193410774
Rt21078 T3813 T5012 9762371.3129367176
Gcorr7151 T3813 T5525 T3813 T5525 -2.8898531730319012e-09
Rt21079 T3814 T3816 3547106.928603332
Rt21080 T3814 T4030 3468292.7907951032
Rt21081 T3814 T4192 1284003.54869548
Gcorr7152 T3814 T5173 T3814 T5173 -7.9450708695539398e-08
Rt21082 T3814 T5704 2766468.7309537204
Rt21083 T3815 T4178 2915379.7425087127
Rt21084 T3815 T4691 895181.17491350963
Rt21085 T3815 T4757 14158551.329073288
Gcorr7153 T3815 T5037 T3815 T5037 -8.3703869574617722e-08
Gcorr7154 T3815 T5450 T3815 T5450 -7.8607294291097989e-07
Rt21086 T3816 T4029 3679647.3983342149
Rt21087 T3816 T4192 1486082.289808437
Rt21088 T3816 T5175 5219916.1843345137
Rt21089 T3816 T5684 29726327.975905389
Rt21090 T3816 T5704 17603537.148752026
Rt21091 T3817 T4124 1928016.6708454951
Rt21092 T3817 T4925 19723955.917766776
Gcorr7155 T3817 T4926 T3817 T4926 -9.5815995707856617e-08
Rt21093 T3817 T5119 511789.5176638189
Gcorr7156 T3817 T5177 T3817 T5177 -5.391227443393561e-07
Gcorr7157 T3817 T5859 T3817 T5859 -3.7660415311721131e-07
Gcorr7158 T3817 T5927 T3817 T5927 -1.008573052616672e-07
Rt21094 T3818 T4851 2446024.1480390779
Rt21095 T3818 T5045 8547098.7430888936
Gcorr7159 T3818 T5362 T3818 T5362 -8.370697853836216e-08
Rt21096 T3819 T4137 1059893.4488113523
Rt21097 T3819 T4776 69945136.05232434
Rt21098 T3819 T4838 2062218.0437610832
Rt21099 T3819 T5509 11540038.091592247
Gcorr7160 T3819 T5510 T3819 T5510 -1.4992899027586763e-07
Rt21100 T3820 T3927 1247515.7445486467
Rt21101 T3820 T4331 23241313.523437336
Rt21102 T3820 T4335 3153059.3794706659
Rt21103 T3820 T5255 3230218.1931434921
Gcorr7161 T3820 T5413 T3820 T5413 -3.2653174241888391e-07
Rt21104 T3821 T3939 181663.89113071168
Rt21105 T3821 T4222 202627.91760027278
Rt21106 T3821 T5377 832717.51476603711
Gcorr7162 T3821 T5753 T3821 T5753 -2.6500743299526277e-06
Rt21107 T3822 T4129 927671.6777594476
Rt21108 T3822 T5155 708106.71789379395
Gcorr7163 T3822 T5250 T3822 T5250 -7.7747470453192113e-08
Rt21109 T3822 T5251 1333242.0842628656
Gcorr7164 T3822 T5868 T3822 T5868 -3.797648517754895e-07
Rt21110 T3823 T4052 739727.63163573423
Rt21111 T3823 T5383 1696635.4908414038
Rt21112 T3823 T5819 4565672.8574667936
Rt21113 T3823 T5857 62284941.205442324
Rt21114 T3824 T4077 939292.95739887492
Gcorr7165 T3824 T5256 T3824 T5256 -5.1604331843681746e-07
Gcorr7166 T3824 T5643 T3824 T5643 -7.6078597624920153e-08
Gcorr7167 T3824 T5679 T3824 T5679 -4.5825901106884942e-07
Rt21115 T3824 T5748 428158.17918496236
Gcorr7168 T3824 T6033 T3824 T6033 -1.7329028628885472e-07
Gcorr7169 T3825 T5176 T3825 T5176 -1.5930007008877765e-07
Gcorr7170 T3825 T5348 T3825 T5348 -1.6953708338910362e-07
Rt21116 T3825 T5646 823177.12199798145
Rt21117 T3825 T5675 1793550.3912227908
Gcorr7171 T3825 T5966 T3825 T5966 -2.2917343965069755e-07
Rt21118 T3826 T4036 1105167.6162088409
Rt21119 T3826 T4142 1223132.4259789123
Gcorr7172 T3826 T4364 T3826 T4364 -1.9362965449374184e-07
Rt21120 T3826 T4365 2990955.8640833637
Rt21121 T3826 T4366 3166022.0669953576
Gcorr7173 T3826 T4367 T3826 T4367 -1.2005231057031926e-07
Rt21122 T3827 T4002 2305297.4791447483
Rt21123 T3827 T5108 574908.32167806441
Rt21124 T3827 T5633 1824184.4217657568
Gcorr7174 T3827 T5668 T3827 T5668 -1.1725798710618905e-06
Gcorr7175 T3827 T5736 T3827 T5736 -4.8292621367681937e-08
Gcorr7176 T3827 T5999 T3827 T5999 -6.0580647836136583e-07
Rt21125 T3828 T4059 1899375.762500053
Rt21126 T3828 T4122 6451971.72874426
Rt21127 T3828 T4125 3223633.4898407976
Rt21128 T3828 T5337 2547978.8520357632
Rt21129 T3828 T5338 696686.80900773057
Rt21130 T3828 T5831 2026261.151683782
Gcorr7177 T3828 T5874 T3828 T5874 -4.6007876609190651e-07
Rt21131 T3829 T4032 1570752.4081992402
Rt21132 T3829 T4146 1307004.3202616847
Rt21133 T3829 T4153 7877483.2818515729
Rt21134 T3829 T4836 1601507.2313186224
Gcorr7178 T3829 T5244 T3829 T5244 -8.0656673858726181e-08
Rt21135 T3829 T5844 14460559.605731614
Rt21136 T3829 T5845 1398460.7114779691
Rt21137 T3830 T3934 2073117.8842888013
Rt21138 T3830 T4028 8962433.7036562171
Rt21139 T3830 T4284 97161874.552651539
Rt21140 T3830 T4299 3557764.2959299376
Rt21141 T3830 T5336 457719.47982858511
Gcorr7179 T3830 T5763 T3830 T5763 -2.777969440302379e-07
Gcorr7180 T3830 T5945 T3830 T5945 -2.745910961540519e-08
Gcorr7181 T3831 T4463 T3831 T4463 -7.2195720453564194e-07
Gcorr7182 T3831 T4465 T3831 T4465 -4.9212951158883859e-07
Gcorr7183 T3831 T4684 T3831 T4684 -1.2637524007669295e-07
Rt21142 T3831 T5680 599917.525280184
Rt21143 T3831 T5681 4564851.5987970103
Rt21144 T3831 T5957 8362148.5861780411
Rt21145 T3832 T4585 9558967.7952766959
Rt21146 T3832 T5420 1274156.5857835088
Rt21147 T3832 T5461 8807488.7450937293
Gcorr7184 T3832 T5694 T3832 T5694 -5.0558723881236225e-07
Gcorr7185 T3832 T6023 T3832 T6023 -5.4088196971278828e-08
Rt21148 T3833 T3990 2577396.6339615993
Gcorr7186 T3833 T4996 T3833 T4996 -7.1019508151784597e-08
Rt21149 T3833 T4998 610190.85484941117
Gcorr7187 T3833 T5316 T3833 T5316 -4.3258378550881316e-07
Gcorr7188 T3833 T5774 T3833 T5774 -9.838032691231689e-08
Rt21150 T3834 T3885 636722.074589025
Gcorr7189 T3834 T4474 T3834 T4474 -4.6393809845430983e-08
Rt21151 T3834 T4841 3136907.2090656464
Rt21152 T3834 T5264 1914499.5397643626
Gcorr7190 T3834 T6085 T3834 T6085 -3.7666606693032781e-07
Gcorr7191 T3835 T4101 T3835 T4101 -1.8539676083573249e-08
Rt21153 T3835 T4363 1889997.693968938
Gcorr7192 T3835 T4387 T3835 T4387 -1.1578234772229968e-07
Rt21154 T3835 T5302 17087096.27626919
Rt21155 T3836 T3869 1253572.489883245
Rt21156 T3836 T3887 8217289.8812288931
Gcorr7193 T3836 T4551 T3836 T4551 -2.0879028106511996e-07
Rt21157 T3836 T5230 18484483.957628172
Rt21158 T3836 T5709 7912103.576375315
Rt21159 T3836 T5768 2415387.9363378319
Gcorr7194 T3837 T3979 T3837 T3979 -6.2873566267094061e-07
Rt21160 T3837 T4921 2552487.0016109035
Rt21161 T3837 T5112 2432286.8185540289
Rt21162 T3837 T5162 5896932.4771368438
Rt21163 T3837 T5549 1078960.7118962074
Rt21164 T3837 T5803 7102177.163325252
Rt21165 T3837 T6007 371870.30164360051
Gcorr7195 T3838 T4889 T3838 T4889 -8.9318484741184271e-08
Rt21166 T3838 T4891 1409855.7176441725
Rt21167 T3838 T5142 3732701.3283069213
Gcorr7196 T3838 T5273 T3838 T5273 -5.0032606572063033e-07
Rt21168 T3839 T5016 10984821.106343608
Rt21169 T3839 T5017 1196598.5636896193
Rt21170 T3839 T5400 4763069.7227595299
Gcorr7197 T3839 T5401 T3839 T5401 -5.0114623042243377e-08
Rt21171 T3840 T4755 1762280.1240000345
Gcorr7198 T3840 T4756 T3840 T4756 -3.4822719533909135e-07
Rt21172 T3840 T5031 1622357.0362167549
Rt21173 T3840 T5979 1309528.0199852383
Gcorr7199 T3841 T4825 T3841 T4825 -1.0735631745757965e-07
Rt21174 T3841 T5009 1614464.9132490263
Rt21175 T3841 T5304 5852940.5921814172
Rt21176 T3841 T5578 7161657.0157437883
Gcorr7200 T3841 T6048 T3841 T6048 -1.0318219245787636e-07
Rt21177 T3842 T3890 1060867.325998303
Rt21178 T3842 T5361 3194666.5609360016
Gcorr7201 T3842 T5760 T3842 T5760 -3.36863294374645e-07
Gcorr7202 T3842 T5920 T3842 T5920 -1.2124906990841167e-07
Rt21179 T3842 T5948 1900531.7709720898
Rt21180 T3843 T4047 888502.05744889576
Rt21181 T3843 T4302 840163.50260298373
Gcorr7203 T3843 T5306 T3843 T5306 -2.0027783837078437e-07
Rt21182 T3844 T3942 1271770.2269475381
Rt21183 T3844 T3962 1029613.3048835216
Gcorr7204 T3844 T5020 T3844 T5020 -1.0739973012335308e-09
Rt21184 T3844 T5341 1434618.2103619589
Rt21185 T3844 T5754 2325081.5128618805
Gcorr7205 T3845 T3983 T3845 T3983 -4.4765331219389329e-08
Rt21186 T3845 T4533 2225961.7491414039
Gcorr7206 T3845 T4535 T3845 T4535 -4.6883554592573935e-08
Rt21187 T3845 T4536 7350133.4515680969
Gcorr7207 T3845 T5522 T3845 T5522 -1.5088745785598914e-07
Rt21188 T3846 T4126 1025827.1931290065
Gcorr7208 T3846 T4136 T3846 T4136 -6.64599148569763e-08
Gcorr7209 T3846 T4210 T3846 T4210 -8.746432304477347e-07
Rt21189 T3846 T5206 89099815.237160906
Rt21190 T3846 T5245 1980595.6368891704
Gcorr7210 T3846 T5772 T3846 T5772 -7.7048253981828239e-09
Rt21191 T3846 T5996 619416.2998234164
Gcorr7211 T3847 T4391 T3847 T4391 -2.397041544526868e-07
Gcorr7212 T3847 T5164 T3847 T5164 -6.1641652631365107e-07
Rt21192 T3847 T5425 558917.42551216099
Gcorr7213 T3847 T5597 T3847 T5597 -8.8632810625878345e-08
Rt21193 T3847 T5705 49885367.354033515
Rt21194 T3848 T3943 2621317.3038634043
Gcorr7214 T3848 T4584 T3848 T4584 -1.3715170385066557e-07
Rt21195 T3848 T4612 2607598.8958513979
Gcorr7215 T3848 T4697 T3848 T4697 -1.8756352168932569e-07
Rt21196 T3848 T6004 2960302.3622760703
Gcorr7216 T3849 T5078 T3849 T5078 -1.3182362836691308e-07
Rt21197 T3849 T5080 2526960.1705853958
Rt21198 T3849 T5081 3588741.5354243368
Gcorr7217 T3849 T5082 T3849 T5082 -1.423095566730669e-07
Rt21199 T3850 T4178 1040816.8606005141
Gcorr7218 T3850 T4590 T3850 T4590 -1.3139098839758458e-07
Rt21200 T3850 T4591 3206690.8363854066
Rt21201 T3850 T4629 6143932.4757364411
Gcorr7219 T3850 T4631 T3850 T4631 -1.8994003633455924e-08
Rt21202 T3851 T4110 1071838.9037140664
Rt21203 T3851 T4835 7648987.6148628248
Rt21204 T3851 T4943 15531884.484333731
Rt21205 T3851 T4944 4548190.4338622699
Gcorr7220 T3851 T4945 T3851 T4945 -9.2522901625707049e-08
Rt21206 T3852 T4180 1121678.3522639661
Rt21207 T3852 T4598 3268667.8308963818
Gcorr7221 T3852 T4883 T3852 T4883 -1.2995864203042879e-07
Rt21208 T3852 T5252 2782381.2752713943
Gcorr7222 T3852 T5787 T3852 T5787 -9.3822873636055776e-08
Rt21209 T3853 T4091 7274943.6586892195
Rt21210 T3853 T5477 2972921.332097257
Gcorr7223 T3853 T5478 T3853 T5478 -1.1410593011399645e-07
Gcorr7224 T3853 T5485 T3853 T5485 -1.0551821102055797e-07
Rt21211 T3853 T5858 3587265.0448963041
Rt21212 T3854 T4145 4197085.9781531719
Gcorr7225 T3854 T4541 T3854 T4541 -1.2711210326063086e-07
Rt21213 T3854 T4542 1941451.4435383445
Rt21214 T3854 T4543 7909147.4408741184
Gcorr7226 T3854 T4544 T3854 T4544 -1.6928379025437607e-07
Rt21215 T3855 T4166 1174975.5694710661
Rt21216 T3855 T5136 1026214.3592066276
Gcorr7227 T3855 T5214 T3855 T5214 -3.251242991190361e-07
Rt21217 T3855 T5799 510885.77305907453
Gcorr7228 T3855 T5816 T3855 T5816 -2.6554733716975601e-07
Gcorr7229 T3855 T5827 T3855 T5827 -1.1870854238312908e-07
Rt21218 T3856 T4196 847863.28190871887
Rt21219 T3856 T4961 1263282.996059193
Gcorr7230 T3856 T4962 T3856 T4962 -2.6133444060748176e-08
Rt21220 T3856 T5134 10555259.334584504
Rt21221 T3856 T5335 1984857.1085880168
Rt21222 T3856 T5899 1524842.9693993409
Rt21223 T3857 T4173 6056854.7298580091
Gcorr7231 T3857 T5127 T3857 T5127 -1.0944502083416705e-07
Rt21224 T3857 T5179 1462831.2327631242
Gcorr7232 T3857 T5888 T3857 T5888 -2.2114834563500723e-07
Rt21225 T3858 T4149 3041768.7277124901
Gcorr7233 T3858 T4496 T3858 T4496 -1.2119930065004993e-07
Rt21226 T3858 T4497 5152976.8017099053
Rt21227 T3858 T4499 2466034.736161245
Gcorr7234 T3858 T4601 T3858 T4601 -1.8716705359318766e-07
Rt21228 T3859 T4086 1455968.32749211
Rt21229 T3859 T5229 7537989.7220522501
Gcorr7235 T3859 T5372 T3859 T5372 -3.7165845485500529e-08
Gcorr7236 T3859 T5950 T3859 T5950 -4.2813207935017963e-08
Rt21230 T3859 T6042 3089101.2311439142
Rt21231 T3860 T4131 2273906.2938169586
Rt21232 T3860 T4778 33593711.82862433
Rt21233 T3860 T4779 1461962.3317333942
Rt21234 T3860 T4780 3614410.8589618499
Gcorr7237 T3860 T4781 T3860 T4781 -6.5631451438101416e-07
Rt21235 T3861 T4051 1238794.7675485678
Rt21236 T3861 T4425 7912879.8747762786
Gcorr7238 T3861 T5355 T3861 T5355 -6.7314789147026622e-08
Rt21237 T3861 T5494 12499808.308195138
Rt21238 T3861 T6073 3360899.0114867766
Gcorr7239 T3862 T4186 T3862 T4186 -5.8910871794449591e-08
Rt21239 T3862 T4212 1534671.1772838675
Rt21240 T3862 T5263 450076.64528263797
Gcorr7240 T3862 T5879 T3862 T5879 -5.4454073594491642e-08
Rt21241 T3863 T4096 586488.24834560312
Rt21242 T3863 T4240 531700.87088880595
Gcorr7241 T3863 T4241 T3863 T4241 -1.1394433297689172e-07
Gcorr7242 T3863 T4242 T3863 T4242 -1.1416689246125931e-07
Rt21243 T3864 T3917 2148635.6904255552
Gcorr7243 T3864 T5226 T3864 T5226 -2.0257928501862631e-07
Rt21244 T3864 T5307 3907759.067285317
Rt21245 T3864 T5898 2521380.2441603723
Gcorr7244 T3864 T5964 T3864 T5964 -3.6294920168527405e-08
Rt21246 T3865 T4034 1210862.9842152218
Rt21247 T3865 T4547 8807395.4647998791
Gcorr7245 T3865 T4551 T3865 T4551 -1.5649292838035305e-07
Rt21248 T3865 T5540 2673491.9710663962
Rt21249 T3866 T4033 4179121.707229407
Rt21250 T3866 T4043 1298966.3793838541
Rt21251 T3866 T4214 4379850.4715121882
Rt21252 T3866 T5271 662976.75016727601
Rt21253 T3866 T5272 8113319.9559161747
Gcorr7246 T3866 T5861 T3866 T5861 -1.9458706212478509e-07
Rt21254 T3867 T3912 516291.72494584962
Rt21255 T3867 T4230 388482.29474096303
Gcorr7247 T3867 T5280 T3867 T5280 -5.4795092807521595e-07
Gcorr7248 T3867 T5292 T3867 T5292 -8.0760763029012419e-07
Rt21256 T3868 T4174 9602016.577750098
Rt21257 T3868 T4398 2484600.1652191225
Gcorr7249 T3868 T4400 T3868 T4400 -1.104437050453819e-07
Rt21258 T3868 T5653 4864794.7577791447
Rt21259 T3869 T4551 10618879.226231374
Gcorr7250 T3869 T4552 T3869 T4552 -1.4072379975017809e-07
Rt21260 T3869 T5709 3733448.136592776
Gcorr7251 T3870 T4459 T3870 T4459 -8.4703556955756805e-08
Rt21261 T3870 T5327 1023708.5157000511
Gcorr7252 T3870 T5384 T3870 T5384 -1.9159757504069426e-07
Gcorr7253 T3870 T5385 T3870 T5385 -3.6296067603445712e-07
Rt21262 T3871 T3966 51790464.477708258
Rt21263 T3871 T4714 3079648.6920241551
Rt21264 T3871 T4858 175290037.52772304
Rt21265 T3871 T5294 2546839.8508483456
Gcorr7254 T3871 T5378 T3871 T5378 -7.981709431993913e-08
Gcorr7255 T3872 T4649 T3872 T4649 -2.3866401611086841e-07
Gcorr7256 T3872 T4650 T3872 T4650 -1.1502148406616143e-07
Rt21266 T3872 T4651 753835.61404502625
Gcorr7257 T3872 T4725 T3872 T4725 -4.7841591600377012e-07
Gcorr7258 T3872 T4726 T3872 T4726 -9.0044045006950038e-08
Gcorr7259 T3873 T4510 T3873 T4510 -9.9829842352444557e-08
Rt21267 T3873 T4512 3169368.4947971506
Rt21268 T3873 T4513 5777026.1731257001
Gcorr7260 T3873 T4514 T3873 T4514 -1.1673994015110843e-07
Rt21269 T3874 T4071 508472.96774599218
Rt21270 T3874 T4841 20250500.743452162
Gcorr7261 T3874 T5247 T3874 T5247 -2.1570586616870923e-08
Rt21271 T3874 T5270 1374460.8009609366
Gcorr7262 T3874 T5918 T3874 T5918 -4.492660137257519e-07
Rt21272 T3875 T3932 3128448.085759318
Rt21273 T3875 T4148 1835802.5676094901
Gcorr7263 T3875 T4478 T3875 T4478 -1.323963057807814e-07
Rt21274 T3875 T4482 7352109.1161691491
Gcorr7264 T3875 T5247 T3875 T5247 -4.834520660852656e-07
Rt21275 T3875 T5983 1151325.9226251068
Gcorr7265 T3876 T4382 T3876 T4382 -6.3912253875903498e-08
Rt21276 T3876 T4385 6288287.6429530429
Rt21277 T3876 T5438 4635076.5089991083
Rt21278 T3877 T3929 1101799.4572440148
Gcorr7266 T3877 T4154 T3877 T4154 -9.3554308961290423e-08
Rt21279 T3877 T4704 4796499.4879386071
Rt21280 T3877 T4732 16974073.848863784
Rt21281 T3877 T5178 29097804.393769689
Rt21282 T3877 T5997 4265918.1438453896
Rt21283 T3878 T3879 5404900.6739073014
Rt21284 T3878 T4111 1682494.8311273097
Gcorr7267 T3878 T4319 T3878 T4319 -1.6721902642570301e-07
Rt21285 T3878 T5297 2982281.765429731
Rt21286 T3878 T5871 9089666.4505687505
Rt21287 T3879 T3904 1793845.6630045206
Rt21288 T3879 T4111 1110327.8511215497
Rt21289 T3879 T4157 918667.07327293605
Gcorr7268 T3879 T4312 T3879 T4312 -1.0176322727795344e-07
Rt21290 T3879 T4316 4371371.6352046439
Rt21291 T3879 T5297 4361117.4951335043
Gcorr7269 T3880 T5202 T3880 T5202 -3.8046572046073966e-08
Rt21292 T3880 T5203 10305381.485734712
Rt21293 T3880 T5649 6108195.1311697727
Rt21294 T3881 T3968 579367.68893699849
Gcorr7270 T3881 T4087 T3881 T4087 -1.3763709566953916e-07
Rt21295 T3881 T5315 261962.291139893
Gcorr7271 T3881 T5860 T3881 T5860 -7.6167921781266484e-07
Rt21296 T3882 T5181 2115999.38200197
Rt21297 T3882 T5821 3838978.8533046427
Rt21298 T3882 T5822 18119979.098264631
Rt21299 T3883 T3884 874610.91821228957
Gcorr7272 T3883 T4386 T3883 T4386 -1.4756789583479505e-07
Rt21300 T3883 T4389 2808773.9171719439
Rt21301 T3883 T4391 1375818.4083514072
Gcorr7273 T3883 T4392 T3883 T4392 -4.3948539800138835e-07
Rt21302 T3884 T4384 2909173.272429199
Gcorr7274 T3884 T4385 T3884 T4385 -4.3943972081807126e-07
Rt21303 T3884 T4386 1229135.4367252311
Gcorr7275 T3884 T4391 T3884 T4391 -1.6325096054556084e-07
Gcorr7276 T3884 T5705 T3884 T5705 -1.2941924545162184e-07
Gcorr7277 T3885 T4841 T3885 T4841 -1.9528856133144565e-07
Gcorr7278 T3885 T5264 T3885 T5264 -2.9686742485877712e-07
Gcorr7279 T3885 T5593 T3885 T5593 -2.2630057956285318e-08
Rt21304 T3885 T6085 1366245.3308262653
Gcorr7280 T3886 T4037 T3886 T4037 -4.1242370168076553e-07
Rt21305 T3886 T4128 3083303.8796595456
Gcorr7281 T3886 T5065 T3886 T5065 -1.223211990208723e-06
Rt21306 T3886 T5625 6957994.5644296668
Rt21307 T3886 T5711 304915.37554216839
Rt21308 T3886 T5786 1025636.7091987799
Rt21309 T3887 T4091 1052074.0814487399
Rt21310 T3887 T5230 2549041.0840493958
Gcorr7282 T3887 T5231 T3887 T5231 -1.5570921812291137e-07
Rt21311 T3887 T5784 6134974.149164794
Rt21312 T3888 T4011 1142199.5741795388
Rt21313 T3888 T4216 563239.66120376869
Rt21314 T3889 T4182 1098653.4238252991
Gcorr7283 T3889 T4346 T3889 T4346 -8.3506196950711742e-08
Rt21315 T3889 T4354 8387992.8529921528
Gcorr7284 T3889 T5169 T3889 T5169 -1.4555397850131548e-07
Rt21316 T3889 T5365 1993318.2490121587
Gcorr7285 T3890 T5255 T3890 T5255 -1.7935546201083825e-07
Gcorr7286 T3890 T5361 T3890 T5361 -3.8734143325870142e-07
Rt21317 T3890 T5760 734498.71687480621
Gcorr7287 T3890 T5920 T3890 T5920 -9.8947296545358888e-08
Gcorr7288 T3890 T6017 T3890 T6017 -3.3550371058081019e-07
Rt21318 T3891 T4109 2016231.7183343251
Gcorr7289 T3891 T4320 T3891 T4320 -3.0055460506199581e-06
Rt21319 T3891 T4322 302083.15227356961
Rt21320 T3891 T4342 10807691.107304197
Gcorr7290 T3891 T5382 T3891 T5382 -1.1072027464310631e-07
Rt21321 T3892 T3937 1596199.638209712
Gcorr7291 T3892 T4652 T3892 T4652 -4.3574630581642926e-08
Gcorr7292 T3892 T5305 T3892 T5305 -3.0547015428268014e-08
Rt21322 T3892 T5419 2956228.4112909818
Gcorr7293 T3892 T6018 T3892 T6018 -3.0700204793881612e-08
Rt21323 T3892 T6049 4253562.8796341075
Rt21324 T3893 T3999 2581132.1496989909
Rt21325 T3893 T4454 4019952.8472974007
Rt21326 T3893 T4456 11306596.20797612
Gcorr7294 T3893 T4613 T3893 T4613 -2.6303503085899162e-08
Rt21327 T3894 T3934 3137084.1323831961
Rt21328 T3894 T5025 4207385.4570489759
Gcorr7295 T3894 T5796 T3894 T5796 -2.0873584449523726e-07
Rt21329 T3894 T5923 1461473.2290299926
Gcorr7296 T3894 T5945 T3894 T5945 -8.1426725063707505e-08
Rt21330 T3894 T6006 833484.84349432471
Rt21331 T3895 T4095 1951441.0623623247
Rt21332 T3895 T4799 6690122.7912675245
Rt21333 T3895 T4800 10079828.465002056
Rt21334 T3895 T4801 2367496.5702249361
Gcorr7297 T3895 T4802 T3895 T4802 -1.1990902966571222e-07
Gcorr7298 T3895 T5980 T3895 T5980 -1.0961801583325591e-07
Rt21335 T3896 T4937 7963840.3068473674
Rt21336 T3896 T4953 1670698.7036395047
Rt21337 T3896 T5014 13422922.577338099
Gcorr7299 T3897 T4112 T3897 T4112 -4.3452250791861162e-07
Gcorr7300 T3897 T4235 T3897 T4235 -5.3232194574595858e-07
Rt21338 T3897 T5292 595613.89318265882
Rt21339 T3897 T5843 2114853.1665778528
Rt21340 T3897 T5887 242922.02195351158
Rt21341 T3898 T4054 1455390.3666662425
Rt21342 T3898 T4373 860687.41811988014
Gcorr7301 T3898 T4375 T3898 T4375 -1.3645276220760478e-07
Gcorr7302 T3898 T5502 T3898 T5502 -1.297133933207841e-07
Gcorr7303 T3898 T5611 T3898 T5611 -5.2887652733210712e-07
Gcorr7304 T3899 T4024 T3899 T4024 -6.563290169444302e-08
Rt21343 T3899 T4261 2259526.1432258748
Gcorr7305 T3899 T4262 T3899 T4262 -1.3038088931016174e-07
Rt21344 T3899 T4263 14384649.597018205
Gcorr7306 T3899 T5489 T3899 T5489 -1.2262333414509226e-07
Rt21345 T3899 T5661 4174660.2221929119
Rt21346 T3900 T4074 709738.95750114857
Rt21347 T3900 T4293 1496825.8790341851
Rt21348 T3900 T4296 1099173.4891266753
Rt21349 T3900 T4297 675037.36626459425
Rt21350 T3901 T4127 1946504.7777836525
Rt21351 T3901 T4169 25685513.797718506
Rt21352 T3901 T5215 5187054.9479656303
Gcorr7307 T3901 T5688 T3901 T5688 -4.0471232267397634e-08
Rt21353 T3901 T6014 4005624.7772660269
Rt21354 T3902 T3972 2654050.4421696831
Rt21355 T3902 T5123 1876229.1467937725
Gcorr7308 T3902 T5520 T3902 T5520 -1.3227683829576374e-07
Gcorr7309 T3902 T5621 T3902 T5621 -9.1652929367144049e-08
Rt21356 T3902 T5970 7479547.2598275458
Rt21357 T3903 T4021 1922616.2428097227
Gcorr7310 T3903 T4741 T3903 T4741 -2.3184346200496224e-07
Rt21358 T3903 T4742 18447120.681024034
Rt21359 T3903 T5588 831613.42182396795
Gcorr7311 T3903 T5589 T3903 T5589 -7.1902267039498675e-08
Gcorr7312 T3903 T5677 T3903 T5677 -5.2012362007152963e-07
Rt21360 T3904 T4062 1305015.5911969119
Rt21361 T3904 T4157 4206492.0824593445
Rt21362 T3904 T4179 2568369.4518740475
Rt21363 T3904 T4312 14935131.390507504
Rt21364 T3904 T4315 2334564.9523801832
Gcorr7313 T3904 T4316 T3904 T4316 -8.0008497712088847e-08
Rt21365 T3905 T5198 1097630.9003420798
Gcorr7314 T3905 T5199 T3905 T5199 -4.1987683924074942e-07
Rt21366 T3905 T5426 18127194.622193784
Rt21367 T3905 T5852 1275925.5856655776
Gcorr7315 T3906 T5134 T3906 T5134 -5.9451795304921696e-08
Rt21368 T3906 T5703 424085.59818348876
Rt21369 T3906 T5902 4130853.2719764854
Rt21370 T3907 T4313 625740.07180540101
Gcorr7316 T3907 T4314 T3907 T4314 -4.9875164264393246e-07
Gcorr7317 T3907 T4336 T3907 T4336 -1.1218014486970588e-07
Gcorr7318 T3907 T4729 T3907 T4729 -1.7416405074206171e-07
Gcorr7319 T3907 T5943 T3907 T5943 -4.313915327506677e-07
Rt21371 T3908 T4158 952870.03425179294
Gcorr7320 T3908 T4535 T3908 T4535 -1.1917295859042815e-07
Rt21372 T3908 T4537 2885947.8320641206
Rt21373 T3908 T4538 7127398.0419629067
Rt21374 T3908 T4539 14441084.064783515
Gcorr7321 T3909 T4392 T3909 T4392 -7.8439072616196592e-08
Rt21375 T3909 T4393 1568290.9077238124
Gcorr7322 T3909 T4394 T3909 T4394 -2.7580020671752079e-07
Gcorr7323 T3910 T5086 T3910 T5086 -8.2404847768527893e-07
Rt21376 T3910 T5088 962109.55142891186
Rt21377 T3910 T5090 137364714.9581728
Rt21378 T3910 T5098 8794845.2013975214
Rt21379 T3910 T5647 6405825.5757629611
Rt21380 T3911 T4157 5480376.8534127083
Gcorr7324 T3911 T4311 T3911 T4311 -8.9199013236879591e-08
Gcorr7325 T3911 T4314 T3911 T4314 -1.3149784931468445e-07
Rt21381 T3911 T5423 1831055.7791654491
Rt21382 T3912 T4044 1411977.776098741
Rt21383 T3912 T4230 1810862.3160172529
Rt21384 T3912 T5280 1328322.5742873584
Rt21385 T3912 T5281 4279119.3347888822
Rt21386 T3912 T6086 2607701.2811479755
Rt21387 T3913 T4357 6969365.6076367721
Gcorr7326 T3913 T4359 T3913 T4359 -9.8606189464258812e-08
Rt21388 T3913 T4620 2934508.7831101208
Gcorr7327 T3913 T5622 T3913 T5622 -8.2998694861299566e-08
Rt21389 T3914 T4706 5089623.7377238469
Gcorr7328 T3914 T4763 T3914 T4763 -1.2028758073446519e-07
Rt21390 T3914 T4764 6065544.0327796536
Rt21391 T3914 T5895 7737891.7731503788
Rt21392 T3915 T4044 5217071.4303639736
Gcorr7329 T3915 T5281 T3915 T5281 -3.4492552730512989e-07
Rt21393 T3915 T5285 902115.73476952477
Rt21394 T3915 T5729 5415601.6893590009
Gcorr7330 T3916 T4260 T3916 T4260 -8.608475333535343e-08
Rt21395 T3916 T4262 2383256.8850174122
Gcorr7331 T3916 T4273 T3916 T4273 -4.3538136197968862e-07
Rt21396 T3916 T5458 2251589.5507648643
Gcorr7332 T3917 T4930 T3917 T4930 -1.2887212568970483e-07
Rt21397 T3917 T5226 1847853.6701454723
Rt21398 T3917 T5228 10613145.080743818
Gcorr7333 T3917 T5898 T3917 T5898 -1.1456244418349598e-07
Rt21399 T3918 T4713 12445534.462063013
Rt21400 T3918 T5109 38878696.758645736
Rt21401 T3918 T5346 4972224.5194167504
Rt21402 T3918 T5991 14129493.934872294
Rt21403 T3919 T4010 1487368.8117442611
Rt21404 T3919 T4814 2689231.6184048904
Rt21405 T3919 T4927 29753242.433293261
Rt21406 T3919 T4947 7570282.292581643
Gcorr7334 T3919 T5399 T3919 T5399 -1.4722679690825053e-07
Rt21407 T3920 T4011 1451117.6755166594
Rt21408 T3920 T4087 1219301.9835278061
Rt21409 T3920 T4228 8147019.2127538901
Rt21410 T3920 T5296 605027.1523633895
Rt21411 T3921 T4068 3381601.3261745716
Gcorr7335 T3921 T4136 T3921 T4136 -1.1443997761434543e-07
Gcorr7336 T3921 T4864 T3921 T4864 -1.1262496442297016e-07
Rt21412 T3921 T5042 1133963.6293137481
Rt21413 T3921 T5043 2671932.5189702264
Gcorr7337 T3921 T5761 T3921 T5761 -1.5486173697435695e-07
Rt21414 T3922 T3977 1410382.7517283242
Gcorr7338 T3922 T4785 T3922 T4785 -2.1552142658221402e-07
Rt21415 T3922 T5064 1615633.0528438522
Gcorr7339 T3922 T5807 T3922 T5807 -1.1140353097808486e-07
Gcorr7340 T3922 T5977 T3922 T5977 -1.8253656911014921e-07
Rt21416 T3922 T6030 803916.83910462272
Rt21417 T3923 T4016 3048839.1912032873
Rt21418 T3923 T4324 2305920.8253183858
Rt21419 T3923 T4326 22704901.17539775
Gcorr7341 T3923 T5382 T3923 T5382 -2.0080390150690122e-07
Rt21420 T3923 T5422 10735032.251304502
Rt21421 T3924 T3944 1529998.5514447687
Rt21422 T3924 T4218 688631.93698216358
Rt21423 T3924 T5642 1261113.3000966569
Gcorr7342 T3925 T4031 T3925 T4031 -2.2924588058472334e-07
Gcorr7343 T3925 T4816 T3925 T4816 -3.6884291422870387e-07
Rt21424 T3925 T5659 1728849.3185902804
Rt21425 T3925 T5660 604001.97990995226
Rt21426 T3926 T4219 1106284.8023985978
Rt21427 T3926 T5321 14397011.879537154
Gcorr7344 T3926 T5329 T3926 T5329 -4.7973458359907869e-07
Rt21428 T3926 T5330 824008.68679004908
Rt21429 T3927 T4047 1816596.8278390807
Rt21430 T3927 T4305 2898852.4710735204
Gcorr7345 T3927 T4306 T3927 T4306 -1.4845388992699416e-07
Rt21431 T3927 T4331 2616489.3104535961
Gcorr7346 T3927 T5255 T3927 T5255 -1.0911912865851802e-07
Gcorr7347 T3928 T4450 T3928 T4450 -4.1965434916479902e-07
Gcorr7348 T3928 T5216 T3928 T5216 -1.1158332549582426e-07
Gcorr7349 T3928 T5300 T3928 T5300 -1.4934238916910278e-06
Gcorr7350 T3928 T5396 T3928 T5396 -3.1138504329209132e-07
Rt21432 T3928 T5889 326937.5053997261
Gcorr7351 T3928 T5981 T3928 T5981 -3.6145355779571766e-07
Gcorr7352 T3929 T4732 T3929 T4732 -1.584346150632311e-07
Rt21433 T3929 T5234 2177701.8535961113
Rt21434 T3929 T5997 42701457.425308004
Rt21435 T3930 T3990 1394948.2240536199
Rt21436 T3930 T4997 3596050.8449662179
Rt21437 T3930 T4999 2071357.9963341502
Gcorr7353 T3930 T5731 T3930 T5731 -2.220794043762438e-09
Rt21438 T3930 T5832 1973696.3213031609
Rt21439 T3931 T3977 2410761.7612235984
Rt21440 T3931 T4094 379663.98420720757
Gcorr7354 T3931 T4618 T3931 T4618 -9.2648206154440404e-07
Rt21441 T3931 T4785 5150329.4016436106
Gcorr7355 T3931 T5260 T3931 T5260 -3.4660188768607044e-07
Rt21442 T3931 T5710 701609.25111913867
Rt21443 T3931 T5807 1868286.5337720746
Rt21444 T3932 T4148 3809879.0564959184
Rt21445 T3932 T4482 8949182.6311021317
Gcorr7356 T3932 T4484 T3932 T4484 -5.903158909498462e-08
Rt21446 T3932 T4832 3233968.161480533
Gcorr7357 T3932 T5983 T3932 T5983 -1.0194958923311621e-07
Rt21447 T3933 T3934 1992183.1183021774
Rt21448 T3933 T4060 1599432.8042723362
Rt21449 T3933 T5029 2502491.9800118394
Gcorr7358 T3933 T5763 T3933 T5763 -8.5364766030577673e-08
Gcorr7359 T3933 T5914 T3933 T5914 -9.6166971940878749e-08
Rt21450 T3933 T6084 1559873.1914813805
Gcorr7360 T3934 T5029 T3934 T5029 -1.3579133177923668e-07
Rt21451 T3934 T5763 4555113.4794760551
Gcorr7361 T3934 T5923 T3934 T5923 -5.1626943818296338e-07
Rt21452 T3934 T5945 499997.44747627352
Rt21453 T3935 T3956 1228509.0860053068
Rt21454 T3935 T4013 2888568.0756110973
Gcorr7362 T3935 T5290 T3935 T5290 -1.1641554782490588e-07
Rt21455 T3935 T5318 2636318.620938608
Rt21456 T3935 T5719 2944742.3641834874
Gcorr7363 T3935 T5795 T3935 T5795 -2.7249748968441356e-07
Rt21457 T3936 T5004 4050997.5672178236
Gcorr7364 T3936 T5182 T3936 T5182 -8.148285475807248e-08
Gcorr7365 T3936 T5312 T3936 T5312 -1.1501321969396496e-07
Rt21458 T3936 T5495 3316953.8107253034
Gcorr7366 T3937 T5059 T3937 T5059 -6.0593403560067513e-08
Gcorr7367 T3937 T5419 T3937 T5419 -2.7117456157260912e-08
Rt21459 T3937 T5578 6883124.1447005523
Rt21460 T3937 T6018 3336107.2324792519
Gcorr7368 T3938 T4237 T3938 T4237 -1.0426991485024429e-06
Rt21461 T3938 T4238 1225441.7560179124
Gcorr7369 T3938 T5623 T3938 T5623 -4.9011057277082835e-07
Rt21462 T3938 T5986 11486870.92011912
Rt21463 T3938 T6029 540737.93481874617
Gcorr7370 T3939 T4222 T3939 T4222 -2.7038777538265434e-06
Rt21464 T3939 T5153 4082303.4042485775
Gcorr7371 T3939 T5154 T3939 T5154 -1.3948023810500299e-07
Rt21465 T3939 T5377 15309673.490113545
Rt21466 T3939 T5753 266315.89567686472
Rt21467 T3940 T4023 2202036.8855205411
Rt21468 T3940 T4483 3232183.0320567624
Gcorr7372 T3940 T4484 T3940 T4484 -1.3681514557320098e-07
Rt21469 T3940 T4485 2952426.6431578766
Gcorr7373 T3940 T5559 T3940 T5559 -1.6447077554371704e-07
Rt21470 T3941 T4134 636865.12560721627
Rt21471 T3941 T5015 732858.89365680283
Gcorr7374 T3941 T5016 T3941 T5016 -3.9980988309082552e-07
Gcorr7375 T3941 T5430 T3941 T5430 -5.3930011514021345e-07
Rt21472 T3942 T4150 1306165.4850528699
Gcorr7376 T3942 T5008 T3942 T5008 -1.9128211841373174e-07
Rt21473 T3942 T5019 2405006.3372426871
Rt21474 T3942 T5020 1292467.5132546357
Rt21475 T3942 T5341 3282029.9576835288
Rt21476 T3943 T4102 1583951.8667164564
Rt21477 T3943 T4132 2829366.8497912004
Rt21478 T3943 T4697 2107369.3198714992
Gcorr7377 T3943 T4718 T3943 T4718 -1.8486789938059569e-07
Gcorr7378 T3943 T6004 T3943 T6004 -1.5519759955836159e-07
Rt21479 T3943 T6077 4283617.5908888588
Rt21480 T3944 T4004 14691659.388620401
Rt21481 T3944 T4218 1901502.019334635
Gcorr7379 T3944 T5280 T3944 T5280 -5.3656677866360739e-07
Rt21482 T3944 T6053 869662.35979234474
Rt21483 T3945 T3946 4214623.4255119907
Rt21484 T3945 T5687 2736936.4159183223
Rt21485 T3945 T5793 1689800.1931202835
Gcorr7380 T3945 T5925 T3945 T5925 -3.5570242599601757e-08
Rt21486 T3946 T4215 44636697.725588858
Gcorr7381 T3946 T5261 T3946 T5261 -2.2741716166434682e-06
Rt21487 T3946 T5687 274691.27948731132
Gcorr7382 T3946 T5926 T3946 T5926 -1.4569612819099907e-07
Rt21488 T3946 T5989 868546.02726062236
Rt21489 T3947 T4590 36677734.693058595
Rt21490 T3947 T4630 4765921.920815683
Rt21491 T3947 T5696 6905072.5394968987
Rt21492 T3948 T4274 1600712.400966462
Gcorr7383 T3948 T5671 T3948 T5671 -5.3128244331958685e-07
Gcorr7384 T3948 T5856 T3948 T5856 -9.5880494177593495e-08
Rt21493 T3948 T5958 1364495.0035549805
Rt21494 T3949 T4025 4523138.3294672435
Rt21495 T3949 T5070 1825965.2665740903
Rt21496 T3949 T5071 12826988.679863835
Rt21497 T3949 T5072 122005187.36301719
Gcorr7385 T3949 T5073 T3949 T5073 -2.0168921465981035e-07
Rt21498 T3950 T5339 310145.6043790105
Rt21499 T3950 T5370 2205426.9384500408
Rt21500 T3950 T5926 2865916.8327267282
Gcorr7386 T3950 T5930 T3950 T5930 -2.8279970013242649e-06
Rt21501 T3951 T4106 369296.06346657505
Gcorr7387 T3951 T5240 T3951 T5240 -5.4121500311596961e-07
Rt21502 T3951 T5352 474154.93082922825
Gcorr7388 T3951 T5804 T3951 T5804 -6.3666695986550261e-08
Rt21503 T3951 T6011 924563.79617889493
Rt21504 T3952 T4198 2040266.528044017
Rt21505 T3952 T5253 822838.93174525921
Gcorr7389 T3952 T5602 T3952 T5602 -4.6623374220813826e-08
Gcorr7390 T3952 T5771 T3952 T5771 -4.214359490975771e-07
Gcorr7391 T3953 T4100 T3953 T4100 -1.6874348234215067e-08
Rt21506 T3953 T4353 24596115.515531965
Rt21507 T3953 T4356 5624820.4456544034
Rt21508 T3953 T5773 2484799.4801455243
Gcorr7392 T3953 T5836 T3953 T5836 -3.0618034313531331e-08
Rt21509 T3954 T4138 390402.11169379804
Rt21510 T3954 T4160 1946455.7548211236
Rt21511 T3954 T4164 7474364.8909683088
Gcorr7393 T3954 T4907 T3954 T4907 -1.7114176000542955e-07
Rt21512 T3954 T4908 702317.45057868911
Gcorr7394 T3954 T4911 T3954 T4911 -3.4248401961575944e-07
Gcorr7395 T3954 T5656 T3954 T5656 -5.6353907697159821e-07
Rt21513 T3955 T5204 5139233.8132266402
Gcorr7396 T3955 T5750 T3955 T5750 -6.8558167427000447e-08
Rt21514 T3955 T6028 4170668.8080504001
Rt21515 T3956 T4013 1666248.0040243741
Rt21516 T3956 T4061 1824765.1242218853
Rt21517 T3956 T4193 547787.84117996192
Gcorr7397 T3956 T4671 T3956 T4671 -4.5306536374632458e-07
Rt21518 T3956 T4682 1343192.317987486
Gcorr7398 T3956 T5318 T3956 T5318 -1.8250426915015766e-07
Rt21519 T3956 T5719 3197898.3603700488
Rt21520 T3957 T4068 1984860.636875856
Rt21521 T3957 T4793 3267888.3321632249
Gcorr7399 T3957 T4794 T3957 T4794 -1.374494377340955e-07
Gcorr7400 T3957 T4796 T3957 T4796 -7.6233935475502163e-08
Rt21522 T3957 T5644 3188726.6804368682
Rt21523 T3958 T4130 544988.85482758004
Rt21524 T3958 T5308 1668035.8807970928
Rt21525 T3958 T5751 1041352.4680993544
Rt21526 T3958 T5893 1226348.9974839846
Gcorr7401 T3959 T4679 T3959 T4679 -1.2292661482552602e-07
Gcorr7402 T3959 T4754 T3959 T4754 -1.1780936415616387e-08
Rt21527 T3959 T5630 2036107.291541859
Rt21528 T3960 T4146 833883.60745864874
Gcorr7403 T3960 T4279 T3960 T4279 -5.4195184657489585e-07
Gcorr7404 T3960 T4281 T3960 T4281 -6.3568883544212553e-07
Rt21529 T3960 T5211 282023.00931969349
Gcorr7405 T3960 T5845 T3960 T5845 -4.0792518871804416e-07
Rt21530 T3961 T4396 10996961.400019122
Gcorr7406 T3961 T4398 T3961 T4398 -1.4337559564460818e-07
Rt21531 T3961 T4399 2231634.3967955727
Gcorr7407 T3961 T5437 T3961 T5437 -9.5108056290004227e-08
Rt21532 T3962 T4221 2431711.7358885664
Gcorr7408 T3962 T5222 T3962 T5222 -1.2384110135628247e-07
Gcorr7409 T3962 T5341 T3962 T5341 -1.2165035227202438e-07
Rt21533 T3962 T5754 941843.80698934617
Rt21534 T3962 T5815 2220784.0808291282
Rt21535 T3963 T3984 1418507.7432563615
Gcorr7410 T3963 T4227 T3963 T4227 -1.0446335986254981e-06
Gcorr7411 T3963 T5275 T3963 T5275 -4.3553028719467524e-07
Gcorr7412 T3963 T5276 T3963 T5276 -4.8370056208394358e-08
Rt21536 T3963 T6083 351940.59256575332
Gcorr7413 T3964 T5041 T3964 T5041 -3.5436869711628447e-08
Rt21537 T3964 T5320 7765411.4505981524
Gcorr7414 T3964 T5503 T3964 T5503 -6.5297280641865463e-08
Rt21538 T3964 T6089 3752226.7569838013
Rt21539 T3965 T3966 1349097.011093619
Rt21540 T3965 T4688 2345253.8398888572
Gcorr7415 T3965 T4752 T3965 T4752 -4.1731421949421686e-07
Rt21541 T3965 T4753 2035850.6393597573
Gcorr7416 T3965 T5941 T3965 T5941 -1.915713979143545e-08
Rt21542 T3966 T4753 8706216.8696816806
Rt21543 T3966 T5294 4661913.3734311098
Rt21544 T3966 T5941 2817597.4476105003
Rt21545 T3967 T4007 1355846.1263401003
Rt21546 T3967 T5185 1221296.1165468295
Gcorr7417 T3967 T5218 T3967 T5218 -4.6013905133576327e-07
Rt21547 T3967 T5840 3239526.5337551846
Rt21548 T3967 T5912 1549927.5840598601
Rt21549 T3968 T4079 2194682.5422909376
Rt21550 T3968 T4234 758923.84439489478
Gcorr7418 T3968 T5315 T3968 T5315 -1.0122041344370648e-07
Rt21551 T3968 T5860 846500.47031882603
Rt21552 T3968 T5975 8783804.8693558127
Rt21553 T3969 T4008 1632652.8482753907
Rt21554 T3969 T4283 2876141.1516828025
Rt21555 T3969 T4285 728991.23236549506
Rt21556 T3969 T5322 1420993.8235141463
Rt21557 T3970 T4072 206298.24052852989
Rt21558 T3970 T4166 592605.31888146803
Gcorr7419 T3970 T4712 T3970 T4712 -5.7134376654387094e-07
Gcorr7420 T3970 T4737 T3970 T4737 -2.0898153186738581e-06
Gcorr7421 T3970 T4843 T3970 T4843 -4.2641048406031354e-07
Gcorr7422 T3970 T5136 T3970 T5136 -3.7088173467540278e-07
Gcorr7423 T3970 T5816 T3970 T5816 -3.9507257120542535e-07
Rt21559 T3970 T6032 212645.78897797852
Rt21560 T3971 T4101 2178724.5494949818
Gcorr7424 T3971 T4359 T3971 T4359 -1.0133458862518782e-07
Rt21561 T3971 T4361 10823903.689444976
Rt21562 T3971 T5267 2829090.6772379093
Rt21563 T3972 T4018 2022964.2655063469
Rt21564 T3972 T4694 4238676.1085638618
Gcorr7425 T3972 T5563 T3972 T5563 -1.2107891271524841e-07
Rt21565 T3972 T5621 10178083.683047015
Rt21566 T3972 T5970 6444546.8658041172
Rt21567 T3973 T3986 2371784.7543158694
Rt21568 T3973 T4000 920889.3976880624
Rt21569 T3973 T4990 1135401.1065847699
Gcorr7426 T3973 T5053 T3973 T5053 -1.7273196766154618e-07
Rt21570 T3973 T5309 2010439.6144940131
Rt21571 T3973 T5411 1440329.2327266685
Rt21572 T3974 T4098 604763.17690177425
Rt21573 T3974 T4099 2811824.3308390826
Rt21574 T3974 T5408 528579.12992808374
Gcorr7427 T3974 T5869 T3974 T5869 -6.311511502972259e-07
Gcorr7428 T3974 T5992 T3974 T5992 -5.1106953762738883e-07
Gcorr7429 T3974 T6057 T3974 T6057 -3.8220716314710391e-07
Gcorr7430 T3975 T4041 T3975 T4041 -9.6457714931366192e-08
Rt21575 T3975 T4976 2447473.7485701051
Gcorr7431 T3975 T4977 T3975 T4977 -6.9748170767156011e-08
Rt21576 T3975 T4978 1935602.4521140596
Gcorr7432 T3975 T4979 T3975 T4979 -4.5518356046092989e-07
Rt21577 T3976 T4189 1257643.5091903447
Rt21578 T3976 T4464 4927764.9552490711
Rt21579 T3976 T4604 5991255.359595363
Gcorr7433 T3976 T4605 T3976 T4605 -9.5481751835059625e-08
Rt21580 T3977 T5159 4916211.0946362372
Gcorr7434 T3977 T5260 T3977 T5260 -3.5085712253954018e-07
Rt21581 T3977 T5807 803981.90594078053
Gcorr7435 T3977 T6030 T3977 T6030 -1.1539498608422077e-07
Rt21582 T3978 T4213 253985.10783348556
Gcorr7436 T3978 T5616 T3978 T5616 -4.565771304076823e-07
Rt21583 T3978 T5954 7030665.0560121862
Gcorr7437 T3978 T6011 T3978 T6011 -2.9004423008583399e-07
Gcorr7438 T3979 T4066 T3979 T4066 -6.4008443848433884e-07
Gcorr7439 T3979 T4213 T3979 T4213 -6.8051805482488816e-07
Gcorr7440 T3979 T4921 T3979 T4921 -1.9306298812445944e-06
Rt21584 T3979 T5115 502619.75641577685
Rt21585 T3979 T5162 200429.29606335596
Rt21586 T3979 T5616 2576393.4744488243
Rt21587 T3980 T4103 3527190.654395577
Gcorr7441 T3980 T4872 T3980 T4872 -4.9733361581704433e-07
Gcorr7442 T3980 T4873 T3980 T4873 -1.0239585472222178e-07
Rt21588 T3980 T4993 850946.33717259963
Gcorr7443 T3980 T5237 T3980 T5237 -1.1746703648260666e-07
Rt21589 T3980 T5395 87938158.27016446
Rt21590 T3981 T4964 5807958.7140018074
Rt21591 T3981 T4965 5994612.387400154
Rt21592 T3981 T4966 59058394.712367781
Rt21593 T3982 T4088 970316.38263852196
Gcorr7444 T3982 T5303 T3982 T5303 -4.180283518273467e-08
Rt21594 T3982 T5356 3912674.0437328215
Rt21595 T3982 T6009 12345988.556322165
Rt21596 T3983 T4067 22289339.598825779
Rt21597 T3983 T4147 1081612.2909517221
Gcorr7445 T3983 T4531 T3983 T4531 -1.4342925083838452e-07
Gcorr7446 T3983 T4533 T3983 T4533 -1.3404599538248804e-07
Rt21598 T3983 T4534 699988.9205504409
Gcorr7447 T3983 T4535 T3983 T4535 -4.7929177553913608e-07
Gcorr7448 T3983 T5635 T3983 T5635 -2.9344652633515799e-07
Rt21599 T3984 T4206 1096439.9183206409
Rt21600 T3984 T5275 767792.36276104092
Gcorr7449 T3984 T6083 T3984 T6083 -8.6528178707128889e-08
Rt21601 T3985 T4175 1683792.8189904422
Rt21602 T3985 T4223 5435378.9191432325
Rt21603 T3985 T5829 1211248.4341332575
Rt21604 T3985 T6041 7501522.6580995126
Rt21605 T3986 T4233 1283726.2751574882
Rt21606 T3986 T5309 1195394.3026945498
Rt21607 T3986 T5411 1170939.5832518588
Rt21608 T3986 T5714 14895134.936980791
Gcorr7450 T3987 T3998 T3987 T3998 -3.4156103243377191e-07
Rt21609 T3987 T5310 735108.21471900516
Rt21610 T3987 T5714 35793559.929452553
Rt21611 T3987 T5910 2049067.424178435
Rt21612 T3987 T5953 3001898.917161826
Rt21613 T3988 T4079 1162849.6455251067
Gcorr7451 T3988 T4234 T3988 T4234 -2.3246658141507447e-07
Rt21614 T3988 T5946 236603.1056418381
Rt21615 T3988 T6038 7600417.1620182721
Rt21616 T3988 T6039 4667030.9716534792
Gcorr7452 T3989 T4269 T3989 T4269 -8.9021040667110311e-08
Rt21617 T3989 T4270 989376.41049413884
Rt21618 T3989 T4271 1034892.6633614646
Gcorr7453 T3989 T4272 T3989 T4272 -4.3039639652620439e-07
Gcorr7454 T3990 T4997 T3990 T4997 -1.1900539994552688e-07
Rt21619 T3990 T4998 2090837.9638997377
Rt21620 T3990 T4999 1223113.484730172
Rt21621 T3990 T5000 24065877.042809457
Rt21622 T3991 T4803 3407728.9681502706
Gcorr7455 T3991 T4804 T3991 T4804 -3.2273812408088134e-08
Rt21623 T3991 T4805 14126318.227000134
Rt21624 T3992 T5076 2711243.7506508408
Gcorr7456 T3992 T5078 T3992 T5078 -4.1604069585448667e-07
Rt21625 T3992 T5529 2196786.3780384841
Gcorr7457 T3992 T5572 T3992 T5572 -7.3909328862108389e-08
Gcorr7458 T3993 T4130 T3993 T4130 -3.9330175402487785e-07
Rt21626 T3993 T4290 347892.31524052052
Gcorr7459 T3993 T4292 T3993 T4292 -2.1728736643496554e-07
Rt21627 T3993 T5359 3817596.9200839214
Rt21628 T3993 T5386 691356.34265105543
Rt21629 T3994 T4159 22697342.377647586
Rt21630 T3994 T4701 3823962.1909364029
Gcorr7460 T3994 T4716 T3994 T4716 -6.7894068673263179e-08
Rt21631 T3994 T5398 7067746.549666984
Rt21632 T3995 T4098 1132516.9079414848
Rt21633 T3995 T4149 1287545.5794029008
Gcorr7461 T3995 T4497 T3995 T4497 -1.5900339603220146e-07
Rt21634 T3995 T4498 4107197.3717522337
Rt21635 T3995 T5613 5581110.3678390533
Rt21636 T3995 T5992 11724202.442425502
Rt21637 T3996 T4078 1181614.5588877355
Rt21638 T3996 T4543 7456366.2445354657
Gcorr7462 T3996 T4545 T3996 T4545 -9.0375227560655743e-08
Rt21639 T3996 T4660 2720914.7298567202
Gcorr7463 T3996 T5548 T3996 T5548 -1.0941401944113556e-07
Gcorr7464 T3997 T4890 T3997 T4890 -1.3196522416526716e-06
Gcorr7465 T3997 T4891 T3997 T4891 -2.5483440347147987e-07
Rt21640 T3997 T4892 401879.05498008302
Gcorr7466 T3997 T4893 T3997 T4893 -2.9891375904837087e-07
Gcorr7467 T3997 T5792 T3997 T5792 -2.939034687269271e-07
Rt21641 T3998 T4108 2611963.3309879699
Rt21642 T3998 T4217 5254831.8827157132
Rt21643 T3998 T5401 25261849.240708344
Rt21644 T3998 T5953 1025585.6914760565
Rt21645 T3998 T6010 1704653.3090559607
Gcorr7468 T3999 T4455 T3999 T4455 -1.9201578417301643e-07
Rt21646 T3999 T4456 1827915.1741112727
Gcorr7469 T3999 T4459 T3999 T4459 -3.5351652366381884e-08
Rt21647 T4000 T5053 617151.21682468837
Gcorr7470 T4000 T5404 T4000 T5404 -2.7948236030963093e-07
Rt21648 T4000 T5411 26277722.022834439
Gcorr7471 T4001 T4918 T4001 T4918 -1.0585305450324799e-07
Rt21649 T4001 T4919 834415.72586696013
Rt21650 T4001 T4920 3446810.5558968214
Gcorr7472 T4001 T4921 T4001 T4921 -1.4301893933510334e-07
Rt21651 T4002 T4081 145052999.29967099
Gcorr7473 T4002 T4658 T4002 T4658 -2.1727943060990527e-07
Gcorr7474 T4002 T5632 T4002 T5632 -1.4891388038340512e-07
Rt21652 T4002 T5633 1362658.0035372605
Gcorr7475 T4002 T5999 T4002 T5999 -8.8596675281635009e-09
Gcorr7476 T4003 T4868 T4003 T4868 -1.2043458125165242e-07
Rt21653 T4003 T5023 1826496.7343051541
Rt21654 T4003 T5210 1304577.7322796665
Gcorr7477 T4003 T5828 T4003 T5828 -7.0192197400498854e-08
Rt21655 T4004 T4044 16369288.422300486
Rt21656 T4004 T5289 1555141.1592475229
Rt21657 T4004 T6053 1366811.2122426569
Rt21658 T4004 T6086 12521229.194737731
Rt21659 T4005 T4508 5717439.3531071041
Rt21660 T4005 T4652 7982931.4858126529
Gcorr7478 T4005 T5480 T4005 T5480 -5.1109516104114653e-08
Gcorr7479 T4006 T5013 T4006 T5013 -5.7645464425297869e-07
Gcorr7480 T4006 T5168 T4006 T5168 -1.224678018975119e-07
Gcorr7481 T4006 T5329 T4006 T5329 -4.3870016534415901e-07
Gcorr7482 T4006 T5607 T4006 T5607 -5.1535020886337939e-07
Gcorr7483 T4006 T5759 T4006 T5759 -1.3889273978302656e-07
Rt21661 T4006 T5939 357822.79410797404
Rt21662 T4007 T4224 2939997.0743720168
Rt21663 T4007 T5185 14980942.066086406
Rt21664 T4007 T5912 2666862.5134017887
Rt21665 T4008 T4282 3226898.9138690666
Rt21666 T4008 T4283 511272.1173962797
Rt21667 T4008 T4284 761248.59048996191
Rt21668 T4008 T4285 23407075.176351402
Rt21669 T4009 T4140 1512744.798847713
Gcorr7484 T4009 T4426 T4009 T4426 -3.5379755290498553e-07
Rt21670 T4009 T4427 2315986.0504243611
Rt21671 T4009 T5379 7929205.2088165432
Gcorr7485 T4009 T5720 T4009 T5720 -3.2011073044658491e-07
Rt21672 T4009 T5990 2860165.9156185845
Gcorr7486 T4010 T4927 T4010 T4927 -1.0113031110531657e-07
Rt21673 T4010 T4947 2664964.9078719225
Rt21674 T4010 T4948 6828393.235448272
Gcorr7487 T4010 T5069 T4010 T5069 -1.3487624338281551e-07
Rt21675 T4011 T4216 3942467.4007553747
Rt21676 T4011 T5296 521680.63609301375
Gcorr7488 T4011 T5643 T4011 T5643 -7.8097669283925662e-07
Gcorr7489 T4012 T4076 T4012 T4076 -2.5097724408469323e-07
Gcorr7490 T4012 T5113 T4012 T5113 -5.6477330424253996e-07
Rt21677 T4012 T5452 1917137.062778804
Rt21678 T4012 T5765 278546.01467133913
Gcorr7491 T4012 T6019 T4012 T6019 -1.7216387276142295e-07
Gcorr7492 T4013 T4682 T4013 T4682 -1.5929957022036569e-07
Gcorr7493 T4013 T5285 T4013 T5285 -1.29312046970434e-07
Rt21679 T4013 T5318 1768153.9890613595
Rt21680 T4013 T5319 4768667.3373313108
Gcorr7494 T4013 T5664 T4013 T5664 -8.880457527015965e-08
Rt21681 T4014 T4829 1427193.8934252658
Rt21682 T4014 T4950 7549016.9330976428
Rt21683 T4014 T4992 1902311.3195561632
Gcorr7495 T4015 T4074 T4015 T4074 -3.2229303806245133e-07
Gcorr7496 T4015 T4300 T4015 T4300 -4.6017079109774282e-08
Rt21684 T4015 T5120 1835937.3136908021
Rt21685 T4015 T5987 382468.26731754484
Gcorr7497 T4015 T6016 T4015 T6016 -1.0243472732327762e-06
Gcorr7498 T4016 T4324 T4016 T4324 -1.6109859208227714e-07
Rt21686 T4016 T4325 1820245.5485767203
Rt21687 T4016 T4326 68621938.769504875
Rt21688 T4016 T4327 2504427.1615483575
Gcorr7499 T4016 T5811 T4016 T5811 -4.6351565565472251e-07
Rt21689 T4017 T4394 8676575.5040977914
Rt21690 T4017 T4395 5184645.8747197744
Rt21691 T4017 T4396 4721037.2726061931
Gcorr7500 T4017 T4397 T4017 T4397 -1.3052121221032393e-07
Gcorr7501 T4018 T4694 T4018 T4694 -1.2833945215969043e-07
Rt21692 T4018 T5621 11365054.333619306
Rt21693 T4018 T5651 2012083.9033353191
Gcorr7502 T4018 T5695 T4018 T5695 -8.3969019636466067e-08
Rt21694 T4019 T4195 9814704.2628720514
Gcorr7503 T4019 T5090 T4019 T5090 -4.1838277887920451e-07
Rt21695 T4019 T5091 2255102.7073406545
Rt21696 T4019 T5092 1071123.6984501488
Gcorr7504 T4019 T5096 T4019 T5096 -6.6736815906749716e-07
Rt21697 T4020 T4021 1547173.4193994361
Rt21698 T4020 T4194 505441.63708949694
Gcorr7505 T4020 T4742 T4020 T4742 -1.7512819183070407e-07
Gcorr7506 T4020 T5579 T4020 T5579 -1.2175252847075767e-07
Gcorr7507 T4020 T5618 T4020 T5618 -4.1825867023974122e-07
Rt21699 T4020 T5867 901323.04345585534
Rt21700 T4021 T4676 10942602.850774493
Rt21701 T4021 T4741 10518446.01658641
Rt21702 T4021 T4742 2579907.78157028
Gcorr7508 T4021 T5867 T4021 T5867 -2.0899056087070912e-07
Rt21703 T4022 T4692 5023992.4312407309
Rt21704 T4022 T4734 4564714.2912130803
Gcorr7509 T4022 T4757 T4022 T4757 -1.7730365106382289e-07
Rt21705 T4022 T5445 4629504.6322308732
Gcorr7510 T4023 T4483 T4023 T4483 -3.8776851693257311e-08
Rt21706 T4023 T5243 3905062.8479284304
Rt21707 T4023 T5559 9906371.2080700547
Rt21708 T4024 T4123 935510.7705760902
Gcorr7511 T4024 T4277 T4024 T4277 -4.4829091586363292e-08
Rt21709 T4024 T5490 4000343.6339382906
Gcorr7512 T4024 T5657 T4024 T5657 -6.0372595152707461e-08
Rt21710 T4024 T5661 2985518.9892005753
Rt21711 T4025 T5072 11172470.153114213
Rt21712 T4025 T5073 8806695.9565754291
Rt21713 T4025 T5074 4578213.4291282678
Rt21714 T4025 T5100 66879281.756316744
Rt21715 T4026 T5038 1165347.9544339739
Gcorr7513 T4026 T5937 T4026 T5937 -1.0419643188650348e-06
Rt21716 T4026 T6005 1014165.0167471967
Rt21717 T4027 T4077 990293.01869133196
Rt21718 T4027 T5190 6651688.4389856802
Rt21719 T4027 T5193 2580602.3480511131
Gcorr7514 T4027 T5678 T4027 T5678 -5.9126349768847768e-08
Gcorr7515 T4028 T4125 T4028 T4125 -2.3297673262926553e-07
Rt21720 T4028 T5336 1113170.5899878128
Rt21721 T4028 T5337 4172345.3987270095
Rt21722 T4028 T5762 1090925.4720828803
Gcorr7516 T4028 T5763 T4028 T5763 -4.5157662670516114e-07
Rt21723 T4029 T4192 1353277.6919899199
Rt21724 T4029 T5174 15752549.679367471
Rt21725 T4029 T5175 3403276.1582730953
Rt21726 T4029 T5187 6934025.0630993322
Gcorr7517 T4029 T5802 T4029 T5802 -9.8921515551019673e-08
Rt21727 T4030 T4192 2706422.640708629
Gcorr7518 T4030 T5109 T4030 T5109 -5.85343989277003e-06
Rt21728 T4030 T5110 12664790.015239136
Rt21729 T4030 T5173 151026.17686705323
Gcorr7519 T4030 T5345 T4030 T5345 -4.2830712282231906e-07
Rt21730 T4031 T4466 608829.70572605182
Gcorr7520 T4031 T5446 T4031 T5446 -2.5435349514452629e-07
Rt21731 T4031 T5549 1038897.4346345883
Rt21732 T4031 T5660 1568788.9189555631
Rt21733 T4032 T5447 4255137.5637748009
Rt21734 T4032 T5627 4346077.1928715175
Rt21735 T4032 T5844 2000492.6747137941
Gcorr7521 T4032 T5845 T4032 T5845 -4.492763925226922e-08
Rt21736 T4033 T4205 1229107.7922787864
Rt21737 T4033 T4226 2476824.6600654246
Rt21738 T4033 T5271 584578.50040795701
Gcorr7522 T4033 T5383 T4033 T5383 -5.4593504451075271e-07
Rt21739 T4034 T4545 2211236.2654309785
Gcorr7523 T4034 T4546 T4034 T4546 -1.3648995547726868e-07
Rt21740 T4034 T4547 19109460.979653906
Gcorr7524 T4034 T5540 T4034 T5540 -1.2767549844494568e-07
Rt21741 T4035 T4613 4568303.5970917493
Rt21742 T4035 T5698 5485274.9169363873
Gcorr7525 T4035 T5699 T4035 T5699 -1.2243170673492055e-07
Rt21743 T4035 T6026 25624280.347247418
Rt21744 T4036 T4365 7016356.4662588192
Rt21745 T4036 T4367 7210652.1507082274
Gcorr7526 T4036 T5439 T4036 T5439 -6.7755395209730655e-08
Rt21746 T4037 T4236 7964740.507726091
Rt21747 T4037 T5317 561074.57412104227
Rt21748 T4037 T5786 497773.62440695555
Gcorr7527 T4037 T5798 T4037 T5798 -3.0324770562461422e-07
Rt21749 T4038 T4077 1118827.080501898
Rt21750 T4038 T4917 3949089.0404574457
Gcorr7528 T4038 T5678 T4038 T5678 -7.918575443653267e-08
Rt21751 T4038 T5679 3189707.6690903129
Rt21752 T4039 T4827 4273089.595213796
Rt21753 T4039 T5552 5510812.0774742579
Gcorr7529 T4039 T5808 T4039 T5808 -3.3062362620623077e-08
Gcorr7530 T4040 T4138 T4040 T4138 -2.8163400158113073e-08
Rt21754 T4040 T4911 3819853.6743651535
Gcorr7531 T4040 T4913 T4040 T4913 -1.4109326192349255e-07
Rt21755 T4040 T4914 1153294.8751246394
Gcorr7532 T4040 T5896 T4040 T5896 -4.0032463032548193e-07
Gcorr7533 T4041 T4977 T4041 T4977 -4.903420071676147e-07
Rt21756 T4041 T4978 4770735.8765832698
Rt21757 T4041 T4981 659385.76080635854
Gcorr7534 T4041 T5575 T4041 T5575 -1.3591486011962877e-07
Gcorr7535 T4041 T6024 T4041 T6024 -6.0811280676353786e-07
Rt21758 T4042 T5286 4518767.3712927364
Gcorr7536 T4042 T5287 T4042 T5287 -1.7791701424006686e-07
Rt21759 T4042 T5288 2588979.1571369004
Rt21760 T4042 T5586 12020918.705156716
Gcorr7537 T4043 T4214 T4043 T4214 -1.4705368083238202e-08
Rt21761 T4043 T5272 1438774.5861836688
Rt21762 T4043 T5706 7657335.7609273773
Gcorr7538 T4043 T6051 T4043 T6051 -7.7408078891122262e-08
Rt21763 T4044 T5281 3980782.0338378134
Rt21764 T4044 T5729 58205910.02906739
Rt21765 T4044 T6086 870852.73510135966
Rt21766 T4045 T4046 5001094.3545844397
Rt21767 T4045 T5278 3714833.3716228604
Rt21768 T4045 T5676 175883958.79553986
Rt21769 T4045 T5974 2452353.8563085715
Rt21770 T4046 T4093 1480903.4244288835
Rt21771 T4046 T4209 104966105.0273104
Rt21772 T4046 T5278 1050232.3350357595
Rt21773 T4046 T5576 4045767.6519282875
Gcorr7539 T4047 T4188 T4047 T4188 -1.9585437302169207e-08
Rt21774 T4047 T4302 9002060.8529190235
Gcorr7540 T4047 T4305 T4047 T4305 -1.5504850649268162e-07
Rt21775 T4047 T4306 1209858.7549225495
Gcorr7541 T4047 T5306 T4047 T5306 -2.0115902675669039e-07
Rt21776 T4048 T4477 845243.10553686041
Gcorr7542 T4048 T4478 T4048 T4478 -4.829804538828362e-08
Gcorr7543 T4048 T4479 T4048 T4479 -2.1411987800640701e-07
Gcorr7544 T4048 T5873 T4048 T5873 -3.4963957899406374e-07
Gcorr7545 T4049 T4112 T4049 T4112 -1.1945536126462923e-07
Gcorr7546 T4049 T5282 T4049 T5282 -4.2875623197842334e-07
Gcorr7547 T4049 T5283 T4049 T5283 -3.572731752002883e-07
Rt21777 T4049 T5284 388816.56814748363
Gcorr7548 T4049 T5286 T4049 T5286 -4.5209433859968226e-07
Rt21778 T4050 T4109 15019322.414395759
Gcorr7549 T4050 T4319 T4050 T4319 -1.307113507438086e-07
Rt21779 T4050 T4320 148383120.70644253
Rt21780 T4050 T5727 2491066.7113260482
Rt21781 T4051 T4171 1224727.8247610824
Rt21782 T4051 T4425 4891583.9505645614
Gcorr7550 T4051 T5344 T4051 T5344 -3.5429520015508659e-07
Rt21783 T4051 T5491 5232179.3385932026
Rt21784 T4051 T6073 4680923.6562359575
Rt21785 T4052 T4053 1547324.5876683681
Rt21786 T4052 T4226 23554915.736408141
Rt21787 T4052 T5381 31730344.732703008
Gcorr7551 T4052 T5383 T4052 T5383 -1.6364662568871055e-07
Rt21788 T4052 T5819 1548038.6389090715
Rt21789 T4053 T4226 4524523.116487219
Rt21790 T4053 T5266 86741729.659131035
Rt21791 T4053 T5381 2226293.9949992727
Rt21792 T4054 T4371 11328301.892705046
Gcorr7552 T4054 T4373 T4054 T4373 -2.3722985258516637e-07
Gcorr7553 T4054 T4380 T4054 T4380 -6.0253995988169097e-08
Rt21793 T4054 T5611 1894495.7682016271
Gcorr7554 T4055 T4504 T4055 T4504 -8.5382568211014607e-08
Gcorr7555 T4055 T4821 T4055 T4821 -1.385375816413058e-07
Rt21794 T4055 T5488 726735.23930277431
Gcorr7556 T4055 T6046 T4055 T6046 -8.766070201511101e-07
Gcorr7557 T4056 T4400 T4056 T4400 -5.1014888888363079e-07
Rt21795 T4056 T4402 7442834.1508728024
Rt21796 T4056 T4403 1658739.7100759309
Rt21797 T4057 T4745 15931337.5826039
Rt21798 T4057 T4768 2507562.7044880479
Rt21799 T4057 T4833 554857.84394375177
Gcorr7558 T4057 T4837 T4057 T4837 -8.4880490820107953e-07
Gcorr7559 T4057 T5903 T4057 T5903 -1.5400301627824978e-07
Gcorr7560 T4058 T4076 T4058 T4076 -3.0085624214490654e-08
Rt21800 T4058 T4987 993804.95816267678
Gcorr7561 T4058 T5258 T4058 T5258 -2.623502218739214e-08
Gcorr7562 T4058 T5259 T4058 T5259 -9.4584062563656336e-08
Gcorr7563 T4059 T4924 T4059 T4924 -6.717779146413802e-08
Rt21801 T4059 T5830 19949560.801293634
Rt21802 T4059 T5831 1024972.5046910421
Rt21803 T4060 T4855 3934352.9643931552
Gcorr7564 T4060 T4956 T4060 T4956 -1.6388175785661123e-07
Rt21804 T4060 T5029 5129280.941481052
Rt21805 T4060 T5914 4196785.7326373942
Gcorr7565 T4061 T4669 T4061 T4669 -1.6430766517714193e-07
Rt21806 T4061 T4682 2009960.5952663878
Rt21807 T4061 T5531 11948029.56728881
Gcorr7566 T4061 T5664 T4061 T5664 -1.2888921667426488e-07
Gcorr7567 T4062 T4157 T4062 T4157 -1.8619362112113164e-08
Rt21808 T4062 T4310 2009898.3317209799
Rt21809 T4062 T4312 188184895.42687103
Gcorr7568 T4062 T4315 T4062 T4315 -7.7156924285714638e-08
Rt21810 T4063 T4853 494495.27445096575
Rt21811 T4063 T4938 10821894.890156737
Rt21812 T4063 T4939 12225890.708222251
Gcorr7569 T4063 T5184 T4063 T5184 -1.8743510756178875e-06
Rt21813 T4064 T5195 4409676.1524331002
Gcorr7570 T4064 T5303 T4064 T5303 -9.2064341996960018e-08
Rt21814 T4064 T5314 4259060.6139758397
Rt21815 T4064 T5426 9863335.5370095018
Gcorr7571 T4065 T4763 T4065 T4763 -1.0945523945083038e-07
Rt21816 T4065 T4870 6399361.0808947999
Gcorr7572 T4065 T5456 T4065 T5456 -7.7314590916095881e-08
Rt21817 T4065 T5715 2504023.929623642
Rt21818 T4066 T5115 1276166.914960291
Rt21819 T4066 T5343 297406.41694853862
Rt21820 T4066 T5616 1521617.0908097429
Gcorr7573 T4066 T5917 T4066 T5917 -5.9310186101014699e-07
Rt21821 T4067 T4529 4000663.5384430187
Gcorr7574 T4067 T4530 T4067 T4530 -5.3438811607126131e-07
Rt21822 T4067 T4531 385652.44660060486
Gcorr7575 T4067 T4532 T4067 T4532 -1.9409449325564552e-06
Rt21823 T4068 T4796 3542789.9171815272
Rt21824 T4068 T4863 4748872.9631011263
Rt21825 T4068 T4864 2655718.7433947143
Gcorr7576 T4068 T5042 T4068 T5042 -1.7274648101998871e-07
Gcorr7577 T4068 T5644 T4068 T5644 -1.065213579472827e-07
Rt21826 T4069 T5254 6217511.9943517242
Gcorr7578 T4069 T5344 T4069 T5344 -1.8852917022740779e-07
Rt21827 T4069 T5884 2836033.8435701178
Rt21828 T4070 T4894 2639694.1434577205
Gcorr7579 T4070 T4895 T4070 T4895 -9.4682843764211642e-08
Rt21829 T4070 T4896 5914449.683838754
Gcorr7580 T4070 T5001 T4070 T5001 -1.0765491315928481e-07
Gcorr7581 T4071 T5247 T4071 T5247 -4.0674425046426195e-07
Gcorr7582 T4071 T5270 T4071 T5270 -3.1121438413583975e-07
Gcorr7583 T4071 T5690 T4071 T5690 -1.3227583181701146e-07
Rt21830 T4071 T5918 960646.22629870207
Rt21831 T4072 T4737 308750.83574339544
Gcorr7584 T4072 T5816 T4072 T5816 -2.5926392270160458e-07
Gcorr7585 T4072 T5854 T4072 T5854 -3.6145591738353744e-07
Gcorr7586 T4072 T6032 T4072 T6032 -2.0124758243786675e-06
Gcorr7587 T4073 T4303 T4073 T4303 -3.296976899201001e-07
Gcorr7588 T4073 T4307 T4073 T4307 -1.103434464905691e-07
Rt21832 T4073 T5208 227833.71236189129
Gcorr7589 T4073 T5360 T4073 T5360 -3.6910437274704076e-06
Gcorr7590 T4074 T4296 T4074 T4296 -2.5465946108137036e-07
Rt21833 T4074 T4297 2380156.1418382316
Rt21834 T4074 T4300 522346.96368129528
Gcorr7591 T4074 T4301 T4074 T4301 -2.0995858773954544e-07
Rt21835 T4075 T4183 8788676.3474426009
Rt21836 T4075 T4308 58808597.31421259
Rt21837 T4075 T4735 28671488.622571472
Rt21838 T4075 T5909 2367385.4523079433
Rt21839 T4076 T4986 13231928.705292741
Rt21840 T4076 T4987 4398721.0882540252
Rt21841 T4076 T5113 686556.93820772076
Gcorr7592 T4077 T5193 T4077 T5193 -1.6588517490806763e-07
Rt21842 T4077 T5678 1395835.0210049211
Rt21843 T4077 T5679 6744691.6792406216
Rt21844 T4077 T5748 16744830.597020123
Rt21845 T4078 T4143 1591775.7978836657
Gcorr7593 T4078 T4660 T4078 T4660 -1.0329980755200698e-07
Rt21846 T4078 T5548 2808541.080349748
Gcorr7594 T4078 T5769 T4078 T5769 -1.8016998522721556e-07
Rt21847 T4078 T6087 4797480.0100147203
Rt21848 T4079 T4234 511855.63703714521
Gcorr7595 T4079 T5946 T4079 T5946 -1.9463263589227368e-07
Rt21849 T4080 T4236 10542620.513108147
Rt21850 T4080 T6000 71462.194979069114
Rt21851 T4081 T4144 1521970.1740205293
Rt21852 T4081 T4767 5353855.5338147562
Gcorr7596 T4081 T5632 T4081 T5632 -1.0754994186490371e-07
Rt21853 T4081 T5999 3164846.2574659581
Rt21854 T4082 T4983 914196.6251841191
Gcorr7597 T4082 T4984 T4082 T4984 -3.785791066929904e-07
Gcorr7598 T4082 T5233 T4082 T5233 -7.6842012491063286e-08
Gcorr7599 T4083 T4214 T4083 T4214 -1.4687994566879981e-07
Rt21855 T4083 T5122 2491238.9727378068
Rt21856 T4083 T5367 2489765.6104555
Rt21857 T4083 T5706 1432917.2864896341
Gcorr7600 T4083 T6041 T4083 T6041 -2.7815322230585828e-07
Rt21858 T4084 T4970 277945.68869925046
Gcorr7601 T4084 T4971 T4084 T4971 -1.7297212140254556e-07
Gcorr7602 T4084 T4972 T4084 T4972 -5.8152515045892456e-08
Gcorr7603 T4084 T5556 T4084 T5556 -3.0611797201391109e-06
Gcorr7604 T4085 T4934 T4085 T4934 -3.0073393592316999e-07
Rt21859 T4085 T4935 1162535.799022041
Gcorr7605 T4085 T4965 T4085 T4965 -3.375342318498965e-08
Gcorr7606 T4085 T5333 T4085 T5333 -3.1569539904418022e-07
Gcorr7607 T4086 T4095 T4086 T4095 -6.3180669929450873e-08
Gcorr7608 T4086 T4866 T4086 T4866 -6.0133479604838557e-07
Gcorr7609 T4086 T5229 T4086 T5229 -1.2226434662842412e-07
Rt21860 T4086 T5372 5578535.5474803541
Rt21861 T4086 T6080 1092761.3949973164
Rt21862 T4087 T4228 530865.31696402584
Gcorr7610 T4087 T5315 T4087 T5315 -1.2091498061979492e-07
Rt21863 T4088 T5303 8842834.0404482856
Rt21864 T4088 T5567 3408320.0951042641
Gcorr7611 T4088 T6009 T4088 T6009 -1.0348212460837269e-07
Rt21865 T4089 T5094 6553279.4763624147
Rt21866 T4089 T5095 4344640.1358429017
Rt21867 T4089 T5102 5453066.8366109272
Gcorr7612 T4089 T5103 T4089 T5103 -1.4373095299261919e-07
Gcorr7613 T4090 T5061 T4090 T5061 -2.3520111949226545e-07
Gcorr7614 T4090 T5262 T4090 T5262 -2.041048434632371e-07
Gcorr7615 T4090 T5324 T4090 T5324 -1.3101751902747668e-07
Rt21868 T4090 T5932 758734.82113213977
Gcorr7616 T4090 T6025 T4090 T6025 -1.0647406936828352e-07
Rt21869 T4091 T5231 3866567.7489562384
Gcorr7617 T4091 T5784 T4091 T5784 -1.0774032025444673e-07
Rt21870 T4091 T5858 7352839.397929172
Gcorr7618 T4092 T4927 T4092 T4927 -4.3458000616933008e-07
Gcorr7619 T4092 T4948 T4092 T4948 -2.9843181176342112e-07
Rt21871 T4092 T5605 48685274.066305079
Gcorr7620 T4092 T5927 T4092 T5927 -2.1547701826409262e-07
Rt21872 T4092 T5938 785958.98851029552
Rt21873 T4093 T4209 4544252.9501479501
Gcorr7621 T4093 T5275 T4093 T5275 -1.2797469545356839e-07
Rt21874 T4093 T5277 1168549.6902997391
Gcorr7622 T4093 T5278 T4093 T5278 -1.8807608678355764e-07
Rt21875 T4094 T4618 679876.85611851292
Rt21876 T4094 T4624 331992855.91248077
Rt21877 T4094 T4785 11421486.896077082
Gcorr7623 T4094 T5710 T4094 T5710 -9.2634749448593163e-07
Gcorr7624 T4095 T4799 T4095 T4799 -9.7765696382530626e-08
Rt21878 T4095 T5148 7017866.4803523067
Rt21879 T4095 T5372 109229045.89730461
Rt21880 T4095 T5980 3163880.1947396845
Rt21881 T4096 T4239 10703919.941124706
Gcorr7625 T4096 T4240 T4096 T4240 -1.9923329243718933e-07
Rt21882 T4096 T4241 646923.67753311119
Gcorr7626 T4096 T5219 T4096 T5219 -7.2755541052266503e-07
Rt21883 T4097 T4358 2737433.2360830279
Rt21884 T4097 T4359 10263767.56861282
Rt21885 T4097 T4360 12358501.180393923
Gcorr7627 T4097 T4627 T4097 T4627 -1.0296503002723904e-07
Gcorr7628 T4098 T4498 T4098 T4498 -6.1899981089606056e-08
Gcorr7629 T4098 T5408 T4098 T5408 -4.693953599230585e-07
Rt21886 T4098 T5992 1718577.750623961
Rt21887 T4098 T6057 4861994.6438778248
Rt21888 T4099 T5406 6137350.4644975858
Rt21889 T4099 T5407 2587980.9464920415
Rt21890 T4099 T5408 18055027.519938622
Rt21891 T4100 T4352 3795525.835364149
Gcorr7630 T4100 T4949 T4100 T4949 -3.6681335242384239e-07
Rt21892 T4100 T4996 1641744.0911148321
Rt21893 T4100 T5773 19615292.772781063
Gcorr7631 T4101 T4360 T4101 T4360 -1.5420663260648291e-07
Rt21894 T4101 T4361 601553.96403441729
Gcorr7632 T4101 T4362 T4101 T4362 -1.061425634696085e-06
Gcorr7633 T4101 T4363 T4101 T4363 -1.4459484997901827e-07
Gcorr7634 T4102 T4697 T4102 T4697 -1.5452188584075714e-07
Rt21895 T4102 T4717 2037065.6937763852
Rt21896 T4102 T4718 3577669.6336337375
Gcorr7635 T4102 T4818 T4102 T4818 -9.6265979955972475e-08
Rt21897 T4103 T5237 51882775.887884378
Rt21898 T4103 T5395 14220526.924398465
Rt21899 T4103 T5396 3087600.0036270111
Gcorr7636 T4103 T6062 T4103 T6062 -7.9743146847556918e-09
Rt21900 T4104 T4105 3604586.4899804182
Gcorr7637 T4104 T5111 T4104 T5111 -4.9128459637250284e-07
Rt21901 T4104 T5171 2648691.2211340298
Gcorr7638 T4104 T5213 T4104 T5213 -3.8808242018104277e-07
Rt21902 T4104 T5870 572567.96408878255
Gcorr7639 T4104 T5949 T4104 T5949 -3.2819262878338301e-07
Rt21903 T4105 T4224 4460673.1373072462
Rt21904 T4105 T5835 2456959.3955877526
Rt21905 T4105 T5870 2090167.6376814644
Rt21906 T4106 T4992 22267415.893740773
Rt21907 T4106 T5240 502521.9148222612
Gcorr7640 T4106 T5352 T4106 T5352 -1.5694095388787258e-07
Gcorr7641 T4106 T6011 T4106 T6011 -5.8675504419900543e-07
Rt21908 T4107 T5965 121017.58110857243
Gcorr7642 T4107 T6074 T4107 T6074 -6.0797259121640785e-07
Rt21909 T4108 T4217 566255.97863829823
Rt21910 T4108 T5335 4799463.4571192628
Gcorr7643 T4108 T6010 T4108 T6010 -2.3731965888200952e-07
Rt21911 T4108 T6012 980315.39909347345
Gcorr7644 T4109 T4318 T4109 T4318 -5.4291942722679538e-07
Rt21912 T4109 T4320 1861514.5554511764
Rt21913 T4109 T4321 2054128.7941372187
Gcorr7645 T4109 T4322 T4109 T4322 -1.0632130441473898e-07
Gcorr7646 T4110 T4834 T4110 T4834 -9.690049493171224e-08
Rt21914 T4110 T4835 4132269.9456262738
Rt21915 T4110 T4945 12133629.81109371
Rt21916 T4110 T5594 8116701.5231465148
Rt21917 T4111 T4316 10444370.998699097
Gcorr7647 T4111 T4318 T4111 T4318 -1.1598194782283337e-07
Rt21918 T4111 T4319 2343286.8203334408
Gcorr7648 T4111 T5297 T4111 T5297 -1.2522153299878502e-07
Gcorr7649 T4112 T4235 T4112 T4235 -4.6084991100372175e-07
Gcorr7650 T4112 T5284 T4112 T5284 -6.9913925458248539e-07
Rt21919 T4112 T5608 383770.92893477919
Rt21920 T4112 T5843 689702.15981143434
Rt21921 T4113 T4141 6378623.4808984771
Rt21922 T4113 T4960 4188180.5513406019
Gcorr7651 T4113 T5008 T4113 T5008 -1.0721123493478435e-07
Rt21923 T4113 T5018 1119283.9928426191
Rt21924 T4113 T5947 6741185.3414510814
Gcorr7652 T4114 T5027 T4114 T5027 -1.0498293563269385e-07
Rt21925 T4114 T5197 2999946.867094832
Rt21926 T4114 T5481 6011525.9699111041
Gcorr7653 T4114 T5603 T4114 T5603 -1.0828623677222131e-07
Rt21927 T4115 T4663 11492417.697642056
Rt21928 T4115 T5428 1949430.9511295781
Gcorr7654 T4115 T5732 T4115 T5732 -2.1630213716138882e-08
Gcorr7655 T4115 T5775 T4115 T5775 -5.7886228988119115e-08
Gcorr7656 T4115 T5976 T4115 T5976 -9.4857729519559221e-08
Gcorr7657 T4116 T4471 T4116 T4471 -1.6818541883014401e-07
Gcorr7658 T4116 T4685 T4116 T4685 -7.2100603224164656e-08
Rt21929 T4116 T5504 1863367.5946829817
Gcorr7659 T4117 T4165 T4117 T4165 -9.5704987427762863e-08
Rt21930 T4117 T4685 19389900.999665774
Rt21931 T4117 T4686 5364540.4334203191
Rt21932 T4117 T4766 2991593.3050047341
Rt21933 T4118 T4940 3588852.1792236194
Gcorr7660 T4118 T5620 T4118 T5620 -1.0191889304191059e-07
Rt21934 T4118 T5682 9202148.2087444123
Rt21935 T4119 T4155 3127766.0739514059
Rt21936 T4119 T5082 35886204.529985681
Rt21937 T4119 T5084 2494640.2510382854
Rt21938 T4119 T5085 17126753.820600111
Gcorr7661 T4119 T5086 T4119 T5086 -1.4749859339116e-07
Rt21939 T4120 T5194 2682130.3687584242
Rt21940 T4120 T5199 12121634.176498672
Rt21941 T4120 T5340 3593668.4011353538
Rt21942 T4121 T4122 1029274.6293752379
Gcorr7662 T4121 T4272 T4121 T4272 -4.5664407194868547e-07
Rt21943 T4121 T4276 2775395.0847909609
Rt21944 T4121 T5789 581653.63688599179
Gcorr7663 T4122 T4276 T4122 T4276 -4.4776357486111643e-07
Rt21945 T4122 T4280 2119300.737979156
Rt21946 T4122 T5338 1199118.587065259
Rt21947 T4122 T5789 1393844.6477880045
Gcorr7664 T4123 T4265 T4123 T4265 -1.3765731088748958e-07
Rt21948 T4123 T4277 831042.60118461458
Gcorr7665 T4123 T5658 T4123 T5658 -2.8575129220805041e-07
Gcorr7666 T4123 T5661 T4123 T5661 -2.9507409064674075e-07
Gcorr7667 T4124 T5119 T4124 T5119 -5.0080149719203419e-07
Rt21949 T4124 T5177 751206.87284900155
Gcorr7668 T4124 T5405 T4124 T5405 -3.9784568289628515e-07
Rt21950 T4124 T6013 1739205.5225460774
Gcorr7669 T4125 T4280 T4125 T4280 -8.3485761885353121e-07
Rt21951 T4125 T4282 1344010.8638008453
Rt21952 T4125 T5337 433565.62747950619
Gcorr7670 T4126 T4863 T4126 T4863 -3.2730838139775761e-08
Rt21953 T4126 T5245 15630041.048404757
Rt21954 T4126 T5772 3545101.0937179942
Rt21955 T4127 T5011 6751331.7637253739
Gcorr7671 T4127 T5137 T4127 T5137 -1.0103891172784552e-07
Rt21956 T4127 T5215 2850836.2360842307
Gcorr7672 T4127 T5525 T4127 T5525 -1.1950959618849173e-07
Rt21957 T4128 T5065 6998305.1043204367
Rt21958 T4128 T5265 1586127.9530005844
Rt21959 T4128 T5711 1457483.3035123779
Rt21960 T4129 T5250 808896.31693070405
Rt21961 T4129 T5251 2646049.9395937943
Gcorr7673 T4129 T5339 T4129 T5339 -5.6367098438088953e-07
Gcorr7674 T4130 T5067 T4130 T5067 -8.5891324704988098e-08
Rt21962 T4130 T5386 475241.04578691768
Gcorr7675 T4130 T5751 T4130 T5751 -4.0003868046660113e-07
Rt21963 T4130 T5893 1316804.1314354769
Gcorr7676 T4131 T4778 T4131 T4778 -2.4144089049678315e-07
Gcorr7677 T4131 T4780 T4131 T4780 -7.1866976723200737e-08
Gcorr7678 T4131 T4958 T4131 T4958 -5.9086011881470381e-07
Rt21964 T4131 T5511 828087.63559408172
Rt21965 T4132 T5232 16609581.765622534
Rt21966 T4132 T6077 4189983.7988585578
Rt21967 T4133 T4661 7949584.964358693
Rt21968 T4133 T4662 4705496.1282943487
Rt21969 T4133 T4751 418108.82254993689
Gcorr7679 T4133 T5034 T4133 T5034 -2.309413804859727e-06
Gcorr7680 T4134 T5015 T4134 T5015 -3.587223846668829e-07
Rt21970 T4134 T5430 1305889.0597877724
Gcorr7681 T4134 T5431 T4134 T5431 -9.321085795351204e-08
Rt21971 T4135 T5183 604226.69078910863
Gcorr7682 T4135 T5368 T4135 T5368 -5.9309108231152843e-10
Gcorr7683 T4135 T5564 T4135 T5564 -1.3362729603139837e-07
Rt21972 T4135 T5959 4392943.7924460657
Gcorr7684 T4135 T6036 T4135 T6036 -7.3558410435937642e-07
Gcorr7685 T4136 T5042 T4136 T5042 -2.3157150638183982e-07
Gcorr7686 T4136 T5245 T4136 T5245 -8.9394012398391362e-08
Rt21973 T4136 T5301 619368.51837089506
Rt21974 T4137 T4776 10851856.20869028
Rt21975 T4137 T4811 1471194.7940725579
Rt21976 T4137 T4838 9199245.7810633779
Gcorr7687 T4137 T5654 T4137 T5654 -6.0543061264453197e-07
Rt21977 T4138 T4160 24866320.382084247
Gcorr7688 T4138 T4908 T4138 T4908 -7.4661458308642694e-07
Rt21978 T4138 T4911 2769780.1999057257
Rt21979 T4138 T5656 648232.97048478818
Gcorr7689 T4138 T5657 T4138 T5657 -2.9099265843594128e-07
Gcorr7690 T4138 T5896 T4138 T5896 -4.7963161740852532e-07
Gcorr7691 T4139 T4326 T4139 T4326 -7.022155528873747e-08
Rt21980 T4139 T4328 1220267.0369299599
Gcorr7692 T4139 T4329 T4139 T4329 -4.732045963558031e-07
Rt21981 T4140 T5379 2269817.9235461107
Gcorr7693 T4140 T5696 T4140 T5696 -7.7532777840039018e-08
Gcorr7694 T4140 T5990 T4140 T5990 -1.0545970414547425e-07
Gcorr7695 T4141 T4931 T4141 T4931 -8.5401558196968801e-08
Gcorr7696 T4141 T5823 T4141 T5823 -4.1273375013145573e-08
Rt21982 T4141 T5947 1424389.925847556
Rt21983 T4141 T6088 6129607.9222255433
Rt21984 T4142 T4364 6483226.7672585277
Rt21985 T4142 T4366 53812321.5999479
Rt21986 T4142 T4663 7024075.6192771709
Rt21987 T4143 T5225 12579279.29048734
Rt21988 T4143 T5769 2305023.8656289759
Gcorr7697 T4143 T6087 T4143 T6087 -5.9716151258116584e-08
Rt21989 T4144 T4767 3545901.1657564892
Rt21990 T4144 T5668 9163910.3722317461
Rt21991 T4144 T5669 2016721.4766351627
Gcorr7698 T4144 T5999 T4144 T5999 -9.7539802696312773e-08
Gcorr7699 T4144 T6072 T4144 T6072 -3.5169070092016862e-07
Rt21992 T4145 T4540 6693147.9305488439
Rt21993 T4145 T4542 7575414.8546230951
Gcorr7700 T4145 T4690 T4145 T4690 -5.1085912465471005e-08
Rt21994 T4146 T5211 2498180.9413245791
Rt21995 T4146 T5244 1108276.5783362195
Gcorr7701 T4146 T5582 T4146 T5582 -4.074765197675889e-07
Rt21996 T4146 T5845 4002230.5715727778
Gcorr7702 T4147 T4197 T4147 T4197 -2.5315884690804343e-08
Gcorr7703 T4147 T4534 T4147 T4534 -1.0106120993036325e-07
Gcorr7704 T4147 T5224 T4147 T5224 -1.5387250497135416e-07
Rt21997 T4147 T5635 10708672.816818843
Gcorr7705 T4147 T5984 T4147 T5984 -7.8446367991287856e-07
Rt21998 T4147 T6002 742597.03019446146
Rt21999 T4148 T4482 1904864.9844556581
Gcorr7706 T4148 T4483 T4148 T4483 -2.6359577194872096e-07
Rt22000 T4149 T4497 13337698.639885299
Rt22001 T4149 T4601 3146447.2356441831
Gcorr7707 T4149 T5613 T4149 T5613 -3.0420519833942338e-08
Rt22002 T4150 T5019 878301.5770656768
Gcorr7708 T4150 T5341 T4150 T5341 -7.5235832509859729e-08
Gcorr7709 T4150 T5619 T4150 T5619 -4.5006319617510198e-07
Rt22003 T4150 T5817 867275.79226487235
Gcorr7710 T4151 T4643 T4151 T4643 -1.3368215819588988e-07
Rt22004 T4151 T4645 6381386.9148998633
Gcorr7711 T4151 T4736 T4151 T4736 -9.190750865034215e-08
Rt22005 T4151 T5692 2146351.3082278329
Rt22006 T4152 T4939 7937579.7581625134
Rt22007 T4152 T5040 55152417.306960076
Rt22008 T4152 T5581 2217791.9967436423
Gcorr7712 T4152 T5906 T4152 T5906 -1.1786540640059212e-07
Gcorr7713 T4152 T6031 T4152 T6031 -8.5197757644258221e-08
Gcorr7714 T4153 T4703 T4153 T4703 -1.180356478775512e-07
Rt22009 T4153 T4731 23625209.361807704
Gcorr7715 T4153 T4836 T4153 T4836 -3.3899358269817449e-07
Gcorr7716 T4153 T5844 T4153 T5844 -2.1909553215089758e-07
Rt22010 T4153 T6063 833414.30883604032
Rt22011 T4154 T4731 87534349.6354381
Rt22012 T4154 T4732 2159578.6980878087
Rt22013 T4154 T4808 54512988.926422253
Rt22014 T4155 T5084 2860478.4535630979
Gcorr7717 T4155 T5086 T4155 T5086 -4.3477007032701137e-07
Rt22015 T4155 T5097 9735286.2625677157
Rt22016 T4155 T5631 3474397.7883260283
Rt22017 T4156 T4163 1777663.2928694752
Rt22018 T4156 T4526 2657246.5241928711
Gcorr7718 T4156 T4529 T4156 T4529 -1.4649035473491193e-07
Rt22019 T4156 T4530 4325086.284718317
Gcorr7719 T4156 T5718 T4156 T5718 -1.3140922444568955e-07
Rt22020 T4157 T4312 2755043.1275806404
Gcorr7720 T4157 T5297 T4157 T5297 -7.7259780452440492e-08
Rt22021 T4157 T5423 16305871.928830018
Gcorr7721 T4158 T4537 T4158 T4537 -1.1606708420626556e-07
Rt22022 T4158 T4539 4127110.6140080737
Rt22023 T4158 T4540 7111375.3681394663
Gcorr7722 T4158 T4541 T4158 T4541 -7.7539332500132698e-08
Gcorr7723 T4159 T4699 T4159 T4699 -8.1460022106293996e-08
Rt22024 T4159 T4701 13460818.445954328
Rt22025 T4159 T4715 3405009.1127656493
Rt22026 T4160 T4907 684307.48836551025
Gcorr7724 T4160 T5489 T4160 T5489 -4.8584675361225611e-07
Gcorr7725 T4160 T5490 T4160 T5490 -4.1341561477397512e-07
Gcorr7726 T4160 T5656 T4160 T5656 -2.1828084366854151e-07
Rt22027 T4161 T4942 5694332.4969948838
Rt22028 T4161 T5131 15443948.481906215
Rt22029 T4161 T5221 6210948.959228511
Rt22030 T4161 T5596 6555390.9522457821
Gcorr7727 T4161 T6079 T4161 T6079 -1.3591410572927927e-07
Gcorr7728 T4162 T4732 T4162 T4732 -7.6626783621593959e-08
Rt22031 T4162 T4809 659743.08721093996
Rt22032 T4162 T4872 16207782.480680017
Gcorr7729 T4162 T4873 T4162 T4873 -1.0604717280701561e-06
Rt22033 T4163 T4191 32679951.630151931
Gcorr7730 T4163 T4530 T4163 T4530 -2.9504424192134347e-07
Gcorr7731 T4163 T5436 T4163 T5436 -1.8483918509861794e-07
Rt22034 T4163 T5718 996288.27744762902
Gcorr7732 T4163 T5767 T4163 T5767 -2.5215659507744998e-07
Gcorr7733 T4164 T4908 T4164 T4908 -1.530818297758553e-07
Gcorr7734 T4164 T4909 T4164 T4909 -5.4493237152044877e-07
Rt22035 T4164 T4910 1150165.9175333418
Rt22036 T4164 T4912 8919915.8079525195
Rt22037 T4165 T4766 15247612.444613295
Rt22038 T4165 T5342 4534016.4273111718
Rt22039 T4165 T5691 3015403.0100063956
Gcorr7735 T4166 T5136 T4166 T5136 -4.7987709002309471e-08
Gcorr7736 T4166 T5410 T4166 T5410 -3.7006467904736989e-07
Rt22040 T4166 T5816 498018.51860052493
Gcorr7737 T4166 T6032 T4166 T6032 -6.1466502321008236e-07
Gcorr7738 T4167 T4980 T4167 T4980 -7.9193126077750405e-08
Rt22041 T4167 T5063 5940809.6604975993
Rt22042 T4167 T5143 6310696.3237674506
Gcorr7739 T4167 T5581 T4167 T5581 -6.4033541117687954e-08
Rt22043 T4168 T5259 3894315.8828196386
Rt22044 T4168 T5612 6687120.2159081465
Gcorr7740 T4168 T5639 T4168 T5639 -5.2544827258466359e-08
Gcorr7741 T4169 T4273 T4169 T4273 -3.1918237395538472e-07
Gcorr7742 T4169 T5525 T4169 T5525 -3.4943711281278389e-08
Rt22045 T4169 T5737 2525849.8351780279
Rt22046 T4169 T6014 3897272.1854776964
Rt22047 T4170 T4211 625300.07045987085
Rt22048 T4170 T5822 4536019.336141984
Gcorr7743 T4170 T5823 T4170 T5823 -2.4782074560362544e-07
Rt22049 T4170 T5949 2109839.3201244064
Rt22050 T4171 T4410 6968894.7465857156
Gcorr7744 T4171 T4425 T4171 T4425 -9.9517608341710044e-08
Rt22051 T4171 T5491 4976406.3993140562
Rt22052 T4172 T4640 5388048.7612983184
Rt22053 T4172 T4641 10915010.777014058
Rt22054 T4172 T4642 7538384.9246002221
Gcorr7745 T4172 T5050 T4172 T5050 -1.3563019160725913e-07
Gcorr7746 T4173 T4180 T4173 T4180 -6.2018718980959713e-08
Gcorr7747 T4173 T4883 T4173 T4883 -1.3085174389542671e-06
Rt22055 T4173 T4884 6076827.0599629302
Gcorr7748 T4173 T5700 T4173 T5700 -5.4763583007927023e-07
Rt22056 T4173 T5888 508791.45107748039
Rt22057 T4174 T4397 41533581.916306131
Rt22058 T4174 T4398 15886778.411620624
Rt22059 T4174 T4616 2633713.2939188159
Rt22060 T4175 T4223 26473855.373866193
Gcorr7749 T4175 T5367 T4175 T5367 -6.1907854362173329e-08
Rt22061 T4175 T6041 842535.62144005159
Gcorr7750 T4176 T4644 T4176 T4644 -2.3993239134907117e-07
Gcorr7751 T4176 T4645 T4176 T4645 -1.085482318555037e-07
Rt22062 T4176 T4646 1089635.7007907676
Gcorr7752 T4176 T5353 T4176 T5353 -2.8761079164920309e-07
Gcorr7753 T4177 T4720 T4177 T4720 -4.7139955978761786e-07
Gcorr7754 T4177 T5469 T4177 T5469 -1.4229450205904755e-07
Rt22063 T4177 T5470 8587432.4055742808
Rt22064 T4177 T5739 703830.17316606664
Gcorr7755 T4177 T5740 T4177 T5740 -1.5562432932650504e-07
Gcorr7756 T4177 T6079 T4177 T6079 -3.6615683747739042e-07
Gcorr7757 T4178 T4591 T4178 T4591 -6.847876566533617e-08
Rt22065 T4178 T4631 6478419.9369812878
Rt22066 T4178 T4691 5649176.8116717292
Rt22067 T4179 T4183 3445773.2368688555
Rt22068 T4179 T4315 6401985.4528038129
Rt22069 T4179 T4317 8655731.4052350707
Rt22070 T4179 T5257 12362071.428072959
Rt22071 T4180 T4883 3785777.9271272416
Gcorr7758 T4180 T5252 T4180 T5252 -3.1553173545426812e-08
Rt22072 T4180 T5863 45445550.622850217
Rt22073 T4181 T4619 3026168.5756149073
Rt22074 T4181 T4756 1338511.952152244
Rt22075 T4181 T5655 4712193.4936630446
Rt22076 T4182 T4354 4717118.9437649027
Gcorr7759 T4182 T4369 T4182 T4369 -8.2245443132271022e-08
Rt22077 T4182 T5169 8751425.7792159654
Rt22078 T4183 T4184 3689850.170742745
Rt22079 T4183 T5257 1655594.9210225644
Gcorr7760 T4183 T5909 T4183 T5909 -5.6223265103132384e-08
Rt22080 T4184 T5249 14820245.665680064
Rt22081 T4184 T5257 11582191.011252377
Rt22082 T4184 T5326 3542039.1884061997
Rt22083 T4184 T5969 2418473.5306828162
Gcorr7761 T4185 T4191 T4185 T4191 -6.2582787049431685e-09
Rt22084 T4185 T4520 6122461.745418055
Rt22085 T4185 T4592 1885220.6054774402
Gcorr7762 T4185 T5467 T4185 T5467 -4.2891626427673546e-07
Rt22086 T4186 T5263 1220448.5154605582
Rt22087 T4186 T5757 13214490.235435799
Gcorr7763 T4186 T5879 T4186 T5879 -6.7891618933585019e-07
Rt22088 T4186 T5890 1007796.1791170465
Rt22089 T4187 T4188 3803627.9177970886
Gcorr7764 T4187 T4331 T4187 T4331 -7.4043721060269562e-08
Rt22090 T4187 T4332 2570829.4386167014
Gcorr7765 T4187 T4333 T4187 T4333 -4.2579476184387604e-08
Rt22091 T4188 T4306 16034969.992511543
Rt22092 T4188 T4332 2523516.5597203542
Gcorr7766 T4188 T4473 T4188 T4473 -1.1986416765188417e-07
Rt22093 T4188 T5728 5381256.237770441
Gcorr7767 T4189 T4464 T4189 T4464 -9.8559351073646595e-08
Rt22094 T4189 T4605 2650469.5263153547
Gcorr7768 T4189 T4666 T4189 T4666 -1.2385776026551457e-07
Rt22095 T4189 T5545 11057982.785365852
Rt22096 T4190 T4220 738412.72540757619
Rt22097 T4190 T5348 11592313.056411697
Gcorr7769 T4190 T5675 T4190 T5675 -9.9700745917128552e-08
Gcorr7770 T4191 T4522 T4191 T4522 -1.3577903423719591e-07
Gcorr7771 T4191 T4592 T4191 T4592 -1.8142961117743855e-07
Gcorr7772 T4191 T5380 T4191 T5380 -2.1488272366004699e-07
Rt22098 T4191 T5767 1092501.1580549127
Rt22099 T4192 T5173 3212112.7417450133
Gcorr7773 T4192 T5174 T4192 T5174 -7.8514890639526561e-08
Rt22100 T4192 T5175 8009241.9795290269
Gcorr7774 T4192 T5704 T4192 T5704 -1.174312586539829e-07
Rt22101 T4193 T4671 1053631.7885605237
Gcorr7775 T4193 T4682 T4193 T4682 -4.100145090079322e-07
Gcorr7776 T4193 T5719 T4193 T5719 -3.2319932417157761e-07
Gcorr7777 T4194 T5154 T4194 T5154 -1.0730235636802696e-07
Gcorr7778 T4194 T5579 T4194 T5579 -2.303771599966053e-07
Rt22102 T4194 T5618 756073.26508225698
Gcorr7779 T4194 T5867 T4194 T5867 -5.4020049413837524e-07
Gcorr7780 T4195 T5089 T4195 T5089 -5.5412634125688979e-08
Gcorr7781 T4195 T5090 T4195 T5090 -1.5519996696571634e-08
Rt22103 T4195 T5091 3865329.5716393054
Gcorr7782 T4196 T4831 T4196 T4831 -1.6208168579271818e-07
Rt22104 T4196 T4840 4313017.1068175239
Rt22105 T4196 T4961 1601251.1380779056
Gcorr7783 T4196 T5134 T4196 T5134 -8.3052709145617615e-08
Gcorr7784 T4197 T4538 T4197 T4538 -7.3157964634741828e-09
Rt22106 T4197 T4743 7517420.8657047562
Rt22107 T4197 T5635 4738806.2178536411
Gcorr7785 T4198 T4210 T4198 T4210 -4.1422426903658588e-07
Rt22108 T4198 T5253 1057448.5865155926
Gcorr7786 T4198 T5771 T4198 T5771 -4.5457568679087387e-08
Rt22109 T4199 T5405 975417.23176426406
Gcorr7787 T4199 T6013 T4199 T6013 -7.4568036193528089e-07
Rt22110 T4200 T4207 11414137.485746108
Gcorr7788 T4201 T5266 T4201 T5266 -1.855142969919103e-07
Gcorr7789 T4202 T5376 T4202 T5376 -5.5669876383833875e-07
Rt22111 T4202 T6013 1431258.6992216657
Rt22112 T4203 T4226 11445102.492591435
Rt22113 T4204 T4227 8252941.9803368542
Gcorr7790 T4205 T5271 T4205 T5271 -2.6564171908814583e-07
Gcorr7791 T4206 T5275 T4206 T5275 -2.2889092941061369e-07
Gcorr7792 T4207 T5266 T4207 T5266 -1.5160385954196684e-07
Rt22114 T4207 T5351 6514790.7186847422
Rt22115 T4207 T5605 2206497.951565051
Rt22116 T4207 T5859 4652588.8492249073
Gcorr7793 T4208 T5183 T4208 T5183 -8.2302192447490087e-08
Gcorr7794 T4208 T5185 T4208 T5185 -7.9295808996978917e-08
Gcorr7795 T4208 T5564 T4208 T5564 -7.6040422644374789e-10
Gcorr7796 T4208 T5840 T4208 T5840 -5.8382269050009946e-08
Rt22117 T4208 T6044 746025.09897953307
Rt22118 T4209 T5275 5667940.2407622021
Gcorr7797 T4209 T5277 T4209 T5277 -1.9893095332323337e-08
Rt22119 T4209 T5278 6719195.4837954529
Rt22120 T4209 T5576 2225665.552768914
Gcorr7798 T4210 T5245 T4210 T5245 -4.3789072198805401e-08
Gcorr7799 T4210 T5301 T4210 T5301 -4.0855951715943845e-08
Rt22121 T4210 T5771 2631203.5692077042
Rt22122 T4210 T5996 618255.10267076071
Rt22123 T4211 T5822 36167609.841772109
Rt22124 T4211 T5823 3236644.4651198876
Rt22125 T4211 T5922 135118242.4948591
Rt22126 T4211 T5949 183895500.16160628
Gcorr7800 T4212 T5205 T4212 T5205 -1.7249066830039271e-07
Gcorr7801 T4212 T5263 T4212 T5263 -8.3800340004398442e-08
Gcorr7802 T4212 T5703 T4212 T5703 -3.8451918362412377e-08
Rt22127 T4212 T5872 3609706.4857517132
Rt22128 T4212 T5879 6548122.8654407803
Gcorr7803 T4212 T5902 T4212 T5902 -7.0404098470950833e-08
Rt22129 T4213 T5162 22622121.198212653
Rt22130 T4213 T5616 1208985.0708438253
Gcorr7804 T4213 T5804 T4213 T5804 -3.1119626127358473e-07
Rt22131 T4213 T5954 18533248.311188851
Rt22132 T4213 T6011 1575374.949467299
Gcorr7805 T4214 T5271 T4214 T5271 -6.1802004697769649e-08
Rt22133 T4214 T5272 13834834.03244712
Rt22134 T4214 T5367 3866856.1013228204
Rt22135 T4214 T5706 1511996.3424779926
Gcorr7806 T4215 T5339 T4215 T5339 -3.3658560481524138e-08
Gcorr7807 T4215 T5687 T4215 T5687 -5.3150626834002408e-08
Rt22136 T4215 T5926 1699708.5509980365
Rt22137 T4215 T5930 7451686.4435208328
Rt22138 T4215 T5989 1666029.6566590995
Gcorr7808 T4216 T5296 T4216 T5296 -1.4375146063978395e-07
Gcorr7809 T4216 T5343 T4216 T5343 -1.3712819437755818e-07
Rt22139 T4216 T5643 5537521.2391107818
Rt22140 T4216 T6033 2602746.0152275381
Gcorr7810 T4217 T5335 T4217 T5335 -1.3950927229361112e-07
Gcorr7811 T4217 T5910 T4217 T5910 -3.1943627121423452e-08
Rt22141 T4217 T5953 4845704.5208394062
Rt22142 T4217 T6010 4387673.4905279242
Gcorr7812 T4217 T6012 T4217 T6012 -1.0505725419317345e-07
Gcorr7813 T4218 T5289 T4218 T5289 -1.6817574042475594e-07
Gcorr7814 T4218 T5640 T4218 T5640 -1.2548035002992581e-07
Rt22143 T4218 T5641 4794233.4020311609
Rt22144 T4218 T5642 6323047.5610029297
Rt22145 T4218 T6053 1860649.2733581807
Rt22146 T4219 T5321 8537691.1115048267
Rt22147 T4219 T5329 8100485.89649795
Gcorr7815 T4219 T5330 T4219 T5330 -2.0268664387676115e-07
Rt22148 T4219 T5759 3528915.0637703994
Gcorr7816 T4219 T5777 T4219 T5777 -8.1164781557077276e-08
Gcorr7817 T4220 T5214 T4220 T5214 -1.3441104452129266e-07
Gcorr7818 T4220 T5348 T4220 T5348 -6.7698757232951525e-08
Rt22149 T4220 T5675 3916325.6150942799
Gcorr7819 T4220 T5826 T4220 T5826 -1.5123331417023275e-07
Rt22150 T4220 T5827 2531299.8351961151
Rt22151 T4221 T5341 12099934.460947812
Gcorr7820 T4221 T5754 T4221 T5754 -6.5485794566991893e-08
Rt22152 T4221 T5815 3178266.6357204514
Rt22153 T4221 T5986 396559.63888626307
Rt22154 T4221 T6061 1918311.1377853737
Gcorr7821 T4222 T5291 T4222 T5291 -2.161166389167592e-07
Rt22155 T4222 T5293 1788766.0125413339
Gcorr7822 T4222 T5377 T4222 T5377 -1.1646076931174467e-07
Rt22156 T4222 T5753 310544.03614655457
Rt22157 T4223 T5798 3917248.3043334275
Rt22158 T4223 T5828 1816549.0685775399
Rt22159 T4223 T5829 4208427.0330129294
Rt22160 T4223 T6041 16776878.011985455
Gcorr7823 T4224 T5171 T4224 T5171 -1.175912305927954e-07
Rt22161 T4224 T5835 2656469.6427334324
Rt22162 T4224 T5870 3639162.4175413763
Rt22163 T4224 T5912 2672828.9952222714
Gcorr7824 T4225 T5253 T4225 T5253 -6.7603751122964366e-08
Rt22164 T4225 T5368 2615515.7920374894
Rt22165 T4225 T5602 4448759.836141482
Gcorr7825 T4225 T5907 T4225 T5907 -1.0689493342588586e-08
Rt22166 T4225 T6036 1547671.4769709755
Rt22167 T4226 T5266 5858737.2900372334
Gcorr7826 T4226 T5271 T4226 T5271 -1.2311579113949702e-07
Rt22168 T4226 T5381 6858122.2132601663
Rt22169 T4226 T5383 924832.23275920784
Gcorr7827 T4226 T5819 T4226 T5819 -2.4609946677552589e-08
Gcorr7828 T4227 T5276 T4227 T5276 -3.8295272877197743e-08
Rt22170 T4227 T5376 1106110.7260546102
Rt22171 T4227 T5782 2568815.0296817138
Rt22172 T4227 T6083 543758.5976626781
Gcorr7829 T4228 T5296 T4228 T5296 -6.0572369431654736e-08
Rt22173 T4228 T5315 3487946.9672627477
Gcorr7830 T4228 T5340 T4228 T5340 -2.8929776762738683e-08
Rt22174 T4228 T5852 3509131.66331119
Rt22175 T4229 T5403 4144063.2049209978
Gcorr7831 T4229 T5404 T4229 T5404 -2.1908792089301504e-07
Rt22176 T4229 T5799 762495.22736516909
Rt22177 T4229 T5891 850883.9388434533
Rt22178 T4230 T5280 4122826.2939424966
Rt22179 T4230 T5281 12637987.968738642
Rt22180 T4230 T5282 10078367.25651516
Rt22181 T4230 T5292 3774904.3589210371
Gcorr7832 T4230 T6086 T4230 T6086 -1.6602135523535164e-07
Gcorr7833 T4231 T4237 T4231 T4237 -2.3267708153419206e-07
Rt22182 T4231 T4239 13835713.599493293
Rt22183 T4231 T4240 4996500.4163108598
Gcorr7834 T4231 T5200 T4231 T5200 -7.102718639429805e-08
Gcorr7835 T4232 T5625 T4232 T5625 -8.2790073853797633e-08
Rt22184 T4232 T5711 3162423.8049298231
Gcorr7836 T4232 T5913 T4232 T5913 -3.2678248320028056e-08
Rt22185 T4232 T5971 1021158.4891136563
Gcorr7837 T4233 T5309 T4233 T5309 -2.9464255135807856e-07
Rt22186 T4233 T5411 3450651.9886131049
Gcorr7838 T4233 T5435 T4233 T5435 -4.1004078601692613e-09
Rt22187 T4233 T5714 1696708.0427058327
Gcorr7839 T4233 T6074 T4233 T6074 -1.3604447873948251e-07
Gcorr7840 T4234 T5315 T4234 T5315 -2.9984173139402802e-07
Gcorr7841 T4234 T5860 T4234 T5860 -9.916810619753509e-08
Rt22188 T4234 T5946 2464872.6502705999
Rt22189 T4234 T5975 5722287.6595800798
Rt22190 T4234 T6038 5387695.5100115556
Gcorr7842 T4235 T5291 T4235 T5291 -1.3565036424801334e-07
Rt22191 T4235 T5608 1786429.0842464319
Rt22192 T4235 T5843 1991811.7106697485
Rt22193 T4235 T5887 1131707.5018256106
Gcorr7843 T4236 T5317 T4236 T5317 -2.2952718447389463e-07
Gcorr7844 T4236 T5625 T4236 T5625 -6.6404636218254921e-09
Rt22194 T4236 T5786 1860175.8961537825
Rt22195 T4236 T5798 6014068.3099633409
Rt22196 T4236 T6000 3353034.9220509622
Rt22197 T4237 T4239 15817506.418273089
Rt22198 T4237 T5986 22943386.017990839
Rt22199 T4237 T6029 666071.56613948557
Rt22200 T4238 T5623 1780448.1792739106
Rt22201 T4238 T5815 21166562.011914156
Gcorr7845 T4238 T5833 T4238 T5833 -6.9452065823284158e-08
Rt22202 T4238 T5900 2995280.8591323704
Rt22203 T4238 T5986 6783566.681729028
Rt22204 T4238 T6029 17616327.167438515
Rt22205 T4239 T4240 17807519.062910572
Rt22206 T4239 T4241 9658778.5890224501
Gcorr7846 T4239 T5219 T4239 T5219 -3.445765287065105e-08
Rt22207 T4239 T5623 4947561.1038768413
Rt22208 T4239 T6029 23772084.381640438
Rt22209 T4240 T4241 6616334.7934162626
Rt22210 T4240 T4242 4181728.6030051592
Rt22211 T4240 T5200 5558858.2309642546
Rt22212 T4240 T5810 3128027.1066170884
Rt22213 T4241 T4242 6416319.9214697471
Rt22214 T4241 T4243 7215160.4035716159
Rt22215 T4241 T4244 4811336.5864091385
Rt22216 T4241 T5219 1216092.2265998977
Rt22217 T4242 T4243 7069625.4914901583
Rt22218 T4242 T4898 5084480.1269740285
Rt22219 T4242 T5196 4175702.0054055275
Rt22220 T4242 T5810 27493802.46893971
Rt22221 T4243 T4244 5981967.7481589084
Rt22222 T4243 T4245 14694823.526251359
Rt22223 T4243 T4898 5476352.5460585486
Rt22224 T4243 T5595 4370127.2381132906
Gcorr7847 T4243 T5967 T4243 T5967 -3.2798557397077911e-08
Rt22225 T4244 T4245 5185399.6084361644
Rt22226 T4244 T4246 3983136.0585554163
Rt22227 T4244 T5219 5991613.217675372
Rt22228 T4244 T5651 9236436.7924049348
Rt22229 T4245 T4246 4638367.1479921518
Rt22230 T4245 T4247 10171206.292790901
Rt22231 T4245 T4746 4269556.7036186969
Rt22232 T4245 T5595 3215106.0748890783
Rt22233 T4246 T4247 4307184.9127741093
Rt22234 T4246 T4248 10526187.017775621
Rt22235 T4246 T4694 3484269.7360481909
Rt22236 T4246 T5651 6081191.3098818511
Rt22237 T4247 T4248 4235698.4703627517
Rt22238 T4247 T4249 7504148.214383116
Rt22239 T4247 T4746 3452578.0313919769
Rt22240 T4247 T5567 7169811.5799283776
Rt22241 T4248 T4249 4160935.2684778553
Rt22242 T4248 T4250 10852015.030355761
Rt22243 T4248 T4694 3992835.5915545006
Rt22244 T4248 T5563 4230325.2486658283
Rt22245 T4249 T4250 4408920.4679667009
Rt22246 T4249 T4251 5059422.9994169157
Rt22247 T4249 T4430 8240334.7130279848
Rt22248 T4249 T5567 7971145.2802548846
Rt22249 T4250 T4251 4324243.9021920348
Rt22250 T4250 T4252 10649620.654066119
Rt22251 T4250 T4422 4349114.2088224506
Rt22252 T4250 T5563 4048281.2160529755
Rt22253 T4251 T4252 3832895.406246216
Rt22254 T4251 T4253 1777873.15752423
Rt22255 T4251 T4430 1949620.6195769701
Rt22256 T4251 T5521 1951534.8429140509
Rt22257 T4252 T4253 10761621.911861841
Rt22258 T4252 T4254 10700740.074711507
Rt22259 T4252 T4422 4401072.1948120845
Rt22260 T4252 T5512 4035547.8404275542
Rt22261 T4253 T4254 4019918.8388458067
Rt22262 T4253 T4255 10509401.842386937
Rt22263 T4253 T5496 4862107.4841552107
Rt22264 T4253 T5521 10245134.262531709
Rt22265 T4254 T4255 4208254.0946005443
Rt22266 T4254 T4256 10557183.381825468
Rt22267 T4254 T5492 3961090.8657898521
Rt22268 T4254 T5512 4172827.6347405282
Rt22269 T4255 T4256 3951857.5638952628
Rt22270 T4255 T4257 10337895.443441963
Rt22271 T4255 T4428 4222852.9445609199
Rt22272 T4255 T5496 4013188.4286275101
Rt22273 T4256 T4257 4226339.3092766227
Rt22274 T4256 T4258 4162578.5138662779
Rt22275 T4256 T4259 4018263.3502280586
Rt22276 T4256 T5492 4200587.3432899332
Rt22277 T4257 T4258 3991278.9126814958
Rt22278 T4257 T4428 3955726.7621984826
Rt22279 T4257 T4907 4235293.0389312655
Rt22280 T4257 T5489 4176744.1764089689
Rt22281 T4258 T4259 10493633.442075344
Rt22282 T4258 T4260 4062046.710765447
Rt22283 T4258 T4261 4165521.1202213671
Rt22284 T4258 T5489 10263445.530335264
Rt22285 T4259 T4260 4153252.9501228216
Rt22286 T4259 T4748 4084632.571467259
Rt22287 T4259 T4842 10670365.316109281
Rt22288 T4259 T5492 4137188.8998949276
Rt22289 T4260 T4261 10386630.488447046
Rt22290 T4260 T4262 4591229.922520251
Rt22291 T4260 T4748 10534219.336369645
Rt22292 T4260 T5458 4621377.175934067
Rt22293 T4261 T4262 3786984.6439947416
Rt22294 T4261 T4263 9384794.5515041742
Rt22295 T4261 T5489 4113740.2955820747
Rt22296 T4261 T5661 9797883.4027544726
Rt22297 T4262 T4263 3678363.0774526708
Rt22298 T4262 T4264 11256197.523050314
Rt22299 T4262 T4273 1891143.164384485
Rt22300 T4262 T5458 9939173.4578252025
Rt22301 T4263 T4264 4050019.3174696746
Rt22302 T4263 T4265 2801161.1477949326
Rt22303 T4263 T4277 19399232.859088659
Rt22304 T4263 T5661 4149936.84768944
Rt22305 T4264 T4265 9293000.5091544371
Rt22306 T4264 T4266 5089360.9151202952
Rt22307 T4264 T4273 4233507.8827535417
Rt22308 T4264 T5688 7116858.6882655434
Rt22309 T4265 T4266 9615236.8763644136
Rt22310 T4265 T4267 842898.89323033148
Rt22311 T4265 T4277 2459383.8520734445
Rt22312 T4265 T5864 18112778.199849598
Rt22313 T4266 T4267 1013406.6923340594
Rt22314 T4266 T4268 12101058.123668842
Rt22315 T4266 T5246 15192320.093688957
Rt22316 T4266 T5688 2055068.6867870241
Gcorr7848 T4266 T6037 T4266 T6037 -5.865397522792016e-08
Rt22317 T4267 T4268 3447550.7638613475
Rt22318 T4267 T4269 11052373.017344816
Rt22319 T4267 T4816 25053188.73
Rt22320 T4267 T5864 1404908.4551702053
Rt22321 T4268 T4269 5244546.7886243863
Rt22322 T4268 T4270 3087847.8063329849
Rt22323 T4268 T6037 549781.59900136781
Rt22324 T4269 T4270 4522869.0412071813
Rt22325 T4269 T4271 5223174.4180820398
Rt22326 T4269 T4816 4840457.8787386576
Rt22327 T4269 T5915 34842161.49049136
Gcorr7849 T4270 T4271 T4270 T4271 -1.9061315957435009e-08
Rt22328 T4270 T4272 3240678.0316869565
Rt22329 T4270 T4274 51664260.033374988
Rt22330 T4270 T5624 6599595.7538642762
Gcorr7850 T4270 T6037 T4270 T6037 -9.6668905474448833e-08
Rt22331 T4271 T4272 3113026.1852617562
Rt22332 T4271 T4275 8531372.6434839498
Gcorr7851 T4271 T4466 T4271 T4466 -1.3598551410305995e-07
Rt22333 T4271 T5915 3099125.192531059
Rt22334 T4272 T4275 7043120.6984581817
Rt22335 T4272 T4276 4631788.7873208923
Rt22336 T4272 T5624 6788640.7237449065
Rt22337 T4272 T5789 1905296.4483503927
Rt22338 T4273 T5458 3316746.9705033367
Rt22339 T4273 T5688 12428937.123167776
Rt22340 T4273 T5737 3133057.0455884379
Rt22341 T4273 T6014 1798699.3352910015
Rt22342 T4274 T5624 8440169.190677179
Rt22343 T4274 T5671 3343837.0077137356
Rt22344 T4274 T5856 6050951.7094802819
Rt22345 T4274 T5958 8014276.0950955069
Rt22346 T4274 T6037 1913714.8106891275
Rt22347 T4275 T4276 6620067.7264911663
Gcorr7852 T4275 T4278 T4275 T4278 -1.8642757853376582e-07
Rt22348 T4275 T4466 5193784.3090642812
Rt22349 T4275 T5865 2346010.6079510278
Rt22350 T4276 T4278 4587191.89778555
Rt22351 T4276 T4279 4989916.6679325718
Rt22352 T4276 T4280 6498860.0544893881
Rt22353 T4276 T5789 3719238.1398844267
Gcorr7853 T4277 T5490 T4277 T5490 -2.971865900437333e-08
Rt22354 T4277 T5657 14783825.472948613
Rt22355 T4277 T5658 3031352.2154374793
Rt22356 T4277 T5661 1766035.5501590886
Rt22357 T4277 T5864 11829759.342779912
Gcorr7854 T4278 T4279 T4278 T4279 -2.275339929783869e-07
Gcorr7855 T4278 T5366 T4278 T5366 -2.5154912155840651e-07
Gcorr7856 T4278 T5582 T4278 T5582 -2.7817046458489959e-07
Rt22358 T4278 T5805 2430254.8930474985
Rt22359 T4278 T5865 13739296.289889727
Gcorr7857 T4279 T4280 T4279 T4280 -1.2832879662061152e-08
Gcorr7858 T4279 T4281 T4279 T4281 -2.4980916984734576e-07
Rt22360 T4279 T5211 2248836.0008884557
Rt22361 T4279 T5582 3265994.0745178605
Rt22362 T4280 T4281 7301521.0818160912
Rt22363 T4280 T4282 2943727.0419615512
Rt22364 T4280 T5337 7787905.8215142023
Rt22365 T4280 T5338 12258644.419521095
Gcorr7859 T4280 T5789 T4280 T5789 -3.2477066136652315e-07
Gcorr7860 T4281 T4282 T4281 T4282 -2.6648769173301198e-07
Rt22366 T4281 T4283 8725524.2770605832
Gcorr7861 T4281 T4295 T4281 T4295 -4.5280908106112321e-08
Rt22367 T4281 T5211 2005503.245693238
Gcorr7862 T4282 T4283 T4282 T4283 -2.43274118459968e-09
Rt22368 T4282 T4284 10070615.951846564
Gcorr7863 T4282 T5336 T4282 T5336 -2.4983212825492917e-07
Rt22369 T4282 T5337 8629114.5839894004
Gcorr7864 T4283 T4284 T4283 T4284 -2.5035316675734032e-07
Rt22370 T4283 T4285 16606087.827401491
Gcorr7865 T4283 T4295 T4283 T4295 -2.4359021312092015e-07
Rt22371 T4283 T5322 28113562.967223369
Rt22372 T4284 T4285 4456665.8176781842
Rt22373 T4284 T4286 6531142.6330627138
Rt22374 T4284 T4299 67368058.030455664
Rt22375 T4284 T5336 7956055.5536311874
Gcorr7866 T4285 T4286 T4285 T4286 -2.4093863555884329e-07
Rt22376 T4285 T4287 4301144.5950849671
Gcorr7867 T4285 T5322 T4285 T5322 -9.4115499406500617e-08
Rt22377 T4285 T5429 564489.11688725359
Rt22378 T4286 T4287 175961347.07917395
Rt22379 T4286 T4288 6108343.470318283
Rt22380 T4286 T4299 492655591.99891967
Gcorr7868 T4286 T5358 T4286 T5358 -2.3712176941753796e-07
Gcorr7869 T4287 T4288 T4287 T4288 -3.1613819052821384e-07
Rt22381 T4287 T4289 17714080.501408566
Gcorr7870 T4287 T5429 T4287 T5429 -4.0423860077949941e-07
Gcorr7871 T4287 T5764 T4287 T5764 -3.2028707345202521e-07
Rt22382 T4287 T6052 1851663.0046007864
Gcorr7872 T4288 T4289 T4288 T4289 -3.5375233993312979e-08
Rt22383 T4288 T4290 8617973.2300709672
Gcorr7873 T4288 T5358 T4288 T5358 -2.3602798965593153e-08
Gcorr7874 T4288 T5359 T4288 T5359 -2.9848309838870689e-07
Gcorr7875 T4289 T4290 T4289 T4290 -3.4316876438216373e-07
Rt22384 T4289 T4291 10736394.314394329
Gcorr7876 T4289 T5452 T4289 T5452 -2.2131160445138392e-08
Gcorr7877 T4289 T5764 T4289 T5764 -2.2477673752672876e-07
Rt22385 T4290 T4291 24661121.434464902
Rt22386 T4290 T4292 11183160.289270462
Rt22387 T4290 T5359 10645895.86028341
Gcorr7878 T4290 T5386 T4290 T5386 -2.863933306766768e-07
Gcorr7879 T4291 T4292 T4291 T4292 -3.2240766918561864e-07
Rt22388 T4291 T4293 11943903.522978289
Rt22389 T4291 T4294 17056546.33754145
Gcorr7880 T4291 T5452 T4291 T5452 -3.0155064574333389e-07
Rt22390 T4292 T4293 480567.91738469404
Gcorr7881 T4292 T4296 T4292 T4296 -2.9091305241429018e-07
Gcorr7882 T4292 T4298 T4292 T4298 -4.0670574023902288e-09
Rt22391 T4292 T5386 91959047.282305717
Gcorr7883 T4293 T4294 T4293 T4294 -2.276180470966314e-07
Gcorr7884 T4293 T4296 T4293 T4296 -4.8820690379727939e-08
Rt22392 T4293 T4297 123151449.37850486
Gcorr7885 T4293 T5770 T4293 T5770 -1.0581913103920272e-07
Rt22393 T4293 T6034 1477796.0980733216
Rt22394 T4294 T5452 5548891.1850377284
Gcorr7886 T4294 T5765 T4294 T5765 -2.1078872111024027e-07
Rt22395 T4294 T5770 809826.89845046401
Rt22396 T4294 T6019 16006693.673899706
Gcorr7887 T4295 T5211 T4295 T5211 -1.7779773538742827e-08
Rt22397 T4295 T5322 13234640.649675885
Gcorr7888 T4295 T5347 T4295 T5347 -9.341668443318296e-08
Rt22398 T4295 T5627 1839571.0262581657
Gcorr7889 T4295 T5905 T4295 T5905 -7.4834609483441003e-08
Gcorr7890 T4296 T4297 T4296 T4297 -1.3633789963358929e-07
Rt22399 T4296 T4298 4539092.2594927922
Rt22400 T4296 T4300 123732640.85147922
Rt22401 T4296 T5120 6923811.5303499056
Gcorr7891 T4297 T4300 T4297 T4300 -1.8571815499348185e-07
Rt22402 T4297 T4301 459073405.16499823
Rt22403 T4297 T5634 5010043.0617968123
Rt22404 T4297 T6034 25985086.729693621
Gcorr7892 T4298 T5120 T4298 T5120 -2.9725993825098776e-07
Gcorr7893 T4298 T5386 T4298 T5386 -2.7039566383327208e-07
Rt22405 T4298 T5693 7724791.5710728047
Rt22406 T4298 T5751 1707961.9483131792
Gcorr7894 T4299 T5336 T4299 T5336 -1.2868068021606025e-07
Gcorr7895 T4299 T5358 T4299 T5358 -3.6180432363936774e-08
Rt22407 T4299 T5945 2867942.4511466371
Rt22408 T4299 T6006 1633287.574205948
Rt22409 T4300 T4301 8878295.5773069318
Rt22410 T4300 T4302 11519056.860618398
Gcorr7896 T4300 T5120 T4300 T5120 -2.8138955641479541e-07
Gcorr7897 T4300 T5306 T4300 T5306 -2.8396011165034045e-08
Rt22411 T4300 T5987 1180916.2241078797
Rt22412 T4301 T4302 14345066.35367766
Rt22413 T4301 T4303 5260438.9382276451
Rt22414 T4301 T4304 5045373.1099963877
Rt22415 T4301 T5634 3633911.6275727251
Gcorr7898 T4302 T4303 T4302 T4303 -4.5232729342792972e-09
Rt22416 T4302 T4305 3620851.4278710075
Rt22417 T4302 T4306 13186652.220577845
Rt22418 T4302 T5306 1823891.7802487093
Rt22419 T4303 T4304 6337093.1736315796
Rt22420 T4303 T4305 3748771535.5927486
Rt22421 T4303 T4307 45326387.612409346
Rt22422 T4303 T5208 2974571.76867668
Rt22423 T4303 T6017 2635056.0448226631
Rt22424 T4304 T4307 4198558.6926540406
Rt22425 T4304 T4308 21199054.8355802
Rt22426 T4304 T4735 3692261.520718317
Gcorr7899 T4304 T5634 T4304 T5634 -6.4482064201448762e-08
Rt22427 T4305 T4306 4901304.4075564966
Rt22428 T4305 T4331 21932656.971985556
Rt22429 T4305 T5255 5481252.5361738857
Rt22430 T4305 T6017 1168660.0277077944
Rt22431 T4306 T4331 6158754.0024741059
Rt22432 T4306 T4332 6078140.9323147442
Rt22433 T4306 T5306 5233202.6214318871
Rt22434 T4306 T5728 4539594.1892735716
Rt22435 T4307 T4308 4360778.7164510759
Rt22436 T4307 T4309 20539806.690422852
Rt22437 T4307 T5208 4608969.9569334826
Rt22438 T4307 T5360 5047603.4401523042
Rt22439 T4307 T5943 7238852.4930332368
Rt22440 T4308 T4309 5434313.3687053109
Rt22441 T4308 T4310 16306638.452620612
Rt22442 T4308 T4735 7403716.3373020021
Rt22443 T4308 T5909 3982806.3809952592
Rt22444 T4309 T4310 4878719.9884009855
Rt22445 T4309 T4311 13343242.69254614
Rt22446 T4309 T4313 4761186.1672450323
Rt22447 T4309 T5943 1937571.5678291291
Rt22448 T4310 T4311 4851197.2969254404
Rt22449 T4310 T4312 4229560.0155872246
Rt22450 T4310 T4315 4490557.5601591803
Rt22451 T4310 T5909 3724345.7813219661
Rt22452 T4311 T4312 11430362.398195248
Rt22453 T4311 T4313 4303089.7239936972
Rt22454 T4311 T4314 4408187.3018847238
Rt22455 T4311 T5423 4967729.7068869639
Rt22456 T4312 T4315 4880233.3821013244
Rt22457 T4312 T4316 4907690.8700196221
Rt22458 T4312 T5297 6157793.9766176427
Rt22459 T4312 T5423 4452720.3087938437
Rt22460 T4313 T4314 1748185.6509505305
Rt22461 T4313 T4336 3891428.6276224819
Rt22462 T4313 T4729 3065360.1097992337
Rt22463 T4313 T5943 1456884.3571002581
Rt22464 T4314 T4336 10573699.060068673
Rt22465 T4314 T4339 4561124.9837656906
Rt22466 T4314 T4815 8928722.0159825031
Rt22467 T4314 T5423 5370881.1896769386
Rt22468 T4315 T4316 3861563.3266129689
Rt22469 T4315 T4317 4715333.0881241821
Rt22470 T4315 T5257 6058012.8401248576
Rt22471 T4315 T5909 9944677.7854884546
Rt22472 T4316 T4317 11994734.703614337
Rt22473 T4316 T4318 5427586.1629626974
Rt22474 T4316 T4319 11195368.61971158
Rt22475 T4316 T5297 4987346.4275291488
Rt22476 T4317 T4318 3938995.113835881
Rt22477 T4317 T5257 5439994.4422884667
Rt22478 T4317 T5326 37660174.618755147
Rt22479 T4317 T5746 2612955.8127593123
Rt22480 T4318 T4319 4607175.6197544821
Rt22481 T4318 T4320 4061304.1093610078
Rt22482 T4318 T4321 1741314.2545115442
Rt22483 T4318 T5746 11382323.619690526
Rt22484 T4319 T4320 4785073.7934587374
Rt22485 T4319 T5297 4080245.6305089826
Rt22486 T4319 T5727 3835058.8227692256
Rt22487 T4319 T5871 4809117.0168382917
Rt22488 T4320 T4321 9918892.4985426478
Rt22489 T4320 T4322 457470.74739263253
Rt22490 T4320 T4342 12303512.068768704
Rt22491 T4320 T5727 4175477.2103641015
Rt22492 T4321 T4322 5533396.0336637944
Rt22493 T4321 T4323 3678994.3585709245
Rt22494 T4321 T4689 3023461.2447628174
Rt22495 T4321 T5746 19771208.027175479
Rt22496 T4322 T4323 3633610.1489120955
Rt22497 T4322 T4324 3925983.4166625217
Rt22498 T4322 T4342 4659567.277924669
Rt22499 T4322 T5382 4975003.0058798613
Rt22500 T4323 T4324 11241687.761925358
Rt22501 T4323 T4325 11196812.087692317
Rt22502 T4323 T4689 12271304.855053274
Rt22503 T4323 T5730 3630003.5434119767
Rt22504 T4324 T4325 4021339.9659348004
Rt22505 T4324 T4326 4072193.2044868828
Rt22506 T4324 T5382 3689374.547319347
Rt22507 T4324 T5422 9721603.123802172
Rt22508 T4325 T4326 9317117.7872925121
Rt22509 T4325 T4327 9515712.488433307
Rt22510 T4325 T5730 3744475.8178180004
Rt22511 T4325 T5811 3320281.013637498
Rt22512 T4326 T4327 1474642.2648567292
Rt22513 T4326 T4328 3274384.2485264493
Rt22514 T4326 T4330 1237788.2577697872
Rt22515 T4326 T5422 4802151.60526691
Rt22516 T4327 T4328 9809823.8153368458
Rt22517 T4327 T4329 4477781.3500439674
Rt22518 T4327 T4345 8414132.1605154574
Rt22519 T4327 T5811 1823437.0109611659
Rt22520 T4328 T4329 1581826.5342467634
Rt22521 T4328 T4330 9666144.0934320539
Rt22522 T4328 T4340 4580967.5924629569
Rt22523 T4328 T5553 4557150.2920568297
Rt22524 T4329 T4345 3709356.9363215198
Rt22525 T4329 T4346 10297291.579123035
Rt22526 T4329 T5365 4422503.6843538601
Rt22527 T4329 T5553 9502188.7362065129
Rt22528 T4330 T4340 3155518.8468207545
Rt22529 T4330 T4341 4238389.1518971967
Rt22530 T4330 T5422 11271174.381279491
Rt22531 T4330 T5514 4453019.8077402692
Rt22532 T4331 T4332 6432418.0302345427
Rt22533 T4331 T4333 6585144.3057273729
Rt22534 T4331 T4335 4360120.7586184805
Rt22535 T4331 T5255 5326282.4794794405
Rt22536 T4332 T4333 5240431.9252473982
Rt22537 T4332 T4334 4801734.7160546556
Rt22538 T4332 T4473 4237550.1937741544
Rt22539 T4332 T5728 12334712.725561816
Rt22540 T4333 T4334 12635445.891049694
Rt22541 T4333 T4335 4845901.1264309566
Rt22542 T4333 T4337 10078295.901043614
Rt22543 T4333 T5325 3959528.3699924783
Rt22544 T4334 T4473 4434353.3814698644
Rt22545 T4334 T4474 3155191.4257269218
Rt22546 T4334 T5264 10286287.225810593
Rt22547 T4334 T5325 4683918.1831920445
Rt22548 T4335 T4337 3328888.0810044003
Rt22549 T4335 T4338 8956438.4632725511
Rt22550 T4335 T5255 91948444.580326453
Rt22551 T4335 T5413 1616984.8443949772
Rt22552 T4336 T4339 4857972.091613234
Rt22553 T4336 T4348 10584276.104783142
Rt22554 T4336 T4729 5151476.7612921055
Rt22555 T4336 T5550 4806809.6337489607
Rt22556 T4337 T4338 4821302.8290154859
Rt22557 T4337 T4343 4838890.6705630813
Rt22558 T4337 T5325 4587910.6963128792
Rt22559 T4337 T5604 10022860.386552768
Rt22560 T4338 T4343 4805561.2436638493
Rt22561 T4338 T4347 3297998.7537317704
Rt22562 T4338 T4635 9411465.4411380757
Rt22563 T4338 T5413 5188506.6272581518
Rt22564 T4339 T4348 4271769.9718988845
Rt22565 T4339 T4349 1302256.5900637754
Rt22566 T4339 T4815 1492666.6107028332
Rt22567 T4339 T5539 2457213.3713277844
Rt22568 T4340 T4341 9581500.0981257968
Rt22569 T4340 T4344 4245143.8813373148
Rt22570 T4340 T5507 8514700.2903230023
Rt22571 T4340 T5553 4669601.5200888654
Rt22572 T4341 T4344 4792569.2473507235
Rt22573 T4341 T4426 5074614.5130000105
Rt22574 T4341 T4587 4677457.6489523714
Rt22575 T4341 T5514 10606580.629535032
Rt22576 T4342 T5382 5422262.833429127
Rt22577 T4342 T5628 6277728.7340567578
Rt22578 T4342 T5727 4295685.5054314053
Rt22579 T4342 T5849 3769162.114635177
Rt22580 T4343 T4347 9769461.5150978025
Rt22581 T4343 T4350 4339011.5079726763
Rt22582 T4343 T4351 10089412.527139518
Rt22583 T4343 T5604 3262284.9982917812
Rt22584 T4344 T4426 4959651.9696018044
Rt22585 T4344 T4427 9781700.8541560359
Rt22586 T4344 T4654 5199430.0484228674
Rt22587 T4344 T5507 3563939.0433726865
Rt22588 T4345 T4346 9410383.9616135377
Rt22589 T4345 T4352 1053617.1102973861
Rt22590 T4345 T4949 9745888.3215490766
Rt22591 T4345 T5811 7738279.2825153461
Rt22592 T4346 T4352 2849243.120423953
Rt22593 T4346 T4353 5208828.1168938894
Rt22594 T4346 T4354 4970298.332742013
Rt22595 T4346 T5365 3471508.7681691493
Rt22596 T4347 T4350 4298168.7457340797
Rt22597 T4347 T4467 4807553.9816773366
Rt22598 T4347 T4635 4847547.7674207659
Rt22599 T4347 T5591 4110286.0773886507
Rt22600 T4348 T4349 10669902.830798145
Rt22601 T4348 T4468 4674430.8930644989
Rt22602 T4348 T5506 4447940.530759736
Rt22603 T4348 T5550 3665029.8157223314
Rt22604 T4349 T4468 4689341.5033038761
Rt22605 T4349 T4469 10431905.345968207
Rt22606 T4349 T4470 1624258.4218063976
Rt22607 T4349 T5539 10078497.774037838
Rt22608 T4350 T4351 4587560.0909746829
Rt22609 T4350 T4431 1719179.9039080471
Rt22610 T4350 T4467 4969541.8750571404
Rt22611 T4350 T5516 9387528.2459898684
Rt22612 T4351 T4431 4732707.3102022791
Rt22613 T4351 T4432 4071251.300568013
Rt22614 T4351 T5498 10927672.130386451
Rt22615 T4351 T5604 4526082.6983942213
Rt22616 T4352 T4353 10914287.113440549
Rt22617 T4352 T4949 2102070.4081094223
Rt22618 T4352 T4996 20784487.305520773
Rt22619 T4352 T5773 4228116.9531316711
Rt22620 T4353 T4354 11113363.451839015
Rt22621 T4353 T4355 3838959.7994130091
Rt22622 T4353 T4356 4354851.9705088986
Rt22623 T4353 T5773 3824322.0405789046
Rt22624 T4354 T4355 4281308.6567433523
Rt22625 T4354 T4369 4949500.0444458006
Rt22626 T4354 T5169 4706073.9780439576
Rt22627 T4354 T5365 14798920.979525592
Rt22628 T4355 T4356 10786289.198936395
Rt22629 T4355 T4357 4648074.1398589099
Rt22630 T4355 T4369 4411307.6359329112
Rt22631 T4355 T5622 8836897.2129647899
Rt22632 T4356 T4357 3884054.4019367672
Rt22633 T4356 T4358 4348639.2377614919
Rt22634 T4356 T5773 12322159.970432315
Rt22635 T4356 T5836 4025325.3201892967
Rt22636 T4357 T4358 10136213.770243431
Rt22637 T4357 T4359 4480635.5799304508
Rt22638 T4357 T4620 10653775.801022971
Rt22639 T4357 T5622 4230130.7928230818
Rt22640 T4358 T4359 4724535.1469583847
Rt22641 T4358 T4360 8820641.1179249827
Rt22642 T4358 T4627 5210628.4378313152
Rt22643 T4358 T5836 9115706.9862419795
Rt22644 T4359 T4360 5180320.4638790283
Rt22645 T4359 T4361 4721522.1436120393
Rt22646 T4359 T4620 3910202.6376003916
Rt22647 T4359 T5267 5570113.0247451579
Rt22648 T4360 T4361 3517469.2362287506
Rt22649 T4360 T4362 2436652.0044411146
Rt22650 T4360 T4627 4717940.8777804691
Rt22651 T4360 T5851 10853720.609361306
Rt22652 T4361 T4362 1281024.5782467059
Rt22653 T4361 T4363 3230367.6508792806
Rt22654 T4361 T4387 10323317.761294654
Rt22655 T4361 T5267 4357179.0004679589
Rt22656 T4362 T4363 4076262.1817348758
Rt22657 T4362 T4364 3965404.3069574735
Rt22658 T4362 T5732 6982973.6001908844
Rt22659 T4362 T5851 1063720.55714442
Rt22660 T4363 T4364 9196559.2272212356
Rt22661 T4363 T4365 4500971.2400605967
Rt22662 T4363 T4387 4287144.4903855417
Rt22663 T4363 T5302 4762712.0570590124
Rt22664 T4364 T4365 3278083.5679402705
Rt22665 T4364 T4366 5148313.8517379239
Rt22666 T4364 T4663 4117333.5005803895
Rt22667 T4364 T5732 8315760.3601365807
Rt22668 T4365 T4366 12214868.499077542
Rt22669 T4365 T4367 5349422.1972052576
Rt22670 T4365 T5302 5125831.1574830674
Rt22671 T4365 T5439 4643258.9607132608
Rt22672 T4366 T4367 3549689.7110801372
Rt22673 T4366 T4368 4167500.8040560675
Rt22674 T4366 T4663 4941915.251818466
Rt22675 T4366 T5636 9271626.5414272025
Rt22676 T4367 T4368 9082562.2558745742
Rt22677 T4367 T4370 3640282.0451305937
Rt22678 T4367 T4429 4425136.7007854637
Rt22679 T4367 T5439 5975869.5838936279
Rt22680 T4368 T4370 4802824.9744985346
Rt22681 T4368 T4371 4750218.283650754
Rt22682 T4368 T4380 10529464.163025606
Rt22683 T4368 T5636 4049817.0622328096
Rt22684 T4369 T5169 5320369.2265730044
Rt22685 T4369 T5313 40421113.312702402
Rt22686 T4369 T5622 3737245.3370093629
Rt22687 T4369 T5813 3068800.2214289568
Rt22688 T4370 T4371 4621420.7027598713
Rt22689 T4370 T4372 10153949.91904377
Rt22690 T4370 T4429 10650188.247718528
Rt22691 T4370 T5544 4676079.1192652769
Rt22692 T4371 T4372 3533027.0231626877
Rt22693 T4371 T4373 5034158.2668087585
Rt22694 T4371 T4380 4460746.2642920436
Rt22695 T4371 T5611 9618667.8158963863
Rt22696 T4372 T4373 4737931.2151322281
Rt22697 T4372 T4374 10695392.709713323
Rt22698 T4372 T5508 3564252.6810993506
Rt22699 T4372 T5544 4673857.0687719136
Rt22700 T4373 T4374 4504426.2522305856
Rt22701 T4373 T4375 3324606.4553653388
Rt22702 T4373 T5502 3305438.3031780305
Rt22703 T4373 T5611 1423490.2335716658
Rt22704 T4374 T4375 10576674.093745124
Rt22705 T4374 T4376 4567986.3139015576
Rt22706 T4374 T4608 10611196.117640724
Rt22707 T4374 T5508 1600752.5672706224
Rt22708 T4375 T4376 4702593.7532166932
Rt22709 T4375 T4377 9641704.2713368814
Rt22710 T4375 T4378 4244869.5944430428
Rt22711 T4375 T5502 5055096.9459728356
Rt22712 T4376 T4377 4667253.4815419726
Rt22713 T4376 T4390 2389272.3626191202
Rt22714 T4376 T4608 3691553.361731363
Rt22715 T4376 T5708 7666700.4572643582
Rt22716 T4377 T4378 3509031.4506525602
Rt22717 T4377 T4379 4583888.7251098221
Rt22718 T4377 T4390 8786708.6059679091
Rt22719 T4377 T5448 5300160.0248736423
Rt22720 T4378 T4379 10582963.50831884
Rt22721 T4378 T4381 3850579.0606313115
Rt22722 T4378 T4822 9573571.1375934556
Rt22723 T4378 T5502 4600141.5439130431
Rt22724 T4379 T4381 4154544.5546192494
Rt22725 T4379 T4382 10581978.221248586
Rt22726 T4379 T5438 3542656.713549206
Rt22727 T4379 T5448 4890207.5417149486
Rt22728 T4380 T5611 4531334.0198883601
Rt22729 T4380 T5612 11057151.60250894
Rt22730 T4380 T5636 3254220.7951667444
Rt22731 T4380 T5842 3324259.90862928
Rt22732 T4381 T4382 3531239.0654211557
Rt22733 T4381 T4383 9567851.9410349689
Rt22734 T4381 T4822 2099357.1216165819
Rt22735 T4381 T5722 8790053.0991948377
Rt22736 T4382 T4383 3931334.6040597907
Rt22737 T4382 T4384 11617457.553008474
Rt22738 T4382 T4385 4524450.2630886408
Rt22739 T4382 T5438 4610521.5927770426
Rt22740 T4383 T4384 3615365.1707078451
Rt22741 T4383 T4621 10379856.413497344
Rt22742 T4383 T4622 22121185.005019024
Rt22743 T4383 T5722 3107754.4174635238
Rt22744 T4384 T4385 1833519.4112328785
Rt22745 T4384 T4386 8944062.305226
Rt22746 T4384 T4621 3976601.3254883569
Rt22747 T4384 T5705 4149798.4269496407
Rt22748 T4385 T4386 2895074.1570209041
Rt22749 T4385 T4388 10635718.387320127
Rt22750 T4385 T4770 3316246.646498499
Rt22751 T4385 T5438 4904169.0893317703
Rt22752 T4386 T4388 4810647.845015998
Rt22753 T4386 T4389 4764251.4491386497
Rt22754 T4386 T4391 3007930.7353123985
Rt22755 T4386 T5705 8435952.8749678694
Rt22756 T4387 T5267 4710480.1462940518
Rt22757 T4387 T5268 4778062.4195422269
Rt22758 T4387 T5302 6195551.1414148714
Rt22759 T4387 T5389 4508324.5862413663
Rt22760 T4388 T4389 10552977.706647649
Rt22761 T4388 T4770 4807321.5884995004
Rt22762 T4388 T4771 4674719.5842086906
Rt22763 T4388 T5417 3597855.0911307535
Rt22764 T4389 T4391 10143451.489730857
Rt22765 T4389 T4392 1392272.8555707878
Rt22766 T4389 T4393 11252878.086303702
Rt22767 T4389 T5417 1766800.2384829291
Rt22768 T4390 T5448 3465299.6498435265
Rt22769 T4390 T5577 4196876.4037544373
Rt22770 T4390 T5650 4602804.8714357642
Rt22771 T4390 T5708 4801368.831617062
Rt22772 T4391 T4392 1436379.8701491163
Gcorr7900 T4391 T5425 T4391 T5425 -4.4242542714674872e-08
Rt22773 T4391 T5597 3440308.7583139949
Rt22774 T4391 T5705 845755.98279143474
Rt22775 T4392 T4393 4735695.6389822327
Rt22776 T4392 T4394 4018890.8366374946
Rt22777 T4392 T4395 1740750.4815332938
Rt22778 T4392 T5597 2084069.668364916
Rt22779 T4393 T4394 2352364.9989411347
Rt22780 T4393 T5051 4812530.2700607963
Rt22781 T4393 T5146 4972578.9296708666
Rt22782 T4393 T5417 4734345.4064240167
Rt22783 T4394 T4395 4133899.5714367963
Rt22784 T4394 T4396 5525345.7038060939
Rt22785 T4394 T5051 9213684.1744609233
Rt22786 T4394 T5437 3448006.1185558615
Rt22787 T4395 T4396 11661762.6716104
Rt22788 T4395 T4397 4432025.9796684273
Rt22789 T4395 T5597 12574527.581152499
Rt22790 T4395 T5919 8965962.7012511231
Rt22791 T4396 T4397 4115398.8656512187
Rt22792 T4396 T4398 4556093.958713118
Rt22793 T4396 T4399 9250490.1779064108
Rt22794 T4396 T5437 5196769.0328076268
Rt22795 T4397 T4398 5370398.3617116651
Rt22796 T4397 T4616 4936846.2229313869
Rt22797 T4397 T4617 21343166.948717758
Rt22798 T4397 T5919 3245648.0370487436
Rt22799 T4398 T4399 4135114.166514182
Rt22800 T4398 T4400 4625668.4912733128
Rt22801 T4398 T4616 4762609.4205077766
Rt22802 T4398 T5653 3753216.5369762867
Rt22803 T4399 T4400 11621999.589063615
Rt22804 T4399 T4401 4867876.1118097473
Rt22805 T4399 T4615 4326090.4570690049
Rt22806 T4399 T5437 5915547.8787070271
Rt22807 T4400 T4401 4311865.2004611269
Rt22808 T4400 T4402 3140272.3226301502
Rt22809 T4400 T4403 2758516.0818159785
Rt22810 T4400 T5653 3368285.2604310848
Rt22811 T4401 T4402 4855527.6717304466
Rt22812 T4401 T4615 5009413.5649695918
Rt22813 T4401 T4826 10773293.235595413
Rt22814 T4401 T5590 4347697.5858689826
Rt22815 T4402 T4403 5501217.7970016096
Rt22816 T4402 T4404 10239637.797531879
Rt22817 T4402 T4405 4965778.8717848537
Rt22818 T4402 T5590 4257767.7759990543
Rt22819 T4403 T4404 4772339.3725592392
Rt22820 T4403 T4415 10887656.189213516
Rt22821 T4403 T5125 3850345.8905754331
Rt22822 T4403 T5653 4049612.316500776
Rt22823 T4404 T4405 4849059.0259907339
Rt22824 T4404 T4406 4730279.3256762102
Rt22825 T4404 T4415 4922310.0879567461
Rt22826 T4404 T5528 10305499.034094239
Rt22827 T4405 T4406 4894131.2597175865
Rt22828 T4405 T4407 10166960.013926977
Rt22829 T4405 T5590 4400786.350068788
Rt22830 T4405 T5662 3914691.496331207
Rt22831 T4406 T4407 4739426.0000055581
Rt22832 T4406 T4408 10179208.435405772
Rt22833 T4406 T5497 1804524.7210118268
Rt22834 T4406 T5528 5072592.2534054592
Rt22835 T4407 T4408 4917906.541019043
Rt22836 T4407 T4409 4288663.6302987244
Rt22837 T4407 T4595 10572343.207367638
Rt22838 T4407 T5662 303233.6659780835
Rt22839 T4408 T4409 4135068.8776678406
Rt22840 T4408 T4410 10592470.24656963
Rt22841 T4408 T4411 4639506.7599206958
Rt22842 T4408 T5497 3846529.028207012
Rt22843 T4409 T4410 4059224.9684387217
Rt22844 T4409 T4425 4252894.6583055044
Rt22845 T4409 T4595 3967721.5503917518
Rt22846 T4409 T5494 10558407.13799658
Rt22847 T4410 T4411 4594883.6524826856
Rt22848 T4410 T4412 9594330.4284950588
Rt22849 T4410 T4425 5178525.1612932049
Rt22850 T4410 T5491 5469771.5177773023
Rt22851 T4411 T4412 2974739.3274124381
Rt22852 T4411 T4413 9862322.1749893874
Rt22853 T4411 T4807 3830157.631219517
Rt22854 T4411 T5497 5044915.2948185178
Rt22855 T4412 T4413 4611076.2038373407
Rt22856 T4412 T4414 4660457.1546547068
Rt22857 T4412 T4951 4410197.9508422296
Rt22858 T4412 T5491 2768965.9767344347
Rt22859 T4413 T4414 10739483.50314584
Rt22860 T4413 T4416 3062041.1500636642
Rt22861 T4413 T4807 4660714.6018547621
Rt22862 T4413 T5513 4502358.4009633558
Rt22863 T4414 T4416 1645747.7558577156
Rt22864 T4414 T4417 10538664.627392037
Rt22865 T4414 T4951 9928918.5799170826
Rt22866 T4414 T5487 4509974.0123142023
Rt22867 T4415 T5125 3980743.3824441591
Rt22868 T4415 T5528 2978516.9904812765
Rt22869 T4415 T5649 9094093.0575579107
Rt22870 T4415 T5750 3815900.0447934759
Rt22871 T4416 T4417 4343355.0716279065
Rt22872 T4416 T4418 4516262.9619258624
Rt22873 T4416 T4420 1769686.2432514599
Rt22874 T4416 T5513 2957468.4184148363
Rt22875 T4417 T4418 10532035.57865013
Rt22876 T4417 T4419 1809409.5444102485
Rt22877 T4417 T4423 10336405.429513577
Rt22878 T4417 T5487 4648393.7579715475
Rt22879 T4418 T4419 4505752.1588535449
Rt22880 T4418 T4420 10582132.13402372
Rt22881 T4418 T4421 4352736.9111353746
Rt22882 T4418 T5555 10407317.558464821
Rt22883 T4419 T4423 2755576.4273100342
Rt22884 T4419 T4424 2749612.7998657152
Rt22885 T4419 T5476 1711757.9734769214
Rt22886 T4419 T5555 4410906.0084616737
Rt22887 T4420 T4421 4314139.7940903492
Rt22888 T4420 T4609 10478939.3335914
Rt22889 T4420 T5453 4587631.4447842678
Rt22890 T4420 T5513 10476923.718286779
Rt22891 T4421 T4609 1712434.1504427106
Rt22892 T4421 T4610 1684151.6274508859
Rt22893 T4421 T5412 1802233.6015235137
Rt22894 T4421 T5555 1710188.0859708816
Rt22895 T4422 T5512 10856258.251220087
Rt22896 T4422 T5519 4008712.8525585267
Rt22897 T4422 T5520 4119223.9249946256
Rt22898 T4422 T5563 10483136.255390381
Rt22899 T4423 T4424 4629415.1778376205
Rt22900 T4423 T4433 4872795.0443413546
Rt22901 T4423 T5487 4623349.1440545386
Rt22902 T4423 T5665 8259140.6316358475
Rt22903 T4424 T4433 4723297.5191871468
Rt22904 T4424 T4434 9102293.6141688917
Rt22905 T4424 T4435 4493798.2051012786
Rt22906 T4424 T5476 10473532.723081494
Rt22907 T4425 T5491 4017979.4420088022
Rt22908 T4425 T5494 3890175.6856341572
Rt22909 T4425 T6073 2543249.861180217
Rt22910 T4426 T4427 1970586.1225597858
Rt22911 T4426 T4587 5048230.2941518938
Rt22912 T4426 T4588 6196107.6940845707
Rt22913 T4426 T5990 1537069.5194176883
Rt22914 T4427 T4654 3673901.591818477
Rt22915 T4427 T4655 4420043.2454230487
Gcorr7901 T4427 T5379 T4427 T5379 -3.5529372731995027e-08
Rt22916 T4427 T5720 3907665.2461352819
Rt22917 T4427 T5990 10357103.956534943
Rt22918 T4428 T4907 10100806.54340058
Rt22919 T4428 T4908 4314310.8006467503
Rt22920 T4428 T4909 4086056.4328792538
Rt22921 T4428 T5496 10317305.589864446
Rt22922 T4429 T5439 24974944.720353246
Rt22923 T4429 T5544 1824480.4674185051
Rt22924 T4429 T5942 6756337.9455308402
Rt22925 T4429 T6045 2923285.4231198328
Rt22926 T4430 T5521 11090723.047143653
Rt22927 T4430 T5567 5236364.9587890077
Rt22928 T4430 T5701 6002519.1999973115
Rt22929 T4430 T6009 5416433.7820082726
Rt22930 T4431 T4432 5071557.5253547039
Rt22931 T4431 T4603 3190461.5736454013
Rt22932 T4431 T4653 9428053.0997486338
Rt22933 T4431 T5516 2641357.490010431
Rt22934 T4432 T4603 10273827.678271038
Rt22935 T4432 T4727 1642361.0756566245
Rt22936 T4432 T4728 9793148.8843104914
Rt22937 T4432 T5498 3508135.8692346555
Rt22938 T4433 T4434 2772234.9306559591
Rt22939 T4433 T4648 10068733.867079277
Rt22940 T4433 T4649 10374028.922478113
Rt22941 T4433 T5665 2698278.2567356541
Rt22942 T4434 T4435 2788598.8977600215
Rt22943 T4434 T4436 4492697.0442190422
Rt22944 T4434 T4648 1702708.7487231249
Rt22945 T4434 T5464 4587763.2984314328
Rt22946 T4435 T4436 9903085.5460305847
Rt22947 T4435 T4437 2765909.3665733878
Rt22948 T4435 T4888 4630337.7140053399
Rt22949 T4435 T5476 4712195.7944882223
Rt22950 T4436 T4437 4546667.9419639492
Rt22951 T4436 T4438 10626041.765564939
Rt22952 T4436 T4439 1646686.3015993321
Rt22953 T4436 T5464 10676660.372615574
Rt22954 T4437 T4438 3758812.0953472541
Rt22955 T4437 T4888 2683319.3474535807
Rt22956 T4437 T5375 3760217.8239402706
Rt22957 T4437 T5599 2617773.3261154033
Rt22958 T4438 T4439 1685142.4878108359
Rt22959 T4438 T4440 10603098.380778603
Rt22960 T4438 T4441 3719812.4838392111
Gcorr7902 T4438 T5375 T4438 T5375 -1.015764171302522e-08
Rt22961 T4438 T6054 127926652.44453278
Rt22962 T4439 T4440 1794146.3968333043
Rt22963 T4439 T5464 1718631.0433627672
Rt22964 T4439 T5465 1721802.4299403282
Rt22965 T4439 T5473 1719378.6498315558
Rt22966 T4440 T4441 4418620.6632309295
Rt22967 T4440 T4442 10516033.94335435
Rt22968 T4440 T4443 4560156.7518939674
Rt22969 T4440 T5465 10547701.608751584
Rt22970 T4441 T4442 1770134.1098749223
Rt22971 T4441 T5392 14671510.771411533
Rt22972 T4441 T6054 2069571.2313289975
Rt22973 T4441 T6071 1815108.1572230333
Rt22974 T4442 T4443 4401701.5960903671
Rt22975 T4442 T4444 10193014.571038811
Rt22976 T4442 T4445 6372323.6941527389
Rt22977 T4442 T6071 4415704.3469785824
Rt22978 T4443 T4444 2939497.0997130009
Rt22979 T4443 T4639 9049949.8868893944
Rt22980 T4443 T4640 2970562.4239249956
Rt22981 T4443 T5465 4410226.1844386822
Rt22982 T4444 T4445 1714727.1638110823
Rt22983 T4444 T4446 10102931.296372982
Rt22984 T4444 T4639 4685726.0540702762
Rt22985 T4444 T5518 4706794.5485396152
Rt22986 T4445 T4446 2960387.6500692642
Rt22987 T4445 T4447 9478877.6767626479
Rt22988 T4445 T5466 2822151.4011153919
Rt22989 T4445 T6071 2502351.3019300848
Rt22990 T4446 T4447 4698006.9297809349
Rt22991 T4446 T4448 4747805.7536982885
Rt22992 T4446 T4458 2758161.6466948697
Rt22993 T4446 T5518 10113439.255798507
Rt22994 T4447 T4448 4711026.0619388781
Rt22995 T4447 T4449 2961726.5748442789
Rt22996 T4447 T4450 10261442.552874818
Rt22997 T4447 T5466 4507558.765325292
Rt22998 T4448 T4449 9153146.850294359
Rt22999 T4448 T4451 4794047.902076846
Rt23000 T4448 T4458 9307217.3604987282
Rt23001 T4448 T5663 4344952.8002965925
Rt23002 T4449 T4450 5325088.7176387524
Rt23003 T4449 T4451 2767465.5162783531
Rt23004 T4449 T4452 4645206.9104802078
Rt23005 T4449 T5981 2918578.8907848056
Rt23006 T4450 T5396 28950765.102238577
Rt23007 T4450 T5466 4046168.6160480129
Rt23008 T4450 T5889 1506921.1452245133
Rt23009 T4450 T5981 6239750.0309233256
Rt23010 T4451 T4452 9875459.4201857354
Rt23011 T4451 T4453 2997678.4403945156
Rt23012 T4451 T5617 4260250.5714053875
Rt23013 T4451 T5663 4340487.1706678262
Rt23014 T4452 T4453 4660267.2046867106
Rt23015 T4452 T4454 13092361.497300314
Rt23016 T4452 T5778 3219630.2068105764
Rt23017 T4452 T5981 11603154.384356612
Rt23018 T4453 T4454 4670961.0400626622
Rt23019 T4453 T4455 2764971.9921405059
Rt23020 T4453 T4457 9959019.6963078845
Rt23021 T4453 T5617 8991581.1484874133
Rt23022 T4454 T4455 9405493.7782327943
Rt23023 T4454 T4456 4795776.845731318
Rt23024 T4454 T4613 4812868.0505943429
Rt23025 T4454 T5778 2823883.7034529666
Rt23026 T4455 T4456 2969271.0971295522
Rt23027 T4455 T4457 4196194.2861289764
Rt23028 T4455 T4459 4507020.3542771293
Rt23029 T4455 T5384 5437613.6868055174
Rt23030 T4456 T4459 4725877.3437991003
Rt23031 T4456 T4460 2619134.8523955513
Rt23032 T4456 T4613 4067905.4860373153
Rt23033 T4456 T5699 1579112436.6486204
Rt23034 T4457 T5384 12101777.426976683
Rt23035 T4457 T5565 2820284.2854603799
Rt23036 T4457 T5617 4401428.9356213734
Rt23037 T4457 T5747 5140344.229065137
Rt23038 T4458 T5391 5173551.9970099982
Rt23039 T4458 T5518 1750390.7915066725
Rt23040 T4458 T5546 4112899.8481074856
Rt23041 T4458 T5663 3110217.1424598228
Rt23042 T4459 T4460 8997449.7638118416
Rt23043 T4459 T4461 3803582.8598507536
Rt23044 T4459 T5327 5148357.093309531
Rt23045 T4459 T5384 4573054.605965375
Rt23046 T4460 T4461 3623762.0527273118
Rt23047 T4460 T4462 11016453.134646177
Rt23048 T4460 T5699 1790390.3908790301
Rt23049 T4460 T6055 2742478.0587008214
Rt23050 T4461 T4462 9118393.8930285033
Rt23051 T4461 T4463 4416010.2413935577
Rt23052 T4461 T4464 4215828.5243709497
Rt23053 T4461 T5327 8872610.7365200687
Rt23054 T4462 T4463 3880438.0923150876
Rt23055 T4462 T4465 4071780.0264758919
Rt23056 T4462 T4614 29175811.939832799
Rt23057 T4462 T6055 781939.32583073538
Rt23058 T4463 T4464 10593738.006973756
Rt23059 T4463 T4465 13425284.759362793
Rt23060 T4463 T4604 2225516.7891721604
Rt23061 T4463 T5680 733129.08736014657
Rt23062 T4464 T4604 5414013.4806271736
Rt23063 T4464 T4605 4719176.6921936329
Rt23064 T4464 T5327 4265613.304516566
Rt23065 T4464 T5545 4993091.0635221517
Rt23066 T4465 T4614 12462777.677950501
Rt23067 T4465 T4619 5835502.318774051
Rt23068 T4465 T5680 2370109.7411556598
Rt23069 T4465 T5681 2343310.8650550586
Rt23070 T4466 T5446 7665542.7435365124
Gcorr7903 T4466 T5549 T4466 T5549 -3.8335477826126411e-07
Gcorr7904 T4466 T5660 T4466 T5660 -2.7153947238800964e-08
Gcorr7905 T4466 T5865 T4466 T5865 -1.3358528385916204e-07
Rt23071 T4466 T5915 5652019.1475433325
Rt23072 T4467 T5516 10488905.953148736
Rt23073 T4467 T5591 11824893.285938172
Rt23074 T4467 T5916 3070883.8737966744
Rt23075 T4467 T6008 5042281.9916020855
Rt23076 T4468 T4469 3368459.9288432533
Rt23077 T4468 T4632 9644478.7637607511
Rt23078 T4468 T4705 4734186.4567171186
Rt23079 T4468 T5506 9424493.4355728682
Rt23080 T4469 T4470 1668502.5285499364
Rt23081 T4469 T4471 10409300.193793589
Rt23082 T4469 T4632 4685691.3260635938
Rt23083 T4469 T5504 4668544.1934193298
Rt23084 T4470 T4471 4373407.5564412121
Rt23085 T4470 T4472 1675155.2971050499
Rt23086 T4470 T5539 1761944.8000037221
Rt23087 T4470 T5554 1655888.9506008246
Rt23088 T4471 T4472 10288857.450372888
Rt23089 T4471 T4597 4415593.8869823711
Rt23090 T4471 T4685 5090496.6181421923
Rt23091 T4471 T5504 3442346.7905963636
Rt23092 T4472 T4597 3083168.9239978241
Rt23093 T4472 T4598 4588639.4008943969
Rt23094 T4472 T4709 4503967.7777291322
Rt23095 T4472 T5554 9920906.3707499448
Rt23096 T4473 T4474 8632972.461594034
Rt23097 T4473 T4475 4617579.2657941263
Rt23098 T4473 T5728 4027711.3278543204
Rt23099 T4473 T5934 11041657.567411551
Rt23100 T4474 T4475 2641134.1945174178
Rt23101 T4474 T4476 1421799.2131078413
Rt23102 T4474 T4841 4811173.068530296
Rt23103 T4474 T5264 2049606.9368483655
Rt23104 T4475 T4476 14913021.260724178
Rt23105 T4475 T4477 4011976.2565509533
Rt23106 T4475 T4823 2700874.1005881708
Rt23107 T4475 T5934 8951699.9945237022
Rt23108 T4476 T4477 4937325.8428580184
Rt23109 T4476 T4478 17014936.853380181
Rt23110 T4476 T4841 13164231.067337401
Rt23111 T4476 T5247 3971811.9399028718
Rt23112 T4477 T4478 4318744.7743456988
Rt23113 T4477 T4479 2871613.3576369337
Rt23114 T4477 T4823 12719779.553404089
Rt23115 T4477 T5873 2087255.2624527521
Rt23116 T4478 T4479 4353986.3767763423
Rt23117 T4478 T4480 18246159.56130404
Rt23118 T4478 T4482 5510569.6375850886
Rt23119 T4478 T5247 51187121.861619435
Rt23120 T4478 T5983 3995692.121730485
Rt23121 T4479 T4480 1355419.6809724537
Rt23122 T4479 T4481 2497740.6187848733
Rt23123 T4479 T4824 9713972.5009893756
Rt23124 T4479 T5873 8653741.9532266892
Rt23125 T4480 T4481 17831036.170112636
Rt23126 T4480 T4482 5209571.5173531687
Rt23127 T4480 T4483 11216099.212237006
Rt23128 T4480 T5243 3886598.9826247822
Rt23129 T4481 T4824 4404196.6089003915
Rt23130 T4481 T4825 28997687.896229997
Rt23131 T4481 T5126 5069823.812428711
Rt23132 T4481 T5243 60323980.708750084
Rt23133 T4481 T6066 3744038.060092574
Rt23134 T4482 T4483 3005648.8941070088
Rt23135 T4482 T4484 5087252.0036147255
Rt23136 T4482 T4832 16796283.733818963
Rt23137 T4482 T5983 2645228.0867858571
Rt23138 T4483 T4484 4064955.8079509628
Rt23139 T4483 T4485 10658084.211245144
Rt23140 T4483 T5243 4726095.2026789775
Rt23141 T4483 T5559 4250324.0133510791
Rt23142 T4484 T4485 4854374.6690849159
Rt23143 T4484 T4486 4786171.7792930882
Rt23144 T4484 T4832 5255663.5760651529
Rt23145 T4484 T5614 10592981.003225254
Rt23146 T4485 T4486 4638560.581179508
Rt23147 T4485 T4487 3950676.670348627
Rt23148 T4485 T4488 4858975.872037855
Rt23149 T4485 T5559 3714598.2200174085
Rt23150 T4486 T4487 10495585.301744029
Rt23151 T4486 T4493 4342850.671987867
Rt23152 T4486 T4494 10687627.646189665
Rt23153 T4486 T5614 3935384.1670669722
Rt23154 T4487 T4488 5004295.2840959001
Rt23155 T4487 T4489 4919312.2340724701
Rt23156 T4487 T4493 4494557.4860563297
Rt23157 T4487 T5535 4560840.8514778363
Rt23158 T4488 T4489 4628803.7947488585
Rt23159 T4488 T4490 3364194.5438016728
Rt23160 T4488 T5041 9882511.7717887089
Rt23161 T4488 T5559 2608722.0428060335
Rt23162 T4489 T4490 10064006.288802819
Rt23163 T4489 T4491 4527848.9084993517
Rt23164 T4489 T5500 5336317.8565465705
Rt23165 T4489 T5535 10104452.810637584
Rt23166 T4490 T4491 9827291.9840705637
Rt23167 T4490 T4492 2350921.1991678597
Rt23168 T4490 T5041 4762220.8977955189
Rt23169 T4490 T5503 4803126.2315994054
Rt23170 T4491 T4492 2025811.2015711721
Rt23171 T4491 T4500 4971364.6753234109
Rt23172 T4491 T4594 1976571.840459187
Rt23173 T4491 T5500 2238489.6657341737
Rt23174 T4492 T4500 5159212.6879440071
Rt23175 T4492 T4501 4620092.0310956417
Rt23176 T4492 T4502 2217836.7592357527
Rt23177 T4492 T5503 9046713.6321394388
Rt23178 T4493 T4494 4361985.4737755349
Rt23179 T4493 T4495 5058771.3010369223
Rt23180 T4493 T5505 4062517.92938708
Rt23181 T4493 T5535 10531633.946805675
Rt23182 T4494 T4495 5612155.6310017304
Rt23183 T4494 T4496 4854346.0619800361
Rt23184 T4494 T5501 4548703.2126227273
Rt23185 T4494 T5614 4160184.143686472
Rt23186 T4495 T4496 4954438.8270525187
Rt23187 T4495 T4497 4442101.6818659715
Rt23188 T4495 T4498 2340954.8979671011
Rt23189 T4495 T5505 4924711.7414750587
Rt23190 T4496 T4497 4697708.7042846633
Rt23191 T4496 T4499 4744495.2800043644
Rt23192 T4496 T4634 4742213.9119810844
Rt23193 T4496 T5501 10603297.033608794
Rt23194 T4497 T4498 2787682.227738509
Rt23195 T4497 T4499 10198260.856480522
Rt23196 T4497 T4601 4496671.0595407849
Rt23197 T4497 T5613 4788651.4824168542
Rt23198 T4498 T5505 17021860.952554256
Rt23199 T4498 T5613 11104834.713732494
Rt23200 T4498 T5992 4168815.1248687389
Rt23201 T4498 T6057 3160626.6377065126
Rt23202 T4499 T4601 3650796.6825326313
Rt23203 T4499 T4602 4028926.6835534759
Rt23204 T4499 T4634 4017992.27317901
Rt23205 T4499 T5432 24819850.881088391
Rt23206 T4500 T4501 3702525.2980091278
Rt23207 T4500 T4594 10584134.264491806
Rt23208 T4500 T4599 5561141.8281804593
Rt23209 T4500 T5904 6267021.4367381381
Rt23210 T4501 T4502 8898234.9080900848
Rt23211 T4501 T4503 4945616.5843612589
Rt23212 T4501 T5726 4325884.2841293579
Rt23213 T4501 T5904 6225286.9395971764
Rt23214 T4501 T6075 45058165.380627833
Rt23215 T4502 T4503 3146469.6515425467
Rt23216 T4502 T4504 1399292.7122540874
Rt23217 T4502 T4821 4701852.8924302263
Rt23218 T4502 T5503 4710818.5316110812
Rt23219 T4503 T4504 10919743.394064948
Rt23220 T4503 T4505 4482797.9511988685
Rt23221 T4503 T4628 26420059.120830461
Rt23222 T4503 T6075 2915103.5514289974
Rt23223 T4504 T4505 4718071.6745230984
Rt23224 T4504 T4506 10418078.108906757
Rt23225 T4504 T4821 5307794.6370458044
Rt23226 T4504 T5488 4595495.3380082082
Rt23227 T4505 T4506 3842364.9352545678
Rt23228 T4505 T4507 10439649.430315323
Rt23229 T4505 T4628 4820831.1750320774
Rt23230 T4505 T5486 4500788.6371494802
Rt23231 T4506 T4507 4667785.9527017605
Rt23232 T4506 T4508 10709924.287165385
Rt23233 T4506 T4652 3862715.9287625314
Rt23234 T4506 T5488 4596042.5214992501
Rt23235 T4507 T4508 4325006.4056055788
Rt23236 T4507 T4509 10473831.902504474
Rt23237 T4507 T5479 4329352.7619136665
Rt23238 T4507 T5486 4001649.398232643
Rt23239 T4508 T4509 4612000.0856997194
Rt23240 T4508 T4510 4339169.5685642986
Rt23241 T4508 T4652 4792967.9648528481
Rt23242 T4508 T5480 4257565.4908067025
Rt23243 T4509 T4510 4403836.5902394718
Rt23244 T4509 T4511 4381660.6316836458
Rt23245 T4509 T4527 3184278.6134946579
Rt23246 T4509 T5479 914574.44068831683
Rt23247 T4510 T4511 10198182.686545525
Rt23248 T4510 T4512 4445759.1367584942
Rt23249 T4510 T4513 4699831.6140748961
Rt23250 T4510 T5480 10694363.580912208
Rt23251 T4511 T4512 4574325.0243974468
Rt23252 T4511 T4527 2022500.2579928807
Rt23253 T4511 T4790 3671166.2257337668
Rt23254 T4511 T5471 4275204.082842825
Rt23255 T4512 T4513 10635243.175768351
Rt23256 T4512 T4514 4290338.2752153547
Rt23257 T4512 T4515 4124678.6603166698
Rt23258 T4512 T5471 10072936.995050702
Rt23259 T4513 T4514 4698785.722711782
Rt23260 T4513 T4633 9829967.7874932215
Rt23261 T4513 T5059 2560958.1762455325
Rt23262 T4513 T5480 4037313.133727489
Rt23263 T4514 T4515 4394504.5299282875
Rt23264 T4514 T4516 3717514.4259727881
Rt23265 T4514 T4633 4058795.1312078675
Rt23266 T4514 T5583 10152724.368545102
Rt23267 T4515 T4516 9429643.4991424587
Rt23268 T4515 T4517 3975169.3773130015
Rt23269 T4515 T5471 3978667.3778175912
Rt23270 T4515 T5475 9503526.8979638312
Rt23271 T4516 T4517 4178523.3989573731
Rt23272 T4516 T4518 3873143.8886430436
Rt23273 T4516 T4647 9469378.4528938867
Rt23274 T4516 T5583 4071230.3422929775
Rt23275 T4517 T4518 9190140.1365132052
Rt23276 T4517 T4519 591499.28638711339
Rt23277 T4517 T4596 8830365.0880289394
Rt23278 T4517 T5475 3938679.4298162013
Rt23279 T4518 T4519 4337610.2446933677
Rt23280 T4518 T4520 9420522.8931425642
Rt23281 T4518 T4647 8793817.85939404
Rt23282 T4518 T5467 1845064.0490026262
Rt23283 T4519 T4520 4698906.312925729
Rt23284 T4519 T4521 9328475.5497659352
Rt23285 T4519 T4596 3930489.1910790517
Rt23286 T4519 T5674 999573.62209936604
Rt23287 T4520 T4521 3898355.7232000013
Rt23288 T4520 T4522 10133555.522884181
Rt23289 T4520 T4592 5096676.5540365651
Rt23290 T4520 T5467 1562766.325590102
Rt23291 T4521 T4522 4303011.9546054723
Rt23292 T4521 T4523 4942677.1791147804
Rt23293 T4521 T5674 1189298.4671019572
Rt23294 T4521 T5683 8867534.3325718772
Rt23295 T4522 T4523 10156353.918139623
Rt23296 T4522 T4524 4801390.4897363102
Rt23297 T4522 T4592 4186482.387843383
Rt23298 T4522 T5767 3928214.0877429717
Rt23299 T4523 T4524 3892185.2419730574
Rt23300 T4523 T4525 4698620.4123251643
Rt23301 T4523 T4593 11120211.944388213
Rt23302 T4523 T5683 3621104.9805551283
Rt23303 T4524 T4525 10654935.868297327
Rt23304 T4524 T4526 4566350.0844157618
Rt23305 T4524 T5718 9591357.1467426158
Rt23306 T4524 T5767 4047429.5387782082
Rt23307 T4525 T4526 3948623.8779673581
Rt23308 T4525 T4528 4836771.2633613897
Rt23309 T4525 T4593 29443143.866158776
Rt23310 T4525 T6065 2580117.1535479096
Rt23311 T4526 T4528 9895742.6415644027
Rt23312 T4526 T4529 1087483.5982297151
Rt23313 T4526 T4530 10910202.563470108
Rt23314 T4526 T5718 4502426.4175869795
Rt23315 T4527 T4790 10621977.797681646
Rt23316 T4527 T4791 4468459.6264723828
Rt23317 T4527 T5459 4604651.3381945379
Rt23318 T4527 T5479 9834080.8702911586
Rt23319 T4528 T4529 3911068.4260923415
Gcorr7906 T4528 T5279 T4528 T5279 -2.6963409979872604e-08
Rt23320 T4528 T5460 5264517.1814587601
Rt23321 T4528 T5928 2135318.9005651609
Rt23322 T4528 T6065 2213467.2358644814
Rt23323 T4529 T4530 2931115.7113857483
Rt23324 T4529 T4531 9443889.0523363631
Rt23325 T4529 T4532 4606512.1147109512
Rt23326 T4529 T5460 1183635.2090974457
Rt23327 T4530 T4531 2311802.8381621819
Rt23328 T4530 T5436 15755469.985393835
Rt23329 T4530 T5537 3503650.0790200173
Rt23330 T4530 T5718 2281199.0803138842
Rt23331 T4531 T4532 600265.03318792954
Rt23332 T4531 T4533 10307433.270886403
Rt23333 T4531 T4534 2694268.2357346648
Rt23334 T4531 T5537 3692959.0331308828
Rt23335 T4532 T4533 4454087.8356389906
Rt23336 T4532 T5460 1167978.7964987084
Rt23337 T4532 T5522 4714472.0249929223
Rt23338 T4532 T5558 9612984.7559667323
Rt23339 T4533 T4534 2309385.8910938613
Rt23340 T4533 T4535 2044921.9599948006
Rt23341 T4533 T4536 10669149.189930443
Rt23342 T4533 T5522 4037269.1149538825
Rt23343 T4534 T4535 2696305.3635019697
Rt23344 T4534 T5537 11218770.308502391
Rt23345 T4534 T5635 2521839.9711577347
Rt23346 T4534 T6002 3688781.2269179071
Rt23347 T4535 T4536 4587763.9491270287
Rt23348 T4535 T4537 4001163.8364137285
Rt23349 T4535 T4538 3175173.4470697325
Rt23350 T4535 T5635 10435728.654260535
Rt23351 T4536 T4537 10313172.488385668
Rt23352 T4536 T5440 3811841.3180987118
Rt23353 T4536 T5443 4835777.735847312
Rt23354 T4536 T5522 4636190.0045926422
Rt23355 T4537 T4538 9949884.998226786
Rt23356 T4537 T4539 4778805.4671510058
Rt23357 T4537 T4540 5332867.6973732067
Rt23358 T4537 T5440 4768774.8779441696
Rt23359 T4538 T4539 4276110.5962032219
Rt23360 T4538 T4550 9474073.0857744534
Rt23361 T4538 T4743 6282291.6268150406
Rt23362 T4538 T5635 4544524.2983621545
Rt23363 T4539 T4540 10645218.841889739
Rt23364 T4539 T4541 4994113.066859955
Rt23365 T4539 T4550 3810555.8234078065
Rt23366 T4539 T5610 9991421.0330027398
Rt23367 T4540 T4541 5216173.3472743854
Rt23368 T4540 T4542 5525807.0162846474
Rt23369 T4540 T4690 4853141.3758772006
Rt23370 T4540 T5440 4690495.4964085352
Rt23371 T4541 T4542 4080957.1197751383
Rt23372 T4541 T4543 4184049.0640663672
Rt23373 T4541 T5548 9912552.1442407779
Rt23374 T4541 T5610 3859857.8829676919
Rt23375 T4542 T4543 10081689.510041542
Rt23376 T4542 T4544 3652842.3763723727
Rt23377 T4542 T4690 5789928.0192564474
Rt23378 T4542 T5797 3927665.656490956
Rt23379 T4543 T4544 4905032.7230541334
Rt23380 T4543 T4545 4902652.2473451979
Rt23381 T4543 T4660 10312923.239474747
Rt23382 T4543 T5548 4780712.7057195026
Rt23383 T4544 T4545 4949627.745402636
Rt23384 T4544 T4546 4926313.7215229105
Rt23385 T4544 T4582 2994670.1061384277
Rt23386 T4544 T5797 6926567.2268838882
Rt23387 T4545 T4546 4305346.9163393043
Rt23388 T4545 T4547 9888037.0496984981
Rt23389 T4545 T4660 4492636.7074863464
Rt23390 T4545 T5540 3991447.0956134675
Rt23391 T4546 T4547 5366004.4615774853
Rt23392 T4546 T4548 5076429.7702156156
Rt23393 T4546 T4582 9862719.8468280211
Rt23394 T4546 T5667 4554832.1717336588
Rt23395 T4547 T4548 3910165.9892957676
Rt23396 T4547 T4549 5366309.8593790261
Rt23397 T4547 T4551 5145281.4746242482
Rt23398 T4547 T5540 5516999.0791350771
Rt23399 T4548 T4549 10451751.552443212
Rt23400 T4548 T5629 3019989.4337231219
Rt23401 T4548 T5667 4530346.3572650757
Rt23402 T4548 T5686 4514866.3094466506
Rt23403 T4549 T4551 5270235.2132144002
Rt23404 T4549 T4552 5291089.9786883015
Rt23405 T4549 T4553 3940889.6874021767
Rt23406 T4549 T5629 4733281.3530749269
Rt23407 T4550 T4743 3659592.1289192224
Rt23408 T4550 T4744 6053364.4736857489
Rt23409 T4550 T5610 3271321.0768451123
Rt23410 T4550 T5911 9021064.7577055115
Rt23411 T4551 T4552 5615893.779290176
Rt23412 T4551 T5540 3868402.4251152701
Rt23413 T4551 T5709 4471243.7443608027
Rt23414 T4551 T5768 2870019.5548965801
Rt23415 T4552 T4553 10383861.830149285
Rt23416 T4552 T4554 1671832.1783033782
Rt23417 T4552 T4555 9797680.1325991806
Rt23418 T4552 T5709 3382132.7102221888
Rt23419 T4553 T4554 2110242.1906352285
Rt23420 T4553 T5542 9552912.322017327
Rt23421 T4553 T5560 4902630.7956924224
Rt23422 T4553 T5629 4620923.7017741576
Rt23423 T4554 T4555 4172128.3456328367
Rt23424 T4554 T4556 4037315.6768021607
Rt23425 T4554 T4557 3962374.8885976197
Rt23426 T4554 T5542 1589308.7305007372
Rt23427 T4555 T4556 10153708.060715299
Rt23428 T4555 T5485 3912639.7959883003
Rt23429 T4555 T5709 4952733.3754183864
Rt23430 T4555 T5784 3302656.0668870877
Rt23431 T4556 T4557 3007435.4138519829
Rt23432 T4556 T4558 3376668.153568102
Rt23433 T4556 T4559 3742994.7702276711
Rt23434 T4556 T5485 4372653.8761100993
Rt23435 T4557 T4558 10635519.835101733
Rt23436 T4557 T4797 4526451.4803483933
Rt23437 T4557 T4798 4172300.794363956
Rt23438 T4557 T5542 10466087.251593675
Rt23439 T4558 T4559 4046890.1063701618
Rt23440 T4558 T4560 4618108.6723096268
Rt23441 T4558 T4797 3647243.0483506871
Rt23442 T4558 T5482 4312461.8115391778
Rt23443 T4559 T4560 10622428.944411507
Rt23444 T4559 T4561 4118532.1182978754
Rt23445 T4559 T5477 4014993.2277004272
Rt23446 T4559 T5485 10648710.308776664
Rt23447 T4560 T4561 4022096.6300134999
Rt23448 T4560 T4562 4596975.4184686253
Rt23449 T4560 T4563 4572572.4593868451
Rt23450 T4560 T5482 4863038.0906890333
Rt23451 T4561 T4562 10590350.98146797
Rt23452 T4561 T4584 4110786.876325598
Rt23453 T4561 T4611 4023728.5888784858
Rt23454 T4561 T5477 10622655.109489141
Rt23455 T4562 T4563 10428015.518098403
Rt23456 T4562 T4564 4906353.284017927
Rt23457 T4562 T4584 3474297.1070430353
Rt23458 T4562 T5790 3582456.9913596222
Rt23459 T4563 T4564 3691028.3049009163
Rt23460 T4563 T4565 4618441.9267927622
Rt23461 T4563 T5482 9445784.8349809889
Rt23462 T4563 T5484 4580386.727912331
Rt23463 T4564 T4565 10455408.918258481
Rt23464 T4564 T4566 4682047.898039598
Rt23465 T4564 T5745 8071929.2900962206
Rt23466 T4564 T5790 3732112.3063002117
Rt23467 T4565 T4566 3659431.6754173897
Rt23468 T4565 T4567 4691697.2977297762
Rt23469 T4565 T4569 10649901.975611214
Rt23470 T4565 T5484 3635967.0697211465
Rt23471 T4566 T4567 9135770.0867260136
Rt23472 T4566 T4568 4235055.2673312481
Rt23473 T4566 T4572 9568807.5309529435
Rt23474 T4566 T5745 3707825.6383748148
Rt23475 T4567 T4568 4232284.5042492338
Rt23476 T4567 T4569 4555353.1134948814
Rt23477 T4567 T4570 16275360.998401141
Rt23478 T4567 T5963 2714058.651742612
Rt23479 T4568 T4570 1364965.8860360049
Rt23480 T4568 T4571 1262945.9556768297
Rt23481 T4568 T4572 1354301.7768585104
Rt23482 T4568 T5721 1267365.9392125423
Rt23483 T4569 T5484 5105347.6447144244
Rt23484 T4569 T5950 7202247.5416025361
Rt23485 T4569 T5963 17716321.937812716
Rt23486 T4569 T6042 2673552.8950015642
Rt23487 T4570 T4571 10082798.592938967
Rt23488 T4570 T4573 3716879.758960872
Rt23489 T4570 T4638 4472957.2724530753
Rt23490 T4570 T5963 3045367.6751831081
Rt23491 T4571 T4573 4485857.1667490918
Rt23492 T4571 T4574 4553949.090209919
Rt23493 T4571 T5721 8343538.1121484851
Rt23494 T4571 T5741 3170605.7299117022
Gcorr7907 T4572 T5239 T4572 T5239 -1.3497768174794693e-08
Rt23495 T4572 T5721 23112529.551039897
Rt23496 T4572 T5738 3933899.2724718577
Rt23497 T4572 T5745 3639548.4684391683
Rt23498 T4572 T6067 1200834.670288567
Rt23499 T4573 T4574 10600325.974516923
Rt23500 T4573 T4575 4319073.8823481454
Rt23501 T4573 T4638 12392349.313786717
Rt23502 T4573 T5964 2951134.6684969878
Rt23503 T4574 T4575 4426834.8973596236
Rt23504 T4574 T4576 4465211.436439747
Rt23505 T4574 T4637 3705711.2152654012
Rt23506 T4574 T5741 8166362.9569444396
Rt23507 T4575 T4576 4561678.4117093775
Rt23508 T4575 T4577 10693003.289993023
Rt23509 T4575 T5897 4370469.4110464342
Rt23510 T4575 T5964 5375724.5573468506
Rt23511 T4576 T4577 3668721.8847990031
Rt23512 T4576 T4578 10590407.425945407
Rt23513 T4576 T4637 10281298.927985355
Rt23514 T4576 T5462 4386550.8496193262
Rt23515 T4577 T4578 4450045.2512817848
Rt23516 T4577 T4579 10195253.93247108
Rt23517 T4577 T4585 4193385.2160997135
Rt23518 T4577 T5897 3142913.5245203464
Rt23519 T4578 T4579 3704318.4835512377
Rt23520 T4578 T4580 10808537.709231436
Rt23521 T4578 T4581 4486411.4351933748
Rt23522 T4578 T5462 3599879.3370450786
Rt23523 T4579 T4580 4246284.490595771
Rt23524 T4579 T4583 4519209.3606222263
Rt23525 T4579 T4585 1258738.0609260583
Rt23526 T4579 T5461 10294242.720734501
Rt23527 T4580 T4581 4350155.7148541082
Rt23528 T4580 T4583 10749932.694805291
Rt23529 T4580 T4586 4244271.8744912958
Rt23530 T4580 T5463 10671922.982183848
Rt23531 T4581 T5462 9727785.7508815434
Rt23532 T4581 T5463 3907923.301462634
Rt23533 T4581 T5527 4446259.8568149749
Rt23534 T4581 T5846 6778215.8591879243
Rt23535 T4582 T5434 5045289.109244518
Rt23536 T4582 T5667 1688143.0125713365
Rt23537 T4582 T5725 3722984.0229737223
Rt23538 T4582 T5797 5542369.1445834721
Rt23539 T4583 T4586 3722502.6991521385
Rt23540 T4583 T4606 3944761.5556314485
Rt23541 T4583 T4636 10018637.286118124
Rt23542 T4583 T5461 4283228.7426096862
Rt23543 T4584 T4611 10564659.238017039
Rt23544 T4584 T4612 4112417.5052651712
Gcorr7908 T4584 T5311 T4584 T5311 -1.9012818192613493e-09
Rt23545 T4584 T5790 9547572.8695945665
Rt23546 T4584 T6004 4483826.7124561919
Rt23547 T4585 T5420 28837513.862439156
Rt23548 T4585 T5461 3433246.2162966211
Rt23549 T4585 T5897 7585431.0716689164
Rt23550 T4585 T6023 2724749.0233262391
Rt23551 T4586 T4606 9830176.0002467707
Rt23552 T4586 T4607 1271895.5628512539
Rt23553 T4586 T4698 9990474.7484879009
Rt23554 T4586 T5463 4525108.253656528
Rt23555 T4587 T4588 10667181.731426118
Rt23556 T4587 T4589 4403516.3905388312
Rt23557 T4587 T4871 466011.47136957315
Rt23558 T4587 T5514 2185923.7018864821
Rt23559 T4588 T4589 1047286.0187821732
Rt23560 T4588 T4590 11810450.919684445
Rt23561 T4588 T5696 4381423.2544857142
Rt23562 T4588 T5990 5518639.6018163068
Rt23563 T4589 T4590 4624533.2681156993
Rt23564 T4589 T4591 10690789.753638951
Rt23565 T4589 T4871 4845319.8942445405
Rt23566 T4589 T5450 4012976.0806330461
Rt23567 T4590 T4591 3964640.320711867
Rt23568 T4590 T4629 4064848.5640254421
Rt23569 T4590 T4630 5394540.8455696926
Rt23570 T4590 T5696 4149613.5874457913
Rt23571 T4591 T4629 10125413.254356213
Rt23572 T4591 T4631 5418273.1385678016
Rt23573 T4591 T4691 5400002.0340697505
Rt23574 T4591 T5450 4409895.973249631
Rt23575 T4592 T5380 35570421.266334265
Rt23576 T4592 T5467 2986872.9141864027
Rt23577 T4592 T5743 3298263.7303250954
Rt23578 T4592 T5767 2680425.2592887883
Rt23579 T4593 T5683 4064822.174630607
Rt23580 T4593 T5733 3710456.897465481
Rt23581 T4593 T5876 7589054.0812826669
Rt23582 T4593 T6065 2514186.4120653286
Rt23583 T4594 T4599 2027741.9044717823
Rt23584 T4594 T4600 10312194.578997947
Rt23585 T4594 T5500 10557745.690858047
Rt23586 T4594 T5526 4682718.334154956
Rt23587 T4595 T5312 104795324.05957066
Rt23588 T4595 T5494 3634843.3690648298
Rt23589 T4595 T5495 33352149.305882301
Rt23590 T4595 T5662 13918005.192601223
Rt23591 T4595 T6043 1495410.694291333
Rt23592 T4596 T5475 4235801.0816169251
Rt23593 T4596 T5573 1548972.0981760358
Rt23594 T4596 T5592 2838313.6707680942
Rt23595 T4596 T5674 4150707.0918077221
Rt23596 T4597 T4598 10445747.374143278
Rt23597 T4597 T4685 9980292.5143404473
Rt23598 T4597 T4686 4184885.5042502894
Rt23599 T4597 T5787 9105459.2534404621
Rt23600 T4598 T4709 4695667.4176843371
Rt23601 T4598 T4883 3696300.3231133381
Rt23602 T4598 T5252 10128110.537614206
Rt23603 T4598 T5787 4001021.3105224855
Rt23604 T4599 T4600 2676271.8861647216
Rt23605 T4599 T4625 11649469.776489969
Rt23606 T4599 T5904 3436711.4814735367
Rt23607 T4599 T5991 2818053.1727461163
Rt23608 T4600 T4625 4097404.7349735065
Rt23609 T4600 T4626 4636228.364958941
Rt23610 T4600 T4845 12597993.808909426
Rt23611 T4600 T5526 4288181.1893299716
Rt23612 T4601 T4602 9384518.7297353912
Rt23613 T4601 T4707 2014553.8062003057
Rt23614 T4601 T4738 4392709.4878370035
Rt23615 T4601 T5613 4017568.6633693902
Rt23616 T4602 T4707 1308561.8826287945
Rt23617 T4602 T4708 9626456.0394556019
Rt23618 T4602 T5015 4339808.5394877577
Rt23619 T4602 T5432 5628488.0718309199
Rt23620 T4603 T4653 4528525.4111916684
Rt23621 T4603 T4678 4625250.8537468137
Rt23622 T4603 T4727 1635119.5459148972
Rt23623 T4603 T5552 10425481.867133942
Rt23624 T4604 T4605 4564190.7697675675
Rt23625 T4604 T4664 3802247.1016666177
Rt23626 T4604 T4684 8550888.1082167812
Rt23627 T4604 T5680 8848656.5307230763
Rt23628 T4605 T4664 10517255.995864311
Rt23629 T4605 T4665 3843388.446613316
Rt23630 T4605 T4666 3426613.7912463294
Rt23631 T4605 T5545 13390258.792804796
Rt23632 T4606 T4607 3642446.7522968692
Rt23633 T4606 T4636 2675886.0394296702
Rt23634 T4606 T4680 4408877.0124717169
Rt23635 T4606 T5469 9282789.0599397793
Rt23636 T4607 T4680 1599178.6557536179
Rt23637 T4607 T4681 4232837.3278729096
Rt23638 T4607 T4698 4248152.3624316864
Rt23639 T4607 T5472 4330691.6566807637
Rt23640 T4608 T5508 4887264.6514908532
Rt23641 T4608 T5707 4392111.4994019764
Rt23642 T4608 T5708 4144225.4114474286
Rt23643 T4608 T5791 10845848.303953141
Rt23644 T4609 T4610 10598331.201755678
Rt23645 T4609 T4699 4645305.5910255089
Rt23646 T4609 T4701 10206911.027320905
Rt23647 T4609 T5453 4392539.4280392202
Rt23648 T4610 T4699 4427636.6933857407
Rt23649 T4610 T4700 9356353.7023225781
Rt23650 T4610 T4702 4754067.9208767954
Rt23651 T4610 T5412 12602675.729447946
Rt23652 T4611 T4612 4129167.6971431402
Rt23653 T4611 T4695 4043416.3120423397
Rt23654 T4611 T5477 4119313.671509143
Rt23655 T4611 T5478 10642649.03807126
Rt23656 T4612 T4695 10546820.75683767
Rt23657 T4612 T4696 3976797.9276328254
Rt23658 T4612 T4697 5309627.2153398125
Rt23659 T4612 T6004 5156101.8997899732
Rt23660 T4613 T5698 44467354.460751168
Rt23661 T4613 T5699 4685821.1199552706
Rt23662 T4613 T5778 14795859.908419311
Rt23663 T4613 T6026 3267087.0844959342
Rt23664 T4614 T4619 3525655.5923685539
Rt23665 T4614 T4755 5808987.0440552523
Rt23666 T4614 T5580 210679102.51478165
Rt23667 T4614 T6055 1267309.5834016323
Rt23668 T4615 T4826 4215556.5247654049
Rt23669 T4615 T5117 10015463.793725567
Rt23670 T4615 T5328 4228295.7679066509
Rt23671 T4615 T5437 22051781.941471081
Rt23672 T4616 T4617 2895337.9929236276
Rt23673 T4616 T4618 22897762.715537626
Rt23674 T4616 T5653 35539157.314058334
Rt23675 T4616 T5850 2983939.460547768
Rt23676 T4617 T4618 568397.50958851934
Rt23677 T4617 T4624 15204730.252966564
Rt23678 T4617 T5164 4809930.2857785514
Rt23679 T4617 T5919 2234104.3748281621
Rt23680 T4618 T4624 3785460.5332592684
Rt23681 T4618 T4785 5591150.9009853043
Rt23682 T4618 T5710 901545.61922445789
Rt23683 T4618 T5850 50636480.959137492
Rt23684 T4619 T4755 35293259.94343292
Rt23685 T4619 T4756 6915449.1997812297
Rt23686 T4619 T5655 5770759.2302485229
Rt23687 T4619 T5681 3696885.9900170178
Rt23688 T4620 T5267 6625476.6075883256
Rt23689 T4620 T5269 4404147.717372546
Rt23690 T4620 T5615 4853167.173270735
Rt23691 T4620 T5622 4227927.5895839678
Rt23692 T4621 T4622 3166632.3648100845
Rt23693 T4621 T4623 17687571.092209574
Rt23694 T4621 T5425 6532037.6704692226
Rt23695 T4621 T5705 7039570.5571228815
Rt23696 T4622 T4623 2600493.8534821677
Rt23697 T4622 T4749 51929007.621455222
Rt23698 T4622 T5722 2731423.2775430754
Rt23699 T4622 T5995 3058336.1710645207
Rt23700 T4623 T4749 4084588.5212372192
Rt23701 T4623 T4750 11170399.35286977
Rt23702 T4623 T5425 15406081.786696374
Rt23703 T4623 T5724 5098103.5308910757
Rt23704 T4624 T4785 3628180.9187623439
Rt23705 T4624 T4787 3612169.9099261509
Rt23706 T4624 T5164 27489395.181360669
Rt23707 T4624 T6069 2289496.8959037997
Rt23708 T4625 T4626 4084048.3820387139
Rt23709 T4625 T4712 3328972.0329860952
Rt23710 T4625 T4713 29250761.119224243
Rt23711 T4625 T5991 2488469.2185468851
Rt23712 T4626 T4712 9850259.929634992
Rt23713 T4626 T4737 5936026.1151969209
Rt23714 T4626 T4845 3685227.5548162651
Rt23715 T4626 T5854 10386197.08045928
Rt23716 T4627 T5316 4999450.8663391629
Rt23717 T4627 T5774 23574717.893248573
Rt23718 T4627 T5836 2574693.6702968804
Rt23719 T4627 T5851 1628081.7023375649
Rt23720 T4628 T5345 25056097.345697016
Rt23721 T4628 T5486 4816468.6055062767
Rt23722 T4628 T5704 3568626.7416822296
Rt23723 T4628 T6075 2433472.4930575183
Rt23724 T4629 T4630 9856441.6141393352
Rt23725 T4629 T4631 4634113.8622713322
Rt23726 T4629 T4693 11295435.181877468
Rt23727 T4629 T5841 2403597.2711725133
Rt23728 T4630 T4693 3963127.1805928014
Rt23729 T4630 T4714 12959286.442096848
Rt23730 T4630 T5378 4857714.0259580063
Rt23731 T4630 T5696 4008142.551069235
Rt23732 T4631 T4691 5568296.9546805546
Rt23733 T4631 T4692 9364028.5590136033
Rt23734 T4631 T4733 4133382.0828591171
Rt23735 T4631 T5841 9583722.1688531749
Rt23736 T4632 T4705 4688650.115505456
Rt23737 T4632 T4706 13121409.970824441
Rt23738 T4632 T5504 4748484.441061846
Rt23739 T4632 T5895 2765775.3218840053
Rt23740 T4633 T5059 1292506.138856014
Rt23741 T4633 T5323 9585280.3443640471
Rt23742 T4633 T5324 17432014.612588037
Rt23743 T4633 T5583 2966571.0687547447
Rt23744 T4634 T5432 5893135.9872722598
Rt23745 T4634 T5501 4767906.5624638824
Rt23746 T4634 T5689 5042446.8195653828
Rt23747 T4634 T5862 3475796.6901662643
Rt23748 T4635 T5413 4885455.5071631912
Rt23749 T4635 T5414 10676953.710250255
Rt23750 T4635 T5415 1401464.8123136787
Rt23751 T4635 T5591 10308039.995639274
Rt23752 T4636 T5461 4060700.5958053479
Rt23753 T4636 T5469 3952732.2589206388
Rt23754 T4636 T5470 10413234.085265318
Rt23755 T4636 T5694 3177779.0774936541
Rt23756 T4637 T5364 19474198.591169406
Rt23757 T4637 T5462 4410280.9665421508
Rt23758 T4637 T5717 3073853.9282161938
Rt23759 T4637 T5741 4373938.6919517247
Gcorr7909 T4638 T5228 T4638 T5228 -1.6056873165941045e-08
Rt23760 T4638 T5442 3601193.2600560905
Rt23761 T4638 T5898 2673621.4858635771
Rt23762 T4638 T5963 18025222.66104015
Rt23763 T4638 T5964 25719132.953725178
Rt23764 T4639 T4640 4727303.2806111258
Rt23765 T4639 T4641 4718897.4471761035
Rt23766 T4639 T5451 9075918.8705801684
Rt23767 T4639 T5518 4688006.8168168524
Rt23768 T4640 T4641 5266647.4349233732
Rt23769 T4640 T4642 10590028.587903596
Rt23770 T4640 T5050 4865482.9100944474
Rt23771 T4640 T5465 10294484.314868633
Rt23772 T4641 T4642 4532159.1052229358
Rt23773 T4641 T4643 4335520.4665315831
Rt23774 T4641 T4644 10033791.263680998
Rt23775 T4641 T5451 2777451.5963334427
Rt23776 T4642 T4643 8897832.274115907
Rt23777 T4642 T4724 3323379.1860131011
Rt23778 T4642 T5050 3553915.3769654622
Rt23779 T4642 T5637 1484336.9640598772
Rt23780 T4643 T4644 4699716.1098895539
Rt23781 T4643 T4645 4693921.7800733438
Rt23782 T4643 T4724 4585886.5293295756
Rt23783 T4643 T5692 4450304.0617865622
Rt23784 T4644 T4645 4414354.2325240979
Rt23785 T4644 T4646 3041524.8389723036
Rt23786 T4644 T5353 10129346.282154001
Rt23787 T4644 T5451 1704266.104136233
Rt23788 T4645 T4646 4678107.9959348245
Rt23789 T4645 T4661 10014822.167416962
Rt23790 T4645 T4736 4569306.7036597878
Rt23791 T4645 T5692 9593174.0459307879
Rt23792 T4646 T4661 4262963.0198120112
Rt23793 T4646 T4662 12158597.800546682
Rt23794 T4646 T4817 4796827.2266647862
Rt23795 T4646 T5353 2600373.1232381812
Rt23796 T4647 T5467 1196942.3680765312
Rt23797 T4647 T5468 4195150.3763174042
Rt23798 T4647 T5583 10888636.980600383
Rt23799 T4647 T6025 2536306.6526657064
Rt23800 T4648 T4649 4714183.3648328604
Rt23801 T4648 T4650 4323852.3535121977
Rt23802 T4648 T5464 10015766.922204096
Rt23803 T4648 T5474 2927655.8348690262
Rt23804 T4649 T4650 4639326.3028053874
Rt23805 T4649 T4651 2486885.4855254684
Rt23806 T4649 T5373 13118745.911150234
Rt23807 T4649 T5665 4268276.6313531622
Rt23808 T4650 T4651 3800942.5103016831
Rt23809 T4650 T4725 9595278.8540954292
Rt23810 T4650 T4933 4827871.0676565245
Rt23811 T4650 T5474 10266065.725776128
Rt23812 T4651 T4725 1642821.8862154987
Rt23813 T4651 T4726 3748014.2595317438
Rt23814 T4651 T4788 11570524.736285945
Rt23815 T4651 T5373 5791211.9704023628
Gcorr7910 T4652 T5419 T4652 T5419 -1.4401300088669742e-08
Rt23816 T4652 T5480 5687832.9892871287
Rt23817 T4652 T5488 17454913.121081095
Rt23818 T4652 T6018 4895409.7438804405
Rt23819 T4652 T6049 2281183.9018672281
Rt23820 T4653 T4678 4594563.5056698415
Rt23821 T4653 T4679 2971361.6635235478
Rt23822 T4653 T5516 4746587.3853565929
Rt23823 T4653 T5630 10733428.497455446
Rt23824 T4654 T4655 10145206.19178836
Rt23825 T4654 T4656 1766009.9847898053
Rt23826 T4654 T4882 10407927.972573364
Rt23827 T4654 T5507 5197641.2098352518
Rt23828 T4655 T4656 1925704.4162227276
Rt23829 T4655 T4657 9461147.3933208697
Rt23830 T4655 T4659 2789923.2531687636
Rt23831 T4655 T5720 3832170.2062420854
Rt23832 T4656 T4657 4583532.7807684513
Rt23833 T4656 T4658 5286203.0714930864
Rt23834 T4656 T4882 1794338.3378819202
Rt23835 T4656 T5824 3867678.2102568108
Rt23836 T4657 T4658 4642671.2538755005
Rt23837 T4657 T4659 4456333.7224306967
Rt23838 T4657 T4687 10602806.326585291
Rt23839 T4657 T5632 2831310.5352152837
Rt23840 T4658 T5424 9652661.3865053002
Rt23841 T4658 T5632 4500800.873008294
Rt23842 T4658 T5633 2680514.2286617039
Rt23843 T4658 T5824 3562237.2175180931
Rt23844 T4659 T4687 4391332.0587928165
Rt23845 T4659 T4688 1626120.5796476863
Rt23846 T4659 T5010 3343792.1485366225
Rt23847 T4659 T5720 7280034.2923777346
Rt23848 T4660 T5540 12777158.305050377
Rt23849 T4660 T5548 4967349.6836172324
Rt23850 T4660 T5866 3491903.6983034494
Rt23851 T4660 T6087 3343719.5868008481
Rt23852 T4661 T4662 4413524.4772203118
Rt23853 T4661 T4736 1840162.8315674677
Rt23854 T4661 T4751 5680974.2480432177
Rt23855 T4661 T5944 3605146.9770051916
Rt23856 T4662 T4751 11295525.075112285
Rt23857 T4662 T4817 11273009.100539546
Rt23858 T4662 T5034 5390542.8780724257
Rt23859 T4662 T5603 3393378.5405553421
Gcorr7911 T4663 T5428 T4663 T5428 -3.2775355166832077e-08
Rt23860 T4663 T5636 3573684.3668359709
Rt23861 T4663 T5732 2976196.7026746906
Rt23862 T4663 T5976 2459737.2729977183
Rt23863 T4664 T4665 4101129.4690269646
Rt23864 T4664 T4684 3926112.416488321
Rt23865 T4664 T4710 11789187.199035263
Rt23866 T4664 T5574 3669935.0306190639
Rt23867 T4665 T4666 10535520.651615841
Rt23868 T4665 T4667 4558528.9501847234
Rt23869 T4665 T4683 4369409.6950843781
Rt23870 T4665 T5574 9748402.080846522
Rt23871 T4666 T4667 4535904.3464152785
Rt23872 T4666 T4668 4860716.6718143364
Rt23873 T4666 T4854 5014711.9947189083
Rt23874 T4666 T5545 6458554.9423955418
Rt23875 T4667 T4668 10677604.090227179
Rt23876 T4667 T4669 4474734.6307582268
Rt23877 T4667 T4683 10318542.408781078
Rt23878 T4667 T5531 4337170.5037746737
Rt23879 T4668 T4669 4513015.8580452744
Rt23880 T4668 T4670 4412837.0154927662
Rt23881 T4668 T4854 4735503.4229388237
Rt23882 T4668 T5517 4590513.4807998361
Rt23883 T4669 T4670 4530662.4158647889
Rt23884 T4669 T4671 4537218.4487164291
Rt23885 T4669 T4682 4143754.7514987462
Rt23886 T4669 T5531 4388918.0758727426
Rt23887 T4670 T4671 10619783.361066256
Rt23888 T4670 T4672 4900039.1099852351
Rt23889 T4670 T5493 4649644.6031909622
Rt23890 T4670 T5517 10177287.595490832
Rt23891 T4671 T4672 4553207.562042905
Rt23892 T4671 T4673 4831617.5945322281
Rt23893 T4671 T4682 2190582.3750350974
Rt23894 T4671 T5719 2422322.5638026241
Rt23895 T4672 T4673 10506476.886287542
Rt23896 T4672 T4674 3077545.3530677222
Rt23897 T4672 T4675 4894424.5408995999
Rt23898 T4672 T5493 5310635.0117964642
Rt23899 T4673 T4674 1790153.2706998799
Rt23900 T4673 T5585 11649753.812277388
Rt23901 T4673 T5719 9882068.7141283844
Rt23902 T4673 T5795 3982228.4809386767
Rt23903 T4674 T4675 2875225.2760914643
Rt23904 T4674 T4676 1486502.4405510081
Rt23905 T4674 T4677 4197502.4028107235
Rt23906 T4674 T5585 4455161.2068819636
Rt23907 T4675 T4676 10534593.015989112
Rt23908 T4675 T4741 4721615.0939736087
Rt23909 T4675 T4747 9663955.7137041949
Rt23910 T4675 T5493 4647706.2747011762
Rt23911 T4676 T4677 10023987.514847819
Rt23912 T4676 T4741 4752685.9998942427
Rt23913 T4676 T4742 10994138.062600739
Rt23914 T4676 T5867 4333864.9993266184
Rt23915 T4677 T5579 434532201.74758732
Rt23916 T4677 T5585 10166774.067202618
Rt23917 T4677 T5586 1509693.3958778961
Rt23918 T4677 T5867 3606063.9524647198
Rt23919 T4678 T4679 8205735.3421189319
Rt23920 T4678 T4721 4079474.7736644684
Rt23921 T4678 T4827 14458077.351625333
Rt23922 T4678 T5552 3492672.8531866004
Rt23923 T4679 T4721 2579762.9458018071
Rt23924 T4679 T4722 1506463.393632534
Rt23925 T4679 T4754 4592332.0300240843
Rt23926 T4679 T5630 1562477.0725685053
Rt23927 T4680 T4681 8705393.1844014507
Rt23928 T4680 T4719 8553337.9623838272
Rt23929 T4680 T4720 3470860.5599662922
Rt23930 T4680 T5469 4312568.1410776954
Rt23931 T4681 T4719 4475237.4024204873
Rt23932 T4681 T4758 4350777.3663734673
Rt23933 T4681 T5299 3643530.8247781196
Rt23934 T4681 T5472 8983559.5826671887
Rt23935 T4682 T5318 4077480.5605755337
Rt23936 T4682 T5531 10347830.665240342
Rt23937 T4682 T5664 1783139.9916191667
Rt23938 T4682 T5719 7902565.7658475572
Rt23939 T4683 T5531 3621947.2597650434
Rt23940 T4683 T5532 3791121.2156570032
Rt23941 T4683 T5533 11754301.758557351
Rt23942 T4683 T5574 3930673.4977042973
Rt23943 T4684 T4710 3739320.3645646572
Rt23944 T4684 T4711 12661573.972639203
Rt23945 T4684 T5680 3964305.038681333
Rt23946 T4684 T5957 3889059.0687061371
Rt23947 T4685 T4686 3914015.9808111456
Rt23948 T4685 T4766 5295744.4767352501
Rt23949 T4685 T5342 25098867.617463991
Rt23950 T4685 T5504 3900110.5721132657
Rt23951 T4686 T4766 4582447.9816342061
Rt23952 T4686 T4844 13284576.374280598
Rt23953 T4686 T4878 27035851.889747448
Rt23954 T4686 T5787 2038049.6183694741
Rt23955 T4687 T4688 9444370.3675267901
Rt23956 T4687 T4752 4574875.1585644251
Rt23957 T4687 T4767 21931916.102450792
Rt23958 T4687 T5632 1608810.0628702436
Rt23959 T4688 T4752 1658583.3939911334
Rt23960 T4688 T4753 25083774.776521064
Rt23961 T4688 T5010 12908508.518675486
Rt23962 T4688 T5941 4194222.0575471413
Rt23963 T4689 T5730 8465090.3286551237
Rt23964 T4689 T5731 4146036.2639366672
Rt23965 T4689 T5746 3624340.0931568132
Rt23966 T4689 T6035 6881740.4754289016
Rt23967 T4690 T5440 9527717.7118641157
Rt23968 T4690 T5441 2087255.1925133129
Rt23969 T4690 T5797 5125384.6042688563
Rt23970 T4690 T5901 3263837.6708357912
Rt23971 T4691 T4692 10094153.425719272
Rt23972 T4691 T4757 4635310.2926451759
Rt23973 T4691 T5037 4348506.421506742
Rt23974 T4691 T5450 1274028.3769842414
Rt23975 T4692 T4733 2794217.3581209574
Rt23976 T4692 T4734 5629035.9316559443
Rt23977 T4692 T4757 4003609.4718372459
Rt23978 T4692 T5445 10157556.351960128
Rt23979 T4693 T4714 2871163.6974220756
Rt23980 T4693 T4830 7886534.9990848228
Rt23981 T4693 T5607 120056198.40471919
Rt23982 T4693 T5841 2537087.2374226623
Rt23983 T4694 T5563 4654581.7588453125
Rt23984 T4694 T5621 4794824.3131075436
Rt23985 T4694 T5651 4184773.2588615981
Rt23986 T4694 T5970 13132053.634411657
Rt23987 T4695 T4696 3978924.7218067762
Rt23988 T4695 T4760 3976799.26357299
Rt23989 T4695 T4761 13027095.242010359
Rt23990 T4695 T5478 3990192.0896276585
Rt23991 T4696 T4697 10628459.673133325
Rt23992 T4696 T4717 3892287.7745644399
Rt23993 T4696 T4760 11141905.13560798
Rt23994 T4696 T5812 3790342.1211888376
Rt23995 T4697 T4717 3313400.9369282108
Rt23996 T4697 T4718 4445313.4636119083
Rt23997 T4697 T6004 2516616.3804883999
Rt23998 T4697 T6077 5011668.3696167795
Rt23999 T4698 T5463 3793048.4908659831
Rt24000 T4698 T5472 11273600.858591793
Rt24001 T4698 T5742 3554416.4198782798
Rt24002 T4698 T5908 4303523.2791546835
Rt24003 T4699 T4700 2910292.3109572465
Rt24004 T4699 T4701 5124655.2816961817
Rt24005 T4699 T4715 4195591.3393628029
Rt24006 T4699 T5652 9882279.1744067967
Rt24007 T4700 T4702 9762199.3301679101
Rt24008 T4700 T4703 2330005.2571122944
Rt24009 T4700 T4730 5397627.923510056
Rt24010 T4700 T5652 4322101.0698937224
Rt24011 T4701 T4715 5191040.823770958
Rt24012 T4701 T4716 4510551.4816953233
Rt24013 T4701 T5398 5177943.2208622247
Rt24014 T4701 T5453 2958912.8748802654
Rt24015 T4702 T4703 1553920.4668452132
Rt24016 T4702 T4704 11460217.440967981
Rt24017 T4702 T5178 3763520.9692871007
Rt24018 T4702 T5412 4446026.8685068749
Rt24019 T4703 T4704 4417795.4393666852
Rt24020 T4703 T4730 11201866.864357896
Rt24021 T4703 T4731 5503347.6368996045
Rt24022 T4703 T6063 3298184.7366619809
Rt24023 T4704 T4731 11099120.143685106
Rt24024 T4704 T4732 5274230.1882592831
Rt24025 T4704 T5178 6183824.0461955871
Rt24026 T4704 T5997 4669623.0072227726
Rt24027 T4705 T4706 4520810.9012566898
Rt24028 T4705 T4762 3275732.8598474674
Rt24029 T4705 T4820 9242493.8338266127
Rt24030 T4705 T5506 2809939.1940574008
Rt24031 T4706 T4762 10433689.000026563
Rt24032 T4706 T4763 4110367.9811479715
Rt24033 T4706 T4764 11832287.515653683
Rt24034 T4706 T5895 3783572.8484437242
Rt24035 T4707 T4708 3417941.7850942705
Rt24036 T4707 T4738 8003274.5981958741
Rt24037 T4707 T4739 9876704.0873179678
Rt24038 T4707 T5955 5877839.8337613298
Rt24039 T4708 T5015 4240871.0590999909
Rt24040 T4708 T5016 9104752.9244155381
Rt24041 T4708 T5017 10758293.082661966
Rt24042 T4708 T5955 2760661.9433699446
Rt24043 T4709 T4883 9644143.5943546426
Rt24044 T4709 T4884 4689421.1919609224
Rt24045 T4709 T5046 4029409.8275377885
Rt24046 T4709 T5554 1533726.1031883231
Rt24047 T4710 T4711 4169278.6567873633
Rt24048 T4710 T4828 16997292.327687416
Rt24049 T4710 T5574 4019869.129691219
Rt24050 T4710 T5937 3331217.0783854597
Rt24051 T4711 T4828 3962586.8669411214
Rt24052 T4711 T4829 9969830.375128096
Rt24053 T4711 T5150 5479479.817793794
Rt24054 T4711 T5957 654737.84170096321
Rt24055 T4712 T4713 4675711.493250886
Rt24056 T4712 T4737 13289221.97874354
Rt24057 T4712 T4843 16777104.499776125
Rt24058 T4712 T6032 1230307.507416693
Rt24059 T4713 T4843 3509742.1934992052
Rt24060 T4713 T4865 21189924.417454153
Rt24061 T4713 T5109 6375815.1399661712
Rt24062 T4713 T5346 265257955.3204318
Rt24063 T4713 T5991 4633500.4909412926
Rt24064 T4714 T4830 3751145.9419125319
Rt24065 T4714 T4858 4841327.6535348231
Rt24066 T4714 T5294 76250568.851921335
Rt24067 T4714 T5378 3839871.0390110654
Rt24068 T4715 T4716 10395304.05432638
Rt24069 T4715 T4723 3386303.0196717996
Rt24070 T4715 T5652 4362621.2112775212
Rt24071 T4715 T5800 4064545.2113582715
Rt24072 T4716 T4723 4178784.9148887009
Rt24073 T4716 T4784 10995190.936033104
Rt24074 T4716 T4922 4700710.245088473
Rt24075 T4716 T5398 4845332.7943189815
Rt24076 T4717 T4718 10377492.443581445
Rt24077 T4717 T4818 3683175.0509354468
Rt24078 T4717 T4839 5738990.3517285557
Rt24079 T4717 T5812 7879712.9469045224
Rt24080 T4718 T4818 3876564.4704938228
Rt24081 T4718 T4819 10669771.940974325
Rt24082 T4718 T4889 4722289.7271358045
Rt24083 T4718 T5232 48021093.738086782
Rt24084 T4718 T6077 4649780.4156356351
Rt24085 T4719 T4720 3366935.118977691
Rt24086 T4719 T4758 9897053.967401728
Rt24087 T4719 T4759 3682858.6250831457
Rt24088 T4719 T5596 4263524.605688246
Rt24089 T4720 T5469 10172715.531772245
Rt24090 T4720 T5596 11129553.339467091
Rt24091 T4720 T5739 1555050.279990338
Rt24092 T4720 T6079 7249062.37251045
Rt24093 T4721 T4722 10890032.916779198
Rt24094 T4721 T4827 3360883.9116214449
Rt24095 T4721 T4831 3902054.8655441543
Gcorr7912 T4721 T5809 T4721 T5809 -6.557489778315405e-09
Rt24096 T4722 T4754 8477637.4285128843
Rt24097 T4722 T4831 4391455.743590408
Rt24098 T4722 T4840 10816021.011206554
Rt24099 T4722 T5388 10713612.987035418
Rt24100 T4723 T4784 4309432.6837849319
Rt24101 T4723 T4786 2096042.689088291
Rt24102 T4723 T4857 13103318.137366422
Rt24103 T4723 T5800 6759975.9287967654
Rt24104 T4724 T5637 15045139.594819028
Rt24105 T4724 T5692 4054902.3478394086
Rt24106 T4724 T5956 8982596.7650124095
Rt24107 T4724 T6040 2980293.2436067238
Rt24108 T4725 T4726 3272405.1269032508
Rt24109 T4725 T4885 4467329.0916210394
Rt24110 T4725 T4933 2742548.6840064269
Rt24111 T4725 T5780 3850025.8872917094
Rt24112 T4726 T4788 1050665.4972555987
Rt24113 T4726 T4789 2744730.8383594155
Rt24114 T4726 T4885 10607887.853555452
Rt24115 T4726 T5924 8401115.1460717674
Rt24116 T4727 T4728 1648219.6834916268
Rt24117 T4727 T4877 4714308.7702869447
Rt24118 T4727 T5138 4778719.4984406373
Rt24119 T4727 T5552 4705935.072498057
Rt24120 T4728 T4877 9441621.6563776396
Rt24121 T4728 T4899 3858692.5364409923
Rt24122 T4728 T5028 4509161.3702552328
Rt24123 T4728 T5498 4513835.705678015
Gcorr7913 T4729 T5360 T4729 T5360 -1.7513957320421834e-08
Rt24124 T4729 T5550 4776166.1481388593
Rt24125 T4729 T5551 15605692.053995289
Rt24126 T4729 T5943 9677486.0355808046
Rt24127 T4729 T5982 3172359.2337639024
Rt24128 T4730 T5652 11954292.309043471
Rt24129 T4730 T5844 24049540.554277368
Rt24130 T4730 T6063 3908275.2001189119
Rt24131 T4730 T6076 2473174.0069371494
Rt24132 T4731 T4732 4758143.8292869311
Rt24133 T4731 T4808 5432573.2975476356
Rt24134 T4731 T4836 58350472.791675821
Rt24135 T4731 T6063 3238004.3324443153
Rt24136 T4732 T4808 4099540.9428296108
Rt24137 T4732 T4809 4945389.801752869
Rt24138 T4732 T4872 6480473.5224108081
Rt24139 T4732 T5234 5210906.4936617306
Rt24140 T4732 T5997 6124498.2075834852
Rt24141 T4733 T4734 10683477.406486325
Rt24142 T4733 T5013 4286839.2994633727
Rt24143 T4733 T5607 22154658.791461192
Rt24144 T4733 T5841 3357889.69385286
Rt24145 T4734 T5013 1238091.9253513331
Rt24146 T4734 T5030 18981956.439080492
Rt24147 T4734 T5201 6939562.3410125533
Rt24148 T4734 T5445 3150700.3808045769
Rt24149 T4735 T5634 31028024.615439765
Rt24150 T4735 T5909 5865384.3582951175
Rt24151 T4735 T5969 2296714.2383520962
Rt24152 T4736 T5250 10490706.811977901
Rt24153 T4736 T5369 3499994.5716245091
Rt24154 T4736 T5692 1394906.8777599244
Rt24155 T4736 T5944 1752730.839840021
Rt24156 T4736 T5956 341606.36273779062
Rt24157 T4737 T5409 5090124.1389348805
Rt24158 T4737 T5816 2565870.8932686108
Rt24159 T4737 T5854 1664667.4038891827
Rt24160 T4737 T6032 435079.06980822003
Rt24161 T4738 T4739 4001527.7261779602
Rt24162 T4738 T4740 3483907.0807636874
Rt24163 T4738 T5406 5170397.2291972851
Rt24164 T4738 T5613 5883571.1770615391
Rt24165 T4739 T4740 12345560.333983749
Rt24166 T4739 T4989 2898762.387576648
Rt24167 T4739 T5758 10143524.626426013
Rt24168 T4739 T5955 944846.17275888042
Rt24169 T4740 T4989 4833303.6963616405
Rt24170 T4740 T4990 587725.917874465
Rt24171 T4740 T5052 4953703.996579377
Rt24172 T4740 T5406 26660954.560823586
Rt24173 T4741 T4742 4688713.7633014489
Rt24174 T4741 T4747 2873205.6921906597
Rt24175 T4741 T4880 9598568.761784371
Rt24176 T4741 T5588 2891596.89795527
Rt24177 T4742 T5588 9170070.5377680026
Rt24178 T4742 T5589 4688549.3187964689
Rt24179 T4742 T5618 5920085.4734586803
Rt24180 T4742 T5867 2709277.098682405
Rt24181 T4743 T4744 10619016.309120635
Rt24182 T4743 T4745 17987872.714773625
Rt24183 T4743 T5635 4679132.3481192552
Rt24184 T4743 T5984 2183554.6078413143
Rt24185 T4744 T4745 4827756.1715142084
Rt24186 T4744 T4768 27949618.003497325
Rt24187 T4744 T4769 4769050.3650898384
Rt24188 T4744 T5911 3141995.5390621573
Rt24189 T4745 T4768 5662410.0918300198
Rt24190 T4745 T4833 4768281.2014470827
Gcorr7914 T4745 T4837 T4745 T4837 -6.4486136568881485e-09
Rt24191 T4745 T5984 3606260.9148163931
Rt24192 T4746 T5303 263378984.47170165
Rt24193 T4746 T5314 5546812.6724235388
Rt24194 T4746 T5567 3344873.9961686702
Rt24195 T4746 T5595 8251928.1708738413
Rt24196 T4747 T4880 4562471.5327796321
Rt24197 T4747 T4881 4662895.0195016768
Rt24198 T4747 T5483 4683877.4000310181
Rt24199 T4747 T5493 3162567.571799132
Rt24200 T4748 T4842 4129779.0823084563
Rt24201 T4748 T4886 10688300.967495291
Rt24202 T4748 T5058 4135021.9654340278
Rt24203 T4748 T5458 4158937.5664741965
Rt24204 T4749 T4750 16758758.238369178
Rt24205 T4749 T4986 7287461.6134863039
Rt24206 T4749 T4987 7895721.7093129298
Rt24207 T4749 T5995 3126075.021392954
Rt24208 T4750 T4986 2436227.9854525542
Rt24209 T4750 T4988 1160298.1095804882
Gcorr7915 T4750 T5673 T4750 T5673 -1.4153469019955868e-07
Rt24210 T4750 T5724 631832.93451753131
Rt24211 T4751 T5034 557305.65138977254
Rt24212 T4751 T5035 3662571.1326306527
Rt24213 T4751 T5036 2973078.0933888885
Rt24214 T4751 T5944 7611718.2489128811
Rt24215 T4752 T4753 3582879.4436085792
Rt24216 T4752 T4767 5716444.6471165959
Rt24217 T4752 T4868 2480911.8475697651
Rt24218 T4752 T6072 1128392.2629580179
Rt24219 T4753 T4868 4563356.5302995853
Rt24220 T4753 T4869 17941601.744757906
Rt24221 T4753 T5294 20099002.467151683
Rt24222 T4753 T5735 6160251.2354323128
Rt24223 T4753 T5941 2593384.0559452213
Rt24224 T4754 T5388 4118489.040593103
Rt24225 T4754 T5630 4009000.6670642826
Rt24226 T4754 T5723 2129962.5963644083
Rt24227 T4755 T4756 3027544.5620877445
Gcorr7916 T4755 T5031 T4755 T5031 -8.0618203437320129e-08
Gcorr7917 T4755 T5580 T4755 T5580 -2.4698596632226482e-09
Rt24228 T4755 T5979 3509625.7349794377
Rt24229 T4756 T5031 4295196.1477315389
Rt24230 T4756 T5032 5432494.55002019
Gcorr7918 T4756 T5033 T4756 T5033 -1.433307871968108e-07
Rt24231 T4756 T5655 6936256.9818787156
Rt24232 T4757 T5037 4660184.2676653229
Rt24233 T4757 T5127 4557569.5097820917
Rt24234 T4757 T5179 8597775.4528612439
Rt24235 T4757 T5445 2492225.0124617196
Rt24236 T4758 T4759 4535392.6123284148
Rt24237 T4758 T4940 4582173.4295654939
Rt24238 T4758 T5299 15655032.707687305
Rt24239 T4758 T5921 2802202.7080643564
Rt24240 T4759 T4940 10987212.440027082
Rt24241 T4759 T4941 914467.50598900882
Rt24242 T4759 T4942 3523910.1359673953
Rt24243 T4759 T5596 10495065.942690784
Rt24244 T4760 T4761 4165064.4221632127
Rt24245 T4760 T4855 14794822.90388583
Rt24246 T4760 T5812 3739237.6491925614
Rt24247 T4760 T5914 3785462.0381095409
Rt24248 T4761 T4855 4078359.4494064124
Rt24249 T4761 T4856 20442050.950223483
Rt24250 T4761 T5478 14507991.680972748
Rt24251 T4761 T5968 2590352.6791956061
Rt24252 T4762 T4763 4455195.6440362027
Rt24253 T4762 T4820 4795329.3217696352
Rt24254 T4762 T4870 10505210.991867587
Rt24255 T4762 T5454 4684801.6926012151
Rt24256 T4763 T4764 4351508.6741431104
Rt24257 T4763 T4765 11927501.398339439
Rt24258 T4763 T4870 4500274.7390592145
Rt24259 T4763 T5715 2822870.108207305
Rt24260 T4764 T4765 2710469.3976841872
Rt24261 T4764 T4879 2993623.971809742
Rt24262 T4764 T5342 739870569.99537599
Rt24263 T4764 T5895 2975709.3169151968
Rt24264 T4765 T4879 11424372.014188664
Rt24265 T4765 T5039 13836876.023089999
Rt24266 T4765 T5157 5960575.3294144999
Rt24267 T4765 T5715 3054542.87896743
Rt24268 T4766 T4844 3374226.173049029
Rt24269 T4766 T4897 40224347.614027545
Rt24270 T4766 T5342 5283193.210787978
Rt24271 T4766 T5691 5083599.683849683
Rt24272 T4767 T5632 5228364.292991301
Gcorr7919 T4767 T5668 T4767 T5668 -4.8028927703090444e-08
Rt24273 T4767 T5669 34301000.502284423
Rt24274 T4767 T5999 2489611.2054506834
Rt24275 T4767 T6072 3118110.4519114811
Rt24276 T4768 T4769 4845399.2726127021
Rt24277 T4768 T4833 134695663.26980105
Gcorr7920 T4768 T4932 T4768 T4932 -1.6446423279400448e-08
Rt24278 T4768 T5903 3422477.107319871
Rt24279 T4769 T4932 6284117.7338293577
Gcorr7921 T4769 T5716 T4769 T5716 -1.813108156732195e-08
Gcorr7922 T4769 T5769 T4769 T5769 -6.5084696819335763e-08
Rt24280 T4769 T5837 2539400.1016530781
Rt24281 T4769 T5911 19249976.989202503
Rt24282 T4770 T4771 4841067.5693767723
Rt24283 T4770 T4772 10196201.58598185
Rt24284 T4770 T5141 1825508.7365370824
Rt24285 T4770 T5438 11776177.564573433
Rt24286 T4771 T4772 3105376.4043698711
Rt24287 T4771 T4773 9411264.4443816002
Rt24288 T4771 T5417 11273421.015739791
Rt24289 T4771 T5543 4609681.3926013093
Rt24290 T4772 T4773 975814.50405845675
Rt24291 T4772 T4774 10630590.349264946
Rt24292 T4772 T5141 1900204.7694522152
Rt24293 T4772 T5536 3625104.8024618244
Rt24294 T4773 T4774 4779116.6831863681
Rt24295 T4773 T4775 1904245.1036110274
Rt24296 T4773 T4777 4974003.6088297283
Rt24297 T4773 T5543 2520424.7743134266
Rt24298 T4774 T4775 10569176.627880614
Rt24299 T4774 T4776 1888397.3942749328
Rt24300 T4774 T4810 10595331.946396181
Rt24301 T4774 T5536 1834923.3809641341
Rt24302 T4775 T4776 4548401.5789280115
Rt24303 T4775 T4777 10435747.843828762
Rt24304 T4775 T4778 1919101.0283819686
Rt24305 T4775 T5509 10573657.075245617
Rt24306 T4776 T4810 1895479.6723848274
Rt24307 T4776 T4811 4956583.0857815929
Rt24308 T4776 T4838 4850761.0074315136
Rt24309 T4776 T5509 4560489.2297991067
Rt24310 T4777 T4778 4755513.4502707478
Rt24311 T4777 T4779 10815683.225238627
Rt24312 T4777 T5543 10186056.583523447
Rt24313 T4777 T5568 1661283.8869868284
Rt24314 T4778 T4779 4945763.3611502554
Rt24315 T4778 T4780 4639857.1289239824
Rt24316 T4778 T5509 2830865.6397272474
Rt24317 T4778 T5511 2831535.5497979368
Rt24318 T4779 T4780 10643297.116772821
Rt24319 T4779 T4781 1330314.6650307423
Rt24320 T4779 T4862 10497711.559360383
Rt24321 T4779 T5568 1886977.3837236827
Rt24322 T4780 T4781 4165076.1620177007
Rt24323 T4780 T4782 4462470.096030511
Rt24324 T4780 T4958 10780320.212207984
Rt24325 T4780 T5511 4300071.7280648164
Rt24326 T4781 T4782 2916035.471587786
Rt24327 T4781 T4783 1873589.8468231526
Rt24328 T4781 T4862 4757495.9445402892
Rt24329 T4781 T5666 4463419.142184563
Rt24330 T4782 T4783 9819796.7539410479
Rt24331 T4782 T4834 10044160.897058113
Rt24332 T4782 T4958 4021658.6388243428
Rt24333 T4782 T5744 2402671.5158146597
Rt24334 T4783 T4834 4197593.4298508484
Rt24335 T4783 T4835 12038951.447054872
Rt24336 T4783 T4943 1685032.549778725
Rt24337 T4783 T5666 8908607.5614613127
Rt24338 T4784 T4786 10569529.224058108
Rt24339 T4784 T4922 3592174.3970610816
Rt24340 T4784 T4923 4513295.7023566365
Rt24341 T4784 T5806 4338813.7465964518
Rt24342 T4785 T4787 10673961.150643298
Rt24343 T4785 T5064 5079203.8729556501
Gcorr7923 T4785 T5710 T4785 T5710 -8.5538366036546387e-08
Rt24344 T4785 T5807 1683660.6990768479
Gcorr7924 T4785 T6030 T4785 T6030 -7.5506896738135065e-08
Rt24345 T4786 T4857 2142060.8322943198
Rt24346 T4786 T4887 12463932.215229969
Rt24347 T4786 T5159 6620471.8636975298
Rt24348 T4786 T5806 3274183.7262857798
Rt24349 T4787 T5064 913466.1464879394
Rt24350 T4787 T5180 2101499.8370378106
Gcorr7925 T4787 T5673 T4787 T5673 -4.0482997440251484e-09
Gcorr7926 T4787 T5875 T4787 T5875 -1.0290412396478854e-07
Rt24351 T4787 T6069 12694209.279494787
Rt24352 T4788 T4789 12652811.997596087
Rt24353 T4788 T4936 5261653.3112966903
Rt24354 T4788 T5254 10755822.311090939
Rt24355 T4788 T5373 4361399.1553750969
Rt24356 T4789 T4936 4657403.1346680494
Rt24357 T4789 T4937 2716211.5809268169
Gcorr7927 T4789 T5793 T4789 T5793 -1.9112789337433418e-08
Rt24358 T4789 T5924 3164189.5668922053
Rt24359 T4790 T4791 4470105.492453522
Rt24360 T4790 T4792 4623682.0158687113
Rt24361 T4790 T5147 4931787.840065226
Rt24362 T4790 T5471 4016311.2844601399
Rt24363 T4791 T4792 10527402.938541397
Rt24364 T4791 T4793 4385306.5677612964
Rt24365 T4791 T4794 4399029.2749578673
Rt24366 T4791 T5459 10565291.490439003
Rt24367 T4792 T4793 4487001.8362568123
Rt24368 T4792 T4795 4139215.0183382775
Rt24369 T4792 T5147 4496628.7531490037
Rt24370 T4792 T5449 4906021.0741696684
Rt24371 T4793 T4794 4415296.49623603
Rt24372 T4793 T4795 4374483.3310328769
Rt24373 T4793 T4796 4018765.0756302597
Rt24374 T4793 T5644 10799363.789835591
Rt24375 T4794 T5459 4337882.0595755195
Rt24376 T4794 T5644 4709028.0946585797
Rt24377 T4794 T5802 11706868.878719572
Rt24378 T4794 T5972 3435359.2724709851
Rt24379 T4795 T4796 9286389.2662136033
Rt24380 T4795 T4846 4204855.6028836928
Rt24381 T4795 T4847 4073878.5356787131
Rt24382 T4795 T5449 10836142.09399889
Rt24383 T4796 T4846 4064711.1140231187
Rt24384 T4796 T4863 4221820.3392360955
Rt24385 T4796 T4864 20063804.043741174
Rt24386 T4796 T5644 3605498.4024901539
Rt24387 T4797 T4798 10375311.209225021
Rt24388 T4797 T4799 3670819.5022884971
Rt24389 T4797 T5148 4504672.8538995571
Rt24390 T4797 T5482 9991241.7132430207
Rt24391 T4798 T4799 1290357.2097478579
Rt24392 T4798 T4800 9236738.2608708851
Rt24393 T4798 T5394 5081002.9615678024
Rt24394 T4798 T5542 4680134.9539807979
Rt24395 T4799 T4800 4513237.7354610022
Rt24396 T4799 T4801 15264870.307306087
Rt24397 T4799 T5148 5009169.8488099109
Rt24398 T4799 T5980 2831539.6187893641
Rt24399 T4800 T4801 9350630.3008836303
Rt24400 T4800 T4802 3609022.8889549784
Rt24401 T4800 T4803 4340202.0377665842
Rt24402 T4800 T5394 3899560.0702454024
Rt24403 T4801 T4802 3962263.8343642298
Rt24404 T4801 T4806 10035983.497447917
Rt24405 T4801 T4866 4913391.2650760496
Rt24406 T4801 T5980 2466689.1928420616
Rt24407 T4802 T4803 10405849.517998785
Rt24408 T4802 T4804 3993015.3630931387
Rt24409 T4802 T4806 11382046.998703739
Rt24410 T4802 T5820 3049115.043279497
Rt24411 T4803 T4804 4817441.1177256154
Rt24412 T4803 T4805 5315887.738171869
Rt24413 T4803 T5331 3911405.8760941476
Rt24414 T4803 T5394 9498518.5248060357
Rt24415 T4804 T4805 5344675.9085125215
Rt24416 T4804 T4859 3409553.9879736183
Rt24417 T4804 T4861 3619608.5105226985
Rt24418 T4804 T5820 8101470.4948138855
Rt24419 T4805 T4859 3678708.8876671935
Rt24420 T4805 T4860 13188444.544619443
Rt24421 T4805 T4934 11562121.140152857
Rt24422 T4805 T5331 3015871.6498159152
Rt24423 T4806 T4866 3315774.340027519
Rt24424 T4806 T4867 3095735.0162294591
Rt24425 T4806 T5820 771823.49315605185
Gcorr7928 T4806 T5821 T4806 T5821 -7.1116559147998417e-08
Rt24426 T4807 T5497 10241433.467199115
Rt24427 T4807 T5513 4624116.2876238422
Rt24428 T4807 T5541 4198714.0995360808
Rt24429 T4807 T5584 3839575.1622697287
Rt24430 T4808 T4809 17303258.118839476
Rt24431 T4808 T4836 4601532.1376751978
Rt24432 T4808 T5244 18148005.590176329
Rt24433 T4808 T5885 4362385.5906729912
Rt24434 T4809 T4872 5461234.9060827093
Rt24435 T4809 T4873 1012503.2645948485
Rt24436 T4809 T4874 2518461.6515260963
Rt24437 T4809 T5885 15477443.17063598
Rt24438 T4810 T4811 9928034.9288065154
Rt24439 T4810 T4812 3576791.3638691111
Rt24440 T4810 T5156 5011362.6864777477
Rt24441 T4810 T5536 4966808.7851826828
Rt24442 T4811 T4812 4830273.8470809972
Rt24443 T4811 T4813 10423980.735341871
Rt24444 T4811 T4838 10136726.309641093
Rt24445 T4811 T5654 1104395.6222365641
Rt24446 T4812 T4813 4481861.0005763369
Rt24447 T4812 T4814 4567941.5957175279
Rt24448 T4812 T5156 8729421.2456806973
Rt24449 T4812 T5399 3277276.9915445279
Rt24450 T4813 T4814 10691188.92819532
Rt24451 T4813 T4925 4111498.6966391541
Rt24452 T4813 T4926 15608813.820422633
Rt24453 T4813 T5654 1488082.1631312978
Rt24454 T4814 T4925 2984120.9484110894
Rt24455 T4814 T4927 4564370.9832337024
Rt24456 T4814 T4947 11950907.220123595
Rt24457 T4814 T5399 3850133.8439662764
Rt24458 T4815 T5423 4695036.1706030229
Rt24459 T4815 T5539 10281071.693198634
Rt24460 T4815 T5570 4883865.4928126866
Rt24461 T4815 T5766 10365718.506936733
Gcorr7929 T4816 T5658 T4816 T5658 -7.7837951369985758e-08
Rt24462 T4816 T5659 20367889.714993183
Rt24463 T4816 T5660 1446104.4842794293
Rt24464 T4816 T5864 1602389.2341149661
Rt24465 T4816 T5915 1349556.3739797359
Rt24466 T4817 T5353 13157848.221316148
Rt24467 T4817 T5354 1669651.0720675352
Rt24468 T4817 T5481 10515119.58371086
Rt24469 T4817 T5603 4017088.7705196599
Rt24470 T4818 T4819 3483377.0957493228
Rt24471 T4818 T4839 15194018.063363502
Rt24472 T4818 T4924 9820582.2713714242
Rt24473 T4818 T6082 3304987.121329647
Rt24474 T4819 T4889 10197155.656570241
Rt24475 T4819 T4890 3418616.4603137467
Rt24476 T4819 T4924 8634646.8597912863
Rt24477 T4819 T5830 2937075.0548837562
Rt24478 T4820 T5454 5129521.7861990184
Rt24479 T4820 T5506 4740680.0061971983
Rt24480 T4820 T5600 11396784.518425012
Rt24481 T4820 T5702 3235254.1330235675
Rt24482 T4821 T5488 3669692.3448877987
Rt24483 T4821 T5503 27051708.365407806
Rt24484 T4821 T6046 6151532.7800533362
Rt24485 T4821 T6089 2941150.9494978194
Rt24486 T4822 T5502 9173392.8775652722
Rt24487 T4822 T5639 2875589.6640892001
Rt24488 T4822 T5722 3904236.7198984171
Rt24489 T4822 T6070 3273238.2967167068
Rt24490 T4823 T5749 7642513.6912100986
Rt24491 T4823 T5873 6793048.790508206
Rt24492 T4823 T5934 702724.70305686444
Rt24493 T4823 T6016 2936032.3083462794
Rt24494 T4824 T4825 4449389.9546844335
Rt24495 T4824 T4955 4427955.4017865146
Gcorr7930 T4824 T5295 T4824 T5295 -1.9531373035780536e-08
Rt24496 T4824 T5873 2945186.7898495025
Rt24497 T4825 T4955 30660717.525292184
Rt24498 T4825 T5009 6291597.56185704
Rt24499 T4825 T5126 5097906.7916961741
Rt24500 T4825 T5304 4737548.1982089086
Rt24501 T4826 T5117 4634248.1309659528
Rt24502 T4826 T5241 4943923.5760303242
Rt24503 T4826 T5242 3619614.362893228
Rt24504 T4826 T5590 803145.22035190533
Rt24505 T4827 T5552 4724461.0009364579
Rt24506 T4827 T5783 8204991.5671871537
Rt24507 T4827 T5808 3136251.5440505524
Rt24508 T4827 T5809 8936315.6911231987
Rt24509 T4828 T4829 4298725.5688860435
Rt24510 T4828 T4950 10989162.861002376
Rt24511 T4828 T5038 5914119.3115387689
Rt24512 T4828 T5937 3000487.3366392632
Rt24513 T4829 T4950 5623768.5644776709
Rt24514 T4829 T4992 3697793.3920121724
Rt24515 T4829 T5150 4127107.7404157934
Rt24516 T4829 T5847 36104406.181133419
Rt24517 T4830 T4858 17934377.543723926
Rt24518 T4830 T5118 4334928.2618586589
Rt24519 T4830 T5168 99616738.748836428
Rt24520 T4830 T5607 7911028.9074493833
Rt24521 T4831 T4840 4608291.9907041015
Rt24522 T4831 T4961 4216451.0932560526
Rt24523 T4831 T4962 108734811.84815757
Rt24524 T4831 T5809 3014712.5027691741
Rt24525 T4832 T5614 5086944.1547076376
Rt24526 T4832 T5918 3765302.278601483
Rt24527 T4832 T5983 3329173.9409871763
Rt24528 T4832 T5998 4663822.5625734376
Rt24529 T4833 T4837 1395728.6296852245
Gcorr7931 T4833 T4994 T4833 T4994 -1.0205674441628461e-08
Rt24530 T4833 T5067 4790473.7609872585
Rt24531 T4833 T5903 2894143.2185439561
Rt24532 T4834 T4835 4464131.7097265813
Rt24533 T4834 T5594 4403529.685486828
Rt24534 T4834 T5744 1231931.7476302758
Rt24535 T4834 T5878 53721165.536134973
Rt24536 T4835 T4943 4664276.9669011347
Rt24537 T4835 T4944 10908915.28206229
Rt24538 T4835 T4945 4425595.0966069307
Rt24539 T4835 T5594 11984735.469774095
Rt24540 T4836 T5244 3011497.5660562115
Rt24541 T4836 T5844 3465387.2709997199
Rt24542 T4836 T5845 14879593.693801504
Rt24543 T4836 T6063 2145037.8482585619
Rt24544 T4837 T4994 4230831.550892395
Gcorr7932 T4837 T4995 T4837 T4995 -1.8970406767772773e-08
Gcorr7933 T4837 T5133 T4837 T5133 -8.2055507917998309e-10
Rt24545 T4837 T5224 970588.01811995439
Gcorr7934 T4837 T5984 T4837 T5984 -1.0905437100548344e-07
Rt24546 T4838 T5509 9334596.8526565563
Rt24547 T4838 T5510 3761858.9372213893
Rt24548 T4838 T5654 3548118.7061275705
Rt24549 T4838 T6060 3157762.8640423878
Rt24550 T4839 T5812 2610062.4473233861
Rt24551 T4839 T6082 2173530.762026309
Rt24552 T4839 T6084 368665.73148359329
Rt24553 T4840 T4961 17400178.791352373
Rt24554 T4840 T5134 7150068.8395835664
Rt24555 T4840 T5388 3142351.3046403574
Rt24556 T4840 T5838 3872663.3546729945
Rt24557 T4841 T5247 2222859.0761745586
Rt24558 T4841 T5264 18429910.137055352
Rt24559 T4841 T5270 4520909.4495415706
Rt24560 T4841 T5593 4257512.2663206365
Rt24561 T4841 T6085 8367962.7195059881
Rt24562 T4842 T4886 4122512.1422600891
Rt24563 T4842 T5139 10808392.260720257
Rt24564 T4842 T5149 4089414.6094517848
Rt24565 T4842 T5492 4058869.3423679667
Rt24566 T4843 T4865 4543716.1276964592
Rt24567 T4843 T5135 5126312.8882129379
Rt24568 T4843 T5136 576079262.77300704
Rt24569 T4843 T6032 1427641.7547126156
Rt24570 T4844 T4878 4571321.6481486941
Rt24571 T4844 T4897 4546472.4542257674
Rt24572 T4844 T4900 4691023.4709046781
Rt24573 T4844 T5890 19643854.8239264
Rt24574 T4845 T5407 75835792.127044752
Rt24575 T4845 T5526 10093374.859033143
Rt24576 T4845 T5854 3897859.1285075038
Rt24577 T4845 T5869 1302971.8406194476
Rt24578 T4846 T4847 10115535.898625415
Rt24579 T4846 T4848 4097310.8742108387
Rt24580 T4846 T4863 11333928.87365843
Rt24581 T4846 T5772 3911987.0825383426
Rt24582 T4847 T4848 4054086.4647934306
Rt24583 T4847 T4849 4111409.6945128893
Rt24584 T4847 T5397 10904532.757915547
Rt24585 T4847 T5449 3925411.7109990553
Rt24586 T4848 T4849 10184237.267477745
Rt24587 T4848 T4850 3831938.7979401005
Rt24588 T4848 T5206 4255862.9987288266
Rt24589 T4848 T5772 9864379.6685284339
Rt24590 T4849 T4850 3995857.9515082943
Rt24591 T4849 T4851 4086782.9281592844
Rt24592 T4849 T5045 9614517.9648507591
Rt24593 T4849 T5397 3889535.3219276918
Rt24594 T4850 T4851 10740664.987943441
Rt24595 T4850 T4852 3954378.2287195344
Rt24596 T4850 T5206 11737582.53205117
Rt24597 T4850 T5801 3878447.7901086225
Rt24598 T4851 T4852 4057434.740809517
Rt24599 T4851 T4853 4342422.4461919889
Rt24600 T4851 T5045 4456462.9009131808
Rt24601 T4851 T5362 4391591.0957024544
Rt24602 T4852 T4853 11006260.301889239
Rt24603 T4852 T4938 3101020.879015849
Rt24604 T4852 T5006 4277385.4588751905
Rt24605 T4852 T5801 9771407.5044292156
Rt24606 T4853 T4938 4959299.1321519418
Rt24607 T4853 T4939 11541239.219527997
Rt24608 T4853 T5184 567773.2566731415
Rt24609 T4853 T5362 9651317.8280970845
Rt24610 T4854 T5385 3678893.2127136569
Rt24611 T4854 T5517 4443829.9077028409
Rt24612 T4854 T5545 4123206.7206718442
Rt24613 T4854 T5569 8942840.9206465129
Rt24614 T4855 T4856 4304357.5557618923
Rt24615 T4855 T4956 4446980.7296641888
Rt24616 T4855 T5029 85041227.534684092
Rt24617 T4855 T5914 3397623.324006374
Rt24618 T4856 T4956 4155364.5487006833
Rt24619 T4856 T5021 21357689.080579367
Rt24620 T4856 T5022 5589241.8580181925
Gcorr7935 T4856 T5231 T4856 T5231 -3.42057965969795e-08
Rt24621 T4856 T5968 3734323.5275664418
Rt24622 T4857 T4887 1896316.8475345534
Rt24623 T4857 T5347 1270653.9213948613
Rt24624 T4857 T5447 5456588.6568047758
Rt24625 T4857 T5800 1741019.5429240749
Rt24626 T4858 T5118 4559111.3540611751
Rt24627 T4858 T5265 55488560.12882749
Rt24628 T4858 T5294 5869887.0264583509
Rt24629 T4858 T5735 4614807.157511198
Rt24630 T4859 T4860 3960806.2329546204
Rt24631 T4859 T4861 11525913.976968726
Rt24632 T4859 T5111 5090805.2884221552
Rt24633 T4859 T5834 12604812.975178145
Rt24634 T4860 T4934 4709346.7751001017
Rt24635 T4860 T4935 11255577.088927103
Rt24636 T4860 T4963 1155219.7408439417
Rt24637 T4860 T5834 13859227.57868992
Rt24638 T4861 T5111 13242296.252227571
Rt24639 T4861 T5213 4647818.0646866718
Rt24640 T4861 T5820 2875469.7983290795
Rt24641 T4861 T5821 15546493.042467108
Rt24642 T4862 T5350 5090499.6215497367
Rt24643 T4862 T5561 4182542.3859887379
Rt24644 T4862 T5568 4499402.3121965574
Rt24645 T4862 T5666 9859525.5412350427
Rt24646 T4863 T4864 11809383.78591211
Rt24647 T4863 T5042 3364844.8722710493
Rt24648 T4863 T5245 7765310.7372395983
Rt24649 T4863 T5772 4018265.0348566235
Rt24650 T4864 T5042 3108790.0109419716
Rt24651 T4864 T5043 4568234.7714487761
Rt24652 T4864 T5644 3579861.5872083781
Rt24653 T4864 T5645 10135821.137180159
Rt24654 T4865 T5109 4944689.2630538475
Rt24655 T4865 T5110 7482729.5397300711
Rt24656 T4865 T5135 5003739.4734826526
Rt24657 T4865 T5826 6320217.4460939672
Rt24658 T4866 T4867 12618753.596425215
Rt24659 T4866 T4928 100113594.72322927
Rt24660 T4866 T5372 574738254.9992708
Rt24661 T4866 T5980 14693095.718545556
Rt24662 T4866 T6080 850240.88771582546
Rt24663 T4867 T4928 3383025.73940629
Rt24664 T4867 T4929 3850744.4229532192
Rt24665 T4867 T5181 3744134.838750985
Gcorr7936 T4867 T5821 T4867 T5821 -5.8638830164744168e-08
Rt24666 T4868 T4869 4934301.7246757438
Rt24667 T4868 T5023 5555451.7309266236
Rt24668 T4868 T5210 1863110.045289228
Rt24669 T4868 T6072 2846992.229060119
Rt24670 T4869 T5023 61752584.912776925
Rt24671 T4869 T5065 4882010.0273858272
Rt24672 T4869 T5735 2895736.5230741235
Rt24673 T4870 T5454 3305415.7188682458
Rt24674 T4870 T5455 4685751.440243151
Rt24675 T4870 T5456 4957371.0686304057
Rt24676 T4870 T5715 10477251.092907095
Rt24677 T4871 T5444 5511439.3636353454
Rt24678 T4871 T5450 5598617.0893957242
Rt24679 T4871 T5514 3698534.4017956881
Rt24680 T4871 T5601 1674632.8933068118
Rt24681 T4872 T4873 14660822.547897356
Rt24682 T4872 T4993 1609809.5436834705
Rt24683 T4872 T5066 10101611.334457951
Rt24684 T4872 T5234 3917407.5052346922
Rt24685 T4873 T4874 13329075.171137309
Rt24686 T4873 T4875 5840630.4162456058
Rt24687 T4873 T4993 4187164.0367329856
Rt24688 T4873 T5395 4187059.6211439045
Rt24689 T4874 T4875 14065276.179993894
Rt24690 T4874 T4876 895191.67044129537
Rt24691 T4874 T5026 38301257.624287784
Rt24692 T4874 T5885 3982621.7947274274
Rt24693 T4875 T4876 961796.54767428664
Rt24694 T4875 T4983 25508601.731733207
Gcorr7937 T4875 T5216 T4875 T5216 -1.2397956406687718e-08
Rt24695 T4875 T5395 11582465.567975156
Rt24696 T4875 T6062 3307057.194505184
Rt24697 T4876 T4983 3447880.1920953258
Rt24698 T4876 T4984 14820246.929543609
Rt24699 T4876 T5026 1665174.2592012119
Rt24700 T4876 T5940 8845971.4672027938
Rt24701 T4877 T4899 4942924.6615588712
Rt24702 T4877 T5138 3324437.4820802356
Rt24703 T4877 T5166 4256372.0819507726
Rt24704 T4877 T5431 8343622.7529892074
Rt24705 T4878 T4900 14418814.054021589
Rt24706 T4878 T5598 2676248.5235755676
Rt24707 T4878 T5787 3615837.153472974
Rt24708 T4878 T6064 4149552.1016855231
Rt24709 T4879 T5039 3213421.0911910017
Rt24710 T4879 T5205 16868767.006973244
Gcorr7938 T4879 T5342 T4879 T5342 -5.6359597387390476e-08
Rt24711 T4879 T5691 3008773.7690292071
Rt24712 T4880 T4881 10482191.787534846
Rt24713 T4880 T5027 2873221.3988427576
Rt24714 T4880 T5197 4763695.6929866094
Rt24715 T4880 T5588 4693867.0784920184
Rt24716 T4881 T5027 1716177.8337872194
Rt24717 T4881 T5055 10417143.630008249
Rt24718 T4881 T5057 1703895.263827489
Rt24719 T4881 T5483 10382221.686276803
Rt24720 T4882 T5507 1809861.4412854556
Rt24721 T4882 T5562 9679315.1200372931
Rt24722 T4882 T5697 1570979.0281224186
Rt24723 T4882 T5824 3358424.332115768
Rt24724 T4883 T4884 13053102.331882142
Rt24725 T4883 T5252 4795497.9184795804
Rt24726 T4883 T5863 4955881.8461694224
Rt24727 T4883 T5888 581700.49025040434
Rt24728 T4884 T5046 4639078.292911211
Rt24729 T4884 T5047 4770738.0768199014
Rt24730 T4884 T5700 1232225.2421410521
Rt24731 T4884 T5888 3346849.452340052
Rt24732 T4885 T5780 9404495.8220329899
Rt24733 T4885 T5924 3548930.4067288036
Rt24734 T4885 T5925 36237878.098479174
Rt24735 T4885 T5994 3248510.4756844537
Rt24736 T4886 T5058 4124676.0507295472
Rt24737 T4886 T5132 4929802.6756937662
Rt24738 T4886 T5139 4419681.2755489666
Rt24739 T4886 T5951 5782755.2102825372
Rt24740 T4887 T5159 3599209.616335758
Rt24741 T4887 T5160 1429328.5868245885
Rt24742 T4887 T5347 3139266.1535830093
Rt24743 T4887 T5905 4028293.2282240614
Rt24744 T4888 T5476 10869736.895416772
Rt24745 T4888 T5599 13931115.197448922
Rt24746 T4888 T5609 3038686.9613550021
Rt24747 T4888 T5855 4255890.5435917638
Rt24748 T4889 T4890 3647276.5694385064
Rt24749 T4889 T4891 4949234.5001767986
Rt24750 T4889 T5142 4372776.2825121842
Rt24751 T4889 T5232 3354025.1170130349
Rt24752 T4890 T4891 10556104.087474961
Rt24753 T4890 T4892 950249.89031436446
Rt24754 T4890 T4893 2555356.3768540802
Rt24755 T4890 T5830 7478494.0617285995
Rt24756 T4891 T4892 2832376.9361653104
Rt24757 T4891 T4894 12204509.494111484
Rt24758 T4891 T5142 10695910.871364167
Rt24759 T4891 T5273 1477246.6008832208
Rt24760 T4892 T4893 2219515.2439975119
Rt24761 T4892 T4894 4658844.2189989043
Rt24762 T4892 T4895 11277006.873935021
Rt24763 T4892 T5792 2121562.577532765
Gcorr7939 T4893 T5672 T4893 T5672 -4.48242116073619e-08
Rt24764 T4893 T5792 2582052.2148623373
Rt24765 T4893 T5830 2956834.6270041261
Rt24766 T4893 T5874 1208885.0469515566
Rt24767 T4894 T4895 4723040.9148253808
Rt24768 T4894 T4896 12331235.888258651
Rt24769 T4894 T5001 3917219.6187815331
Rt24770 T4894 T5273 5319724.6344803125
Rt24771 T4895 T4896 4358668.501133183
Rt24772 T4895 T4901 9540007.0021516662
Rt24773 T4895 T4957 3937385.2176924716
Rt24774 T4895 T5792 3634700.1895592068
Rt24775 T4896 T4901 10426013.569876846
Rt24776 T4896 T4902 3656851.3117749896
Rt24777 T4896 T5001 4858530.4596378077
Rt24778 T4896 T5393 4767919.5499144597
Rt24779 T4897 T5205 7867005.7462217966
Rt24780 T4897 T5691 3024494.4861707781
Rt24781 T4897 T5879 12801911.226245536
Rt24782 T4897 T5890 3457259.2805541046
Rt24783 T4898 T5196 27070955.84461594
Rt24784 T4898 T5198 4174268.3858541884
Gcorr7940 T4898 T5426 T4898 T5426 -5.0599912099486701e-08
Rt24785 T4898 T5967 2197584.1129366085
Rt24786 T4899 T5028 11590288.898708299
Rt24787 T4899 T5166 3645045.0896372823
Rt24788 T4899 T5167 4928771.3846616317
Rt24789 T4899 T5985 3271227.561027484
Rt24790 T4900 T5321 52716839.877356559
Gcorr7941 T4900 T5330 T4900 T5330 -5.1199274216239003e-08
Rt24791 T4900 T5598 10311974.307889516
Gcorr7942 T4900 T5757 T4900 T5757 -3.2774325855054184e-08
Rt24792 T4900 T5890 3132141.0344241261
Rt24793 T4901 T4902 4023599.5754829128
Rt24794 T4901 T4903 10612389.704206068
Rt24795 T4901 T4957 3767940.3064449718
Rt24796 T4901 T5670 3235580.7691970342
Rt24797 T4902 T4903 4730890.416312566
Rt24798 T4902 T4904 9464238.2978013549
Rt24799 T4902 T5116 1384122.5043718014
Rt24800 T4902 T5393 11402247.522051761
Rt24801 T4903 T4904 3222438.3710178803
Rt24802 T4903 T4905 11102746.877184352
Rt24803 T4903 T5638 4114698.9815490195
Rt24804 T4903 T5670 2284061.3548350576
Rt24805 T4904 T4905 1323742.6958912846
Rt24806 T4904 T4906 4981621.7198979501
Rt24807 T4904 T5116 1468232.2681107779
Rt24808 T4904 T5781 6876690.1699879998
Rt24809 T4905 T4906 10622623.517319305
Rt24810 T4905 T5011 4181741.5091281962
Rt24811 T4905 T5137 3488640.9684666162
Rt24812 T4905 T5638 11062899.42906826
Rt24813 T4906 T5011 3695132.6883906359
Rt24814 T4906 T5012 4733121.9353750255
Rt24815 T4906 T5145 11649653.394814951
Rt24816 T4906 T5781 2787389.0907669603
Rt24817 T4907 T4908 3962287.6162300152
Rt24818 T4907 T5489 1571809.3469163305
Rt24819 T4907 T5490 1950128.083048681
Rt24820 T4907 T5656 2441401.444929027
Rt24821 T4908 T4909 9780668.6345615834
Rt24822 T4908 T4910 2971220.5599077148
Rt24823 T4908 T4911 2138507.3419301058
Rt24824 T4908 T5656 1523660.3552432524
Rt24825 T4909 T4910 2349800.3851568918
Rt24826 T4909 T4912 2567646.4934221036
Rt24827 T4909 T5151 5513923.1538722347
Rt24828 T4909 T5496 5136526.4146765638
Rt24829 T4910 T4911 9407441.1682649981
Rt24830 T4910 T4912 4579252.9280078802
Rt24831 T4910 T4913 4725877.5989438752
Rt24832 T4910 T5547 9902713.9206662942
Rt24833 T4911 T4913 4363333.6083151884
Rt24834 T4911 T4914 15757516.83223434
Rt24835 T4911 T5656 9240390.8906277455
Rt24836 T4911 T5896 2319830.3770047901
Rt24837 T4912 T5151 4678449.841539816
Rt24838 T4912 T5152 3206151.6600293131
Rt24839 T4912 T5188 8762710.3154124431
Rt24840 T4912 T5547 2774167.6898247055
Rt24841 T4913 T4914 3592319.7029791214
Rt24842 T4913 T4915 2730658.6538201603
Rt24843 T4913 T4917 2053404.3145405783
Rt24844 T4913 T5547 3744427.052739758
Rt24845 T4914 T4915 4720315.9810147425
Rt24846 T4914 T4916 16528105.389899306
Rt24847 T4914 T4954 2676292.5561080584
Rt24848 T4914 T5896 1438221.7921664193
Rt24849 T4915 T4916 4960018.8350564446
Rt24850 T4915 T4917 9639576.3684442639
Rt24851 T4915 T4918 2892260.862085897
Rt24852 T4915 T5679 32043522.875143778
Rt24853 T4916 T4918 13917536.381423458
Rt24854 T4916 T4919 7082960.8274648366
Rt24855 T4916 T4954 1393515.8866802366
Rt24856 T4916 T5883 24037994.904578716
Rt24857 T4917 T5547 21703872.025186677
Rt24858 T4917 T5678 5717066.992819434
Rt24859 T4917 T5679 5891162.7172929626
Rt24860 T4917 T5993 2531682.165516119
Rt24861 T4918 T4919 3201108.6896873382
Rt24862 T4918 T4920 8223441.381642418
Rt24863 T4918 T5256 12167596.449862685
Rt24864 T4918 T5679 5212760.0901762638
Rt24865 T4919 T4920 43377302.413969934
Rt24866 T4919 T4921 5117643.4012959599
Gcorr7943 T4919 T5112 T4919 T5112 -9.1448903627002235e-08
Rt24867 T4919 T5883 3398826.3072187672
Rt24868 T4920 T4921 8377899.2749713212
Rt24869 T4920 T5115 21336132.675944082
Gcorr7944 T4920 T5256 T4920 T5256 -3.3912713621120372e-08
Rt24870 T4920 T5917 2807344.6586043425
Rt24871 T4921 T5112 9028076.8836797327
Rt24872 T4921 T5115 4500529.9069385398
Rt24873 T4921 T5162 510200.21628296596
Rt24874 T4921 T6007 5961373.9859780893
Rt24875 T4922 T4923 10817864.288451243
Rt24876 T4922 T5202 4707767.8673839057
Rt24877 T4922 T5203 9439769.7330823466
Rt24878 T4922 T5398 5197605.5949133402
Rt24879 T4923 T5202 4212434.2712662471
Rt24880 T4923 T5204 9842817.6353159789
Rt24881 T4923 T5260 4803363.7754409509
Rt24882 T4923 T5806 10090034.822904941
Gcorr7945 T4924 T5337 T4924 T5337 -1.5452154101910381e-07
Gcorr7946 T4924 T5762 T4924 T5762 -1.2799344124539986e-07
Rt24883 T4924 T5830 3503110.9588405737
Rt24884 T4924 T5831 2946656.0333194444
Rt24885 T4924 T6082 1832362.7141025166
Rt24886 T4925 T4926 3903639.3415344544
Rt24887 T4925 T4927 11209172.467665488
Rt24888 T4925 T5119 14743115.481908629
Rt24889 T4925 T5927 3483295.6960676867
Rt24890 T4926 T5119 3176832.4655532059
Rt24891 T4926 T5177 17154202.596851077
Rt24892 T4926 T5217 4381388.5317242164
Rt24893 T4926 T5654 1856477.100547326
Rt24894 T4927 T4947 4841757.7507906985
Rt24895 T4927 T4948 4786612.379857311
Rt24896 T4927 T5927 2330156.4124757499
Rt24897 T4927 T5938 2190395.5008527562
Rt24898 T4928 T4929 15118423.081269514
Rt24899 T4928 T4930 5687990.337097751
Rt24900 T4928 T5228 4877289.3355486142
Rt24901 T4928 T5229 17038735.797052875
Rt24902 T4928 T6080 3492916.3160264739
Rt24903 T4929 T4930 4323748.0739422254
Rt24904 T4929 T4931 21761522.581600875
Rt24905 T4929 T5181 28179098.015059225
Rt24906 T4929 T6088 3436945.9476594152
Rt24907 T4930 T4931 3635845.9367979579
Rt24908 T4930 T4959 21040214.931746721
Rt24909 T4930 T5226 3904422.614742449
Rt24910 T4930 T5228 4576296.9160713628
Rt24911 T4931 T4959 4652700.3998794546
Rt24912 T4931 T4960 17989125.413241919
Rt24913 T4931 T5947 4502499.3249518871
Rt24914 T4931 T6088 4016231.2205861118
Rt24915 T4932 T5716 3551662.2168053389
Gcorr7947 T4932 T5796 T4932 T5796 -1.3028588133375488e-07
Rt24916 T4932 T5903 2104454.054300128
Rt24917 T4932 T5935 1962304.9425163884
Rt24918 T4933 T5474 10537190.003602598
Rt24919 T4933 T5606 1282931.4651639177
Rt24920 T4933 T5712 8423213.0283670742
Rt24921 T4933 T5780 10370485.870718077
Rt24922 T4934 T4935 2657151.461566729
Rt24923 T4934 T5331 1794304.966055379
Rt24924 T4934 T5332 10396215.162048433
Rt24925 T4934 T5333 3556162.803949385
Rt24926 T4935 T4963 4166620.4738554819
Rt24927 T4935 T4964 12414156.845448833
Rt24928 T4935 T4965 4658451.0059702164
Rt24929 T4935 T5333 2847123.0217798571
Rt24930 T4936 T4937 9039068.0531509928
Rt24931 T4936 T4952 5697052.7879191963
Rt24932 T4936 T5254 2720046.063970264
Rt24933 T4936 T5344 16165544.819999827
Rt24934 T4937 T4952 2424082.6974758883
Rt24935 T4937 T4953 4828094.5039909333
Rt24936 T4937 T5014 5626819.4434350431
Rt24937 T4937 T5793 9920205.2553157397
Rt24938 T4938 T4939 5038114.0989094991
Rt24939 T4938 T5006 13390335.558091514
Rt24940 T4938 T5040 3890359.5309442468
Rt24941 T4938 T6027 8233489.3273606049
Rt24942 T4939 T5040 4821373.3037589993
Rt24943 T4939 T5184 5833369.7067642575
Rt24944 T4939 T5581 13583716.30237144
Rt24945 T4939 T6031 2505193.0256377826
Rt24946 T4940 T4941 3488646.2044528355
Rt24947 T4940 T5620 4155519.4096724601
Rt24948 T4940 T5682 4043634.9757301477
Rt24949 T4940 T5921 18065482.584898401
Rt24950 T4941 T4942 8456502.6926700082
Rt24951 T4941 T4991 3888785.0526583903
Rt24952 T4941 T5123 3871569.3949431274
Rt24953 T4941 T5682 8046610.7785665942
Rt24954 T4942 T4991 3361747.092862173
Rt24955 T4942 T5131 758000.42985556228
Rt24956 T4942 T5221 31330085.515952528
Rt24957 T4942 T5596 4058752.8312507528
Rt24958 T4943 T4944 5023932.7090393314
Rt24959 T4943 T5666 1665882.414437254
Rt24960 T4943 T5734 2399229.6136817802
Rt24961 T4943 T5814 11247685.970428215
Rt24962 T4944 T4945 4275428.2892481666
Rt24963 T4944 T4946 12392438.653841376
Rt24964 T4944 T5003 3346754.8908855207
Rt24965 T4944 T5814 3317335.7280973699
Rt24966 T4945 T4946 3715272.2900317898
Rt24967 T4945 T5594 5902992.3985785237
Rt24968 T4945 T5676 2735998.0690469914
Rt24969 T4945 T5962 9626592.7932457495
Rt24970 T4946 T5003 4450125.0357584376
Rt24971 T4946 T5004 3559288.3817702499
Rt24972 T4946 T5005 3517409.7667259546
Rt24973 T4946 T5676 13570837.473979939
Rt24974 T4947 T4948 11477439.623835221
Rt24975 T4947 T5069 3800041.5213098372
Rt24976 T4947 T5158 5109889.379989069
Rt24977 T4947 T5399 4510151.3696597107
Rt24978 T4948 T5069 4829520.6844811505
Rt24979 T4948 T5070 10308575.365280282
Rt24980 T4948 T5071 2732148.7850947306
Rt24981 T4948 T5938 2118573.8742188173
Rt24982 T4949 T4996 3087389.8005977715
Rt24983 T4949 T4997 3613798.2788505647
Gcorr7948 T4949 T5730 T4949 T5730 -9.8974342046624591e-08
Gcorr7949 T4949 T5731 T4949 T5731 -4.2813904048700865e-08
Rt24984 T4949 T5811 1385445.3725453331
Rt24985 T4950 T4992 2993336.9387024031
Rt24986 T4950 T5038 3851803.9775359938
Rt24987 T4950 T5163 17901949.27422094
Gcorr7950 T4950 T5641 T4950 T5641 -2.4546328383858688e-08
Rt24988 T4951 T5487 3133332.6953827841
Rt24989 T4951 T5491 13382125.766674755
Rt24990 T4951 T5752 4017561.5139866485
Rt24991 T4951 T5884 3462322.7030755817
Rt24992 T4952 T4953 20388388.671666883
Rt24993 T4952 T5344 5065747.2669620179
Rt24994 T4952 T5355 14783112.764015382
Rt24995 T4952 T5794 3133064.5715513225
Rt24996 T4953 T5014 5967909.2706456147
Rt24997 T4953 T5049 23680000.07219037
Gcorr7951 T4953 T5298 T4953 T5298 -3.9940904705443683e-08
Rt24998 T4953 T5794 5131301.3359173154
Rt24999 T4953 T5892 9045008.2092642598
Rt25000 T4954 T5657 11904798.560295444
Rt25001 T4954 T5658 2882655.0781607036
Rt25002 T4954 T5659 1573016.2957461446
Rt25003 T4954 T5883 1428096.2245142353
Rt25004 T4954 T5896 6912397.5679988824
Rt25005 T4955 T5009 3111530.9971484425
Rt25006 T4955 T5060 3114197.8685051883
Rt25007 T4955 T5295 2933095.1522614839
Gcorr7952 T4955 T5693 T4955 T5693 -2.121685651290242e-07
Rt25008 T4956 T5021 4657535.7813204499
Rt25009 T4956 T5025 70241149.800152928
Rt25010 T4956 T5029 4906760.0399098415
Rt25011 T4956 T5923 3864191.9290649937
Rt25012 T4957 T5670 6183886.7288999222
Rt25013 T4957 T5671 1764277.7801995177
Gcorr7953 T4957 T5672 T4957 T5672 -5.4922038508666022e-08
Rt25014 T4957 T5792 2554272.4821273456
Rt25015 T4958 T5511 1523105.7072512691
Rt25016 T4958 T5744 9002877.0391655676
Rt25017 T4958 T5785 8145568.4552913718
Rt25018 T4958 T5877 3907076.6538648731
Rt25019 T4959 T4960 3795049.4459500224
Rt25020 T4959 T5007 29216865.193267852
Rt25021 T4959 T5226 4244280.5378408367
Rt25022 T4959 T5227 3677768.6996664181
Rt25023 T4960 T5007 4735643.5749419518
Rt25024 T4960 T5008 5145920.3015984595
Rt25025 T4960 T5018 139106251.46170607
Rt25026 T4960 T5947 4398698.0746184867
Rt25027 T4961 T4962 3033971.8380677728
Rt25028 T4961 T5134 4800596.6367490301
Gcorr7954 T4961 T5335 T4961 T5335 -1.459213881228624e-08
Rt25029 T4961 T5899 140226871.28297871
Rt25030 T4962 T5335 4487251.8311383585
Rt25031 T4962 T5400 4267967.9998086076
Rt25032 T4962 T5809 2936668.0893612243
Rt25033 T4962 T6010 1323763.788446289
Rt25034 T4963 T4964 11584848.459673747
Rt25035 T4963 T5834 2835917.2642572238
Rt25036 T4963 T5835 19456093.568061378
Rt25037 T4963 T5881 3684665.8814497367
Rt25038 T4964 T4965 4294104.166409729
Rt25039 T4964 T4966 4104182.478039661
Rt25040 T4964 T4967 3740282.9318405627
Rt25041 T4964 T5881 3237493.5132826008
Rt25042 T4965 T4966 5257629.1293261144
Rt25043 T4965 T5333 6313091.4927931
Rt25044 T4965 T5334 3082825.3815475092
Rt25045 T4965 T5374 4564288.761774634
Rt25046 T4966 T4967 9594000.8116181046
Rt25047 T4966 T4968 11689588.325159615
Rt25048 T4966 T4969 2751194.2067086408
Rt25049 T4966 T5374 5097859.9341818644
Rt25050 T4967 T4968 4565484.4760953905
Rt25051 T4967 T5002 10269602.503804281
Rt25052 T4967 T5218 1418023.5087764498
Rt25053 T4967 T5881 12804162.535866279
Rt25054 T4968 T4969 4308093.3234844329
Rt25055 T4968 T4970 12365980.447370373
Rt25056 T4968 T5002 13596737.035950691
Rt25057 T4968 T5839 3208468.5257258881
Rt25058 T4969 T4970 4849527.5058470899
Rt25059 T4969 T4971 9648502.2733942959
Rt25060 T4969 T5374 12552896.807337897
Rt25061 T4969 T5433 1866617.4328645959
Rt25062 T4970 T4971 3537985.2677326212
Rt25063 T4970 T4972 4680758.9087969819
Rt25064 T4970 T5556 381947.87453840591
Rt25065 T4970 T5839 2727312.7453595847
Rt25066 T4971 T4972 5222691.2697599921
Rt25067 T4971 T4973 4948131.4864532407
Rt25068 T4971 T5161 4904946.2547537368
Rt25069 T4971 T5433 3428795.6368038831
Rt25070 T4972 T4973 2091555.8410935581
Rt25071 T4972 T4974 9788339.6504318677
Rt25072 T4972 T4975 2205077.8501502299
Rt25073 T4972 T5556 9574653.5268674232
Rt25074 T4973 T4974 2795361.990809198
Rt25075 T4973 T4982 4336582.5958564449
Rt25076 T4973 T5161 5164447.7351537682
Rt25077 T4973 T6003 1188157.3887779673
Rt25078 T4974 T4975 2643022.8111301963
Rt25079 T4974 T4976 4636698.3986645117
Rt25080 T4974 T4982 5110546.4315108452
Rt25081 T4974 T5530 4987743.1163413543
Rt25082 T4975 T4976 8534674.4750365485
Rt25083 T4975 T4977 3921865.5730471518
Rt25084 T4975 T5068 9476257.9316290412
Rt25085 T4975 T5556 4000361.9630935732
Rt25086 T4976 T4977 4323701.6164153041
Rt25087 T4976 T4978 11282909.752737964
Rt25088 T4976 T4979 3566684.3285881924
Rt25089 T4976 T5530 4978154.3343262095
Rt25090 T4977 T4978 2528481.1313193738
Rt25091 T4977 T4981 2396727.9131332957
Rt25092 T4977 T5068 1611660.1035872754
Rt25093 T4977 T6024 7705594.034951319
Rt25094 T4978 T4979 1494584.9001252714
Rt25095 T4978 T4980 9368159.494087968
Rt25096 T4978 T4981 10141655.501747875
Rt25097 T4978 T5575 4450044.2691539777
Rt25098 T4979 T4980 4303989.9432174386
Rt25099 T4979 T4985 5055574.3742390489
Rt25100 T4979 T5048 9737795.9643173181
Rt25101 T4979 T5530 4829120.4708979502
Rt25102 T4980 T4985 4981454.6963211391
Rt25103 T4980 T5063 4897672.0226610387
Rt25104 T4980 T5143 5087667.5087764459
Rt25105 T4980 T5575 4394364.486297762
Gcorr7955 T4981 T5368 T4981 T5368 -8.876199211097718e-08
Rt25106 T4981 T5575 2963912.2642317321
Rt25107 T4981 T5959 2134544.1434945371
Rt25108 T4981 T6024 814757.45803965139
Rt25109 T4982 T5443 5948033.7070814688
Rt25110 T4982 T5523 8232545.8511998756
Rt25111 T4982 T5530 4391763.7344633089
Rt25112 T4982 T6003 2572910.4346202859
Rt25113 T4983 T4984 2511659.2981411712
Rt25114 T4983 T5044 93158718.074914038
Rt25115 T4983 T5216 5779580.6181298103
Rt25116 T4983 T5233 2654994.3315564278
Rt25117 T4984 T5044 3274801.0424064812
Gcorr7956 T4984 T5238 T4984 T5238 -4.9235413595841217e-10
Gcorr7957 T4984 T5366 T4984 T5366 -6.5204276297191411e-08
Rt25118 T4984 T5940 2398658.6660039872
Rt25119 T4985 T5048 3706562.6951009226
Rt25120 T4985 T5063 10553940.650899911
Rt25121 T4985 T5186 1967056.8163678462
Rt25122 T4985 T5755 7677437.381468839
Rt25123 T4986 T4987 9469133.611792922
Gcorr7958 T4986 T4988 T4986 T4988 -4.3014790196867091e-08
Rt25124 T4986 T5113 2870124.2931308178
Gcorr7959 T4986 T5765 T4986 T5765 -1.761997987506189e-07
Rt25125 T4987 T5113 7241283.5166259566
Gcorr7960 T4987 T5114 T4987 T5114 -4.6189577727685693e-08
Rt25126 T4987 T5258 7808899.5140684247
Rt25127 T4987 T5259 4053768.1161042512
Gcorr7961 T4987 T5995 T4987 T5995 -9.1798155010317621e-08
Gcorr7962 T4988 T5452 T4988 T5452 -3.4607689433656086e-07
Gcorr7963 T4988 T5673 T4988 T5673 -8.229894926084614e-08
Rt25128 T4988 T5765 4957182.7141601788
Rt25129 T4988 T5875 5549744.4334447738
Rt25130 T4989 T4990 53361806.736216776
Rt25131 T4989 T5309 3730374.6555790533
Rt25132 T4989 T5310 9059758.349669667
Gcorr7964 T4989 T5758 T4989 T5758 -3.5034195622013107e-08
Gcorr7965 T4990 T5052 T4990 T5052 -1.8573345776178745e-09
Rt25133 T4990 T5053 3014133.4067835193
Rt25134 T4990 T5309 4521466.1777240839
Gcorr7966 T4990 T5411 T4990 T5411 -1.7057425517466637e-07
Rt25135 T4991 T5123 11595163.521448761
Rt25136 T4991 T5124 2884130.0657489183
Rt25137 T4991 T5131 12140056.708104404
Rt25138 T4991 T5833 867007.85730042157
Rt25139 T4992 T5163 3589010.0227120481
Rt25140 T4992 T5240 6480131.9076566109
Rt25141 T4992 T5352 10641950.258447163
Gcorr7967 T4992 T5847 T4992 T5847 -4.6636134495232514e-08
Rt25142 T4993 T5066 4350524.7292604391
Rt25143 T4993 T5236 4679258.5844290741
Rt25144 T4993 T5237 3569371.5057349564
Rt25145 T4993 T5395 9951577.9751681108
Rt25146 T4994 T4995 6046502.2024662029
Rt25147 T4994 T5067 6242517.9953256939
Gcorr7968 T4994 T5308 T4994 T5308 -2.7438614338216505e-08
Rt25148 T4994 T5893 3815578.718853801
Rt25149 T4995 T5133 1201001.9954372423
Rt25150 T4995 T5207 143401170.01411706
Rt25151 T4995 T5308 4690947.4106651163
Rt25152 T4995 T5978 2293952.1134037403
Rt25153 T4996 T4997 4069378.3444244782
Rt25154 T4996 T4998 5317005.6601793617
Rt25155 T4996 T5773 3961291.2437482476
Rt25156 T4996 T5774 4831825.9104739511
Rt25157 T4997 T4998 3993229.3447016436
Rt25158 T4997 T4999 5261308.8483756827
Rt25159 T4997 T5731 2926156.8445414901
Gcorr7969 T4997 T5832 T4997 T5832 -6.6661041629233083e-08
Rt25160 T4998 T4999 33077049.097905137
Rt25161 T4998 T5000 5118146.2523039887
Rt25162 T4998 T5316 2363986.2199028577
Rt25163 T4998 T5774 2347644.4059411781
Rt25164 T4999 T5000 5573450.11903538
Gcorr7970 T4999 T5024 T4999 T5024 -3.5625750502537405e-08
Rt25165 T4999 T5249 9202591.0014123116
Rt25166 T4999 T5832 2678649.0767483888
Gcorr7971 T5000 T5024 T5000 T5024 -3.2253864840836116e-08
Gcorr7972 T5000 T5316 T5000 T5316 -2.8273264758423377e-08
Rt25167 T5000 T5776 9181063.1976756174
Rt25168 T5000 T5880 2009957.1710109101
Rt25169 T5001 T5273 7104412.5079339826
Rt25170 T5001 T5274 3647624.4638386364
Rt25171 T5001 T5364 10495657.87692113
Rt25172 T5001 T5393 4445802.8830590248
Rt25173 T5002 T5218 1360773.1044940604
Gcorr7973 T5002 T5557 T5002 T5557 -1.2059243232807513e-07
Rt25174 T5002 T5839 928245.19257881574
Rt25175 T5002 T5840 7487738.7881420115
Rt25176 T5003 T5004 5143183.8109098766
Rt25177 T5003 T5312 11653115.235246567
Rt25178 T5003 T5814 9736209.0522509851
Rt25179 T5003 T5936 3120014.3237362648
Rt25180 T5004 T5005 10937169.064874681
Rt25181 T5004 T5182 5954286.9566676943
Rt25182 T5004 T5312 4198879.6636010045
Rt25183 T5004 T5495 8891342.4162942432
Rt25184 T5005 T5182 3766654.2971598008
Rt25185 T5005 T5298 16928937.932684749
Rt25186 T5005 T5676 14080960.479852444
Rt25187 T5005 T5974 3683062.1600678307
Gcorr7974 T5006 T5253 T5006 T5253 -7.9932173067773379e-08
Gcorr7975 T5006 T5602 T5006 T5602 -1.0832263233624553e-08
Rt25188 T5006 T5771 12012703.064324182
Rt25189 T5006 T5801 2448731.0391973867
Rt25190 T5006 T6027 1986982.8301756899
Rt25191 T5007 T5008 4276847.344474542
Rt25192 T5007 T5227 5822558.1341793137
Rt25193 T5007 T5420 3373576.259101395
Rt25194 T5007 T5421 9049276.1111760102
Rt25195 T5008 T5018 4845270.8686825642
Rt25196 T5008 T5019 6681161.8025013274
Rt25197 T5008 T5020 6127398.1602346664
Rt25198 T5008 T5421 5617367.0252803387
Rt25199 T5009 T5060 113910017.13609402
Gcorr7976 T5009 T5061 T5009 T5061 -7.1685271782412923e-08
Gcorr7977 T5009 T5304 T5009 T5304 -4.4336455172754368e-09
Rt25200 T5009 T5578 24442287.479247954
Rt25201 T5009 T6048 1972770.8381501934
Rt25202 T5010 T5378 4443229.2413298152
Rt25203 T5010 T5379 19421739.9828966
Rt25204 T5010 T5720 4119297.97830228
Rt25205 T5010 T5941 3349512.9741302752
Rt25206 T5011 T5012 10136823.375324164
Rt25207 T5011 T5137 4657222.9771050476
Rt25208 T5011 T5215 12034412.888925306
Rt25209 T5011 T5525 4648892.868948021
Rt25210 T5012 T5145 4458825.1940461043
Rt25211 T5012 T5223 3505854.7826214521
Rt25212 T5012 T5357 9976025.3374976963
Rt25213 T5012 T5525 4388081.5790033694
Rt25214 T5013 T5030 3382355.8971086456
Rt25215 T5013 T5329 22036758.447267272
Rt25216 T5013 T5607 13910286.25709535
Rt25217 T5013 T5939 1268883.2259954419
Rt25218 T5014 T5049 13644774.896390866
Rt25219 T5014 T5261 2319005.9212591518
Rt25220 T5014 T5687 5813068.3738671271
Rt25221 T5014 T5793 15013050.417007079
Rt25222 T5015 T5016 2021947.0488208658
Rt25223 T5015 T5430 1805791.2146126041
Rt25224 T5015 T5431 3062190.2156653726
Rt25225 T5015 T5432 8250727.0141896689
Rt25226 T5016 T5017 3912575.6233313675
Rt25227 T5016 T5400 5484566.1467525037
Rt25228 T5016 T5430 10789478.308373684
Rt25229 T5016 T5783 3488756.8733729962
Rt25230 T5017 T5400 12996474.34815024
Rt25231 T5017 T5401 2943729.4737941651
Rt25232 T5017 T5758 3584023.3951990912
Rt25233 T5017 T5955 3688385.5808495083
Rt25234 T5018 T5019 6158056.8064899743
Rt25235 T5018 T5619 2804000.0167397675
Gcorr7978 T5018 T5922 T5018 T5922 -9.8064305371386432e-08
Rt25236 T5018 T5947 3845017.8675962207
Gcorr7979 T5019 T5020 T5019 T5020 -1.992925626377345e-08
Rt25237 T5019 T5341 5743569.8733124463
Rt25238 T5019 T5619 3441572.7620861582
Gcorr7980 T5019 T5817 T5019 T5817 -2.3773499316036742e-08
Rt25239 T5020 T5341 7967863.8900797106
Gcorr7981 T5020 T5402 T5020 T5402 -3.0354938008702545e-08
Gcorr7982 T5020 T5421 T5020 T5421 -1.075824469174893e-07
Rt25240 T5020 T5740 2456665.6288229004
Rt25241 T5020 T5754 7009162.6563403029
Rt25242 T5021 T5022 4571184.9951778278
Rt25243 T5021 T5025 3262442.6717749755
Rt25244 T5021 T5165 3902400.073194196
Gcorr7983 T5021 T5716 T5021 T5716 -8.0951392329314195e-08
Rt25245 T5022 T5165 5206888.680924098
Rt25246 T5022 T5209 1528268.0941961319
Rt25247 T5022 T5230 4524487.6901798742
Rt25248 T5022 T5231 8176134.0153368181
Rt25249 T5023 T5065 1424769.262442634
Gcorr7984 T5023 T5210 T5023 T5210 -1.0136143586387734e-08
Gcorr7985 T5023 T5317 T5023 T5317 -8.1551095766516537e-08
Rt25250 T5023 T5828 6316561.4317994779
Rt25251 T5024 T5249 3815566.7331340984
Rt25252 T5024 T5349 3719926.0564520909
Rt25253 T5024 T5770 139545924.55979341
Rt25254 T5024 T5880 2501505.9127928563
Rt25255 T5025 T5716 6067904.1933769658
Rt25256 T5025 T5796 6437968.4589684317
Rt25257 T5025 T5923 2946862.271841744
Gcorr7986 T5025 T6006 T5025 T6006 -5.6756413286839718e-08
Gcorr7987 T5026 T5244 T5026 T5244 -7.0186543713296399e-08
Rt25258 T5026 T5582 669147.30849935987
Rt25259 T5026 T5805 85331319.614668801
Rt25260 T5026 T5885 7077126.0928932577
Rt25261 T5026 T5940 3409585.826042946
Rt25262 T5027 T5055 4480823.1460828353
Rt25263 T5027 T5056 4459155.8588081319
Rt25264 T5027 T5197 4050494.077060461
Rt25265 T5027 T5481 4861235.0467741517
Rt25266 T5028 T5498 10440188.535298843
Rt25267 T5028 T5593 18897400.928950798
Rt25268 T5028 T5626 5647243.5074850582
Rt25269 T5028 T5985 6507514.1851369115
Rt25270 T5028 T6085 4235071.2860599719
Rt25271 T5029 T5763 16849060.176548544
Rt25272 T5029 T5914 4707889.5558908191
Rt25273 T5029 T5923 18943790.537121121
Rt25274 T5029 T5945 2980520.7915255255
Rt25275 T5029 T6084 12357527.224594697
Rt25276 T5030 T5201 5175336.8455533236
Rt25277 T5030 T5329 5244941.7190361479
Gcorr7988 T5030 T5330 T5030 T5330 -1.5442882974351492e-09
Rt25278 T5030 T5598 2740584.7231639577
Gcorr7989 T5031 T5032 T5031 T5032 -8.9896658150247966e-08
Gcorr7990 T5031 T5427 T5031 T5427 -6.143310158995154e-08
Rt25279 T5031 T5446 3597128.8941207388
Rt25280 T5031 T5979 6742967.5195253883
Rt25281 T5032 T5033 5541000.252293935
Rt25282 T5032 T5446 10924974.244460762
Rt25283 T5032 T5549 8822469.4306276664
Gcorr7991 T5032 T5803 T5032 T5803 -1.58161632032841e-07
Gcorr7992 T5033 T5352 T5033 T5352 -2.0989174390500098e-07
Rt25284 T5033 T5655 11604397.598767072
Rt25285 T5033 T5803 6437465.0779041108
Gcorr7993 T5033 T5804 T5033 T5804 -1.344051724894508e-07
Rt25286 T5033 T5847 2412166.3948445339
Rt25287 T5034 T5035 25432145.701127458
Rt25288 T5034 T5603 22942240.844874665
Rt25289 T5034 T5677 2370422.8673968343
Rt25290 T5034 T5988 2982107.4961913093
Rt25291 T5035 T5036 10976560.796980945
Rt25292 T5035 T5153 5499535.1172724413
Gcorr7994 T5035 T5154 T5035 T5154 -2.6562363622003295e-08
Rt25293 T5035 T5988 2086088.5285860363
Rt25294 T5036 T5153 14099623.162726002
Rt25295 T5036 T5155 3684752.6679743011
Gcorr7995 T5036 T5250 T5036 T5250 -2.0303038515743967e-08
Rt25296 T5036 T5944 2987443.2131059496
Rt25297 T5037 T5127 4548071.3013158021
Rt25298 T5037 T5170 4579387.1135947164
Rt25299 T5037 T5444 5199091.7284358917
Rt25300 T5037 T5450 11879863.190631283
Rt25301 T5038 T5640 4449615.9451676514
Rt25302 T5038 T5641 5038684.8810358914
Rt25303 T5038 T5937 6396772.8701742906
Rt25304 T5038 T6005 1902493.758764138
Rt25305 T5039 T5157 3963090.6473467066
Rt25306 T5039 T5205 3302654.0693545355
Rt25307 T5039 T5212 4424896.0475047203
Rt25308 T5039 T5872 13898214.330239812
Rt25309 T5040 T5581 177373961.86950189
Rt25310 T5040 T5906 2594391.971904546
Rt25311 T5040 T5907 10574739.755127802
Rt25312 T5040 T6027 2667266.1173861544
Rt25313 T5041 T5320 9056752.6807605494
Rt25314 T5041 T5503 5136352.0264990991
Rt25315 T5041 T5559 1776856.6426824918
Rt25316 T5041 T5756 6648723.6977966372
Rt25317 T5041 T6089 14285443.688112134
Rt25318 T5042 T5043 12117063.018119508
Rt25319 T5042 T5245 15780665.609490244
Rt25320 T5042 T5301 1687028.2924338661
Rt25321 T5042 T5761 4593667.7721030125
Gcorr7996 T5043 T5348 T5043 T5348 -6.8716450827036428e-08
Rt25322 T5043 T5645 832514.23748249945
Rt25323 T5043 T5646 7403679.833715478
Rt25324 T5043 T5761 3420464.6767045674
Rt25325 T5044 T5233 115907209.7370856
Rt25326 T5044 T5238 3439410.5395399914
Rt25327 T5044 T5580 5396809.316600346
Rt25328 T5044 T5698 1880824.6448688069
Rt25329 T5045 T5362 5575694.548089697
Rt25330 T5045 T5363 4094822.9061884917
Rt25331 T5045 T5397 4106746.8974673566
Rt25332 T5045 T5573 9047199.8874899819
Rt25333 T5046 T5047 10068762.681253554
Rt25334 T5046 T5054 3618437.3669781461
Rt25335 T5046 T5554 10582675.858796287
Rt25336 T5046 T5570 3755638.3161862474
Rt25337 T5047 T5054 2656792.6528532393
Rt25338 T5047 T5220 10038330.563375454
Rt25339 T5047 T5387 4531380.1940539675
Rt25340 T5047 T5700 8394582.5333512034
Rt25341 T5048 T5523 15917447.110492894
Rt25342 T5048 T5530 1832362.4989805222
Rt25343 T5048 T5558 4873801.0284534171
Rt25344 T5048 T5755 4156392.8551302426
Rt25345 T5049 T5261 8351362.9225000311
Gcorr7997 T5049 T5576 T5049 T5576 -3.7295226340382503e-08
Rt25346 T5049 T5892 1087496.6721354171
Rt25347 T5049 T5973 2309493.4393488793
Rt25348 T5050 T5465 4627960.116401569
Rt25349 T5050 T5473 4590425.1401138678
Rt25350 T5050 T5606 2833489.9882323574
Rt25351 T5050 T5637 9405521.987250261
Rt25352 T5051 T5146 3242336.040179281
Rt25353 T5051 T5328 8153082.2492371593
Rt25354 T5051 T5437 4605838.8791139061
Rt25355 T5051 T5561 4108516.6781171323
Rt25356 T5052 T5053 6329191.5336168176
Rt25357 T5052 T5406 4163418.2134114634
Rt25358 T5052 T5407 17976830.579147696
Rt25359 T5052 T5409 3673730.2147098253
Gcorr7998 T5053 T5404 T5053 T5404 -1.7275850785058465e-08
Gcorr7999 T5053 T5409 T5053 T5409 -1.3989116492311994e-08
Rt25360 T5053 T5410 4225613.5293472027
Rt25361 T5053 T5411 8409666.5547161531
Rt25362 T5054 T5220 1972915.5091085611
Rt25363 T5054 T5570 11586129.366270054
Rt25364 T5054 T5766 4315254.882457125
Rt25365 T5054 T5871 3792822.6117926915
Rt25366 T5055 T5056 10616290.457932519
Rt25367 T5055 T5057 4625073.1296806363
Rt25368 T5055 T5140 4666335.9404566558
Rt25369 T5055 T5747 7927542.5460468614
Rt25370 T5056 T5140 1702509.3751730537
Rt25371 T5056 T5354 5619672.2756953808
Rt25372 T5056 T5391 9221679.7945422754
Rt25373 T5056 T5481 9111764.8570278306
Rt25374 T5057 T5483 2813572.1746141487
Rt25375 T5057 T5565 1471522.7661173632
Rt25376 T5057 T5569 2717250.9815798877
Rt25377 T5057 T5747 4908306.371851611
Rt25378 T5058 T5132 9048435.3085451759
Rt25379 T5058 T5357 4750492.4029176626
Rt25380 T5058 T5458 11929893.51796977
Rt25381 T5058 T5737 3888999.815434806
Gcorr8000 T5058 T6050 T5058 T6050 -7.9758044316504782e-09
Rt25382 T5059 T5323 1567165.5225269329
Rt25383 T5059 T5480 11316338.156529825
Rt25384 T5059 T5578 7254107.5976924272
Rt25385 T5059 T6018 2363494.2353174891
Rt25386 T5060 T5061 6876262.7157507995
Rt25387 T5060 T5062 350880.51206358755
Rt25388 T5060 T5693 2497316.5734867975
Gcorr8001 T5061 T5062 T5061 T5062 -9.1235083006230224e-09
Rt25389 T5061 T5262 6853457.6087795524
Gcorr8002 T5061 T5323 T5061 T5323 -6.9842856977268292e-08
Gcorr8003 T5061 T5324 T5061 T5324 -1.3964764880191413e-09
Rt25390 T5061 T5932 3893923.5227304497
Rt25391 T5061 T6048 2097595.1353694103
Gcorr8004 T5062 T5262 T5062 T5262 -3.5037177228518668e-08
Gcorr8005 T5062 T5693 T5062 T5693 -3.7913329456119503e-07
Rt25392 T5062 T5751 47637570.130233102
Rt25393 T5062 T6058 713011.88867524208
Rt25394 T5063 T5143 10567071.643047407
Rt25395 T5063 T5186 1991973.8420829915
Rt25396 T5063 T5248 10628816.420862831
Rt25397 T5063 T5581 4988509.7815611735
Gcorr8006 T5064 T5180 T5064 T5180 -1.1082940236993809e-07
Gcorr8007 T5064 T5429 T5064 T5429 -2.1864445215652243e-07
Rt25398 T5064 T5977 2307707.4294497538
Rt25399 T5064 T6030 8037519.0384264374
Gcorr8008 T5065 T5265 T5065 T5265 -2.3687300715599495e-08
Rt25400 T5065 T5317 2745351.1507694139
Rt25401 T5065 T5711 726538.6549317207
Gcorr8009 T5065 T5735 T5065 T5735 -1.3765463385463718e-07
Rt25402 T5065 T5786 4795007.0164776342
Rt25403 T5066 T5234 5002313.2307525575
Rt25404 T5066 T5236 9349254.5191365685
Rt25405 T5066 T5375 3058240.2665138328
Rt25406 T5066 T5599 4263510.0016604969
Rt25407 T5067 T5359 6745077.7593553597
Gcorr8010 T5067 T5386 T5067 T5386 -6.930103382340857e-08
Rt25408 T5067 T5893 4434889.7200811934
Rt25409 T5067 T5903 2782730.0729088229
Rt25410 T5068 T5556 7185175.9780311482
Rt25411 T5068 T5557 2687135.8223861493
Rt25412 T5068 T6024 939087.05773401645
Gcorr8011 T5068 T6044 T5068 T6044 -7.9767370609130275e-10
Rt25413 T5069 T5070 4612227.1785772219
Rt25414 T5069 T5158 10077993.232084107
Rt25415 T5069 T5418 14557886.436259059
Rt25416 T5069 T5707 1627219.9556211487
Rt25417 T5070 T5071 4226128.080084715
Rt25418 T5070 T5072 10103116.698488906
Rt25419 T5070 T5073 2932657.8723860923
Rt25420 T5070 T5418 4811217.8940915009
Rt25421 T5071 T5072 4818443.2068056921
Rt25422 T5071 T5605 58007350.204193279
Rt25423 T5071 T5938 6845784.4098667093
Rt25424 T5071 T5961 2658139.5595526085
Rt25425 T5072 T5073 4365089.6577111911
Rt25426 T5072 T5074 11209301.355248829
Rt25427 T5072 T5100 3999716.0934258313
Rt25428 T5072 T5961 7352629.6205586465
Rt25429 T5073 T5074 5395344.0984764062
Rt25430 T5073 T5075 9758618.9620295577
Rt25431 T5073 T5107 1702952.0562852903
Rt25432 T5073 T5418 9266071.8858417813
Rt25433 T5074 T5075 2954628.5274242954
Rt25434 T5074 T5076 10035422.325258438
Rt25435 T5074 T5100 4059202.1195356385
Rt25436 T5074 T5572 9199447.2333382182
Rt25437 T5075 T5076 4380984.0676548555
Rt25438 T5075 T5077 4767875.0681310343
Rt25439 T5075 T5107 2536184.6976143694
Rt25440 T5075 T5566 4803657.9995585848
Rt25441 T5076 T5077 10414958.823827818
Rt25442 T5076 T5078 1716428.9709242764
Rt25443 T5076 T5529 10708520.091268931
Rt25444 T5076 T5572 4438682.8984599309
Rt25445 T5077 T5078 1765965.6427790306
Rt25446 T5077 T5079 10081370.981388215
Rt25447 T5077 T5515 3573409.9804316428
Rt25448 T5077 T5566 4736432.0486894734
Rt25449 T5078 T5079 4473774.9809823819
Rt25450 T5078 T5080 4612120.1724654576
Rt25451 T5078 T5081 1745152.3547870384
Rt25452 T5078 T5529 1516722.0933505693
Rt25453 T5079 T5080 10367476.430451365
Rt25454 T5079 T5104 3892537.2126489957
Rt25455 T5079 T5144 5179780.9303756906
Rt25456 T5079 T5515 4795547.4150343351
Rt25457 T5080 T5081 9960879.3251486178
Rt25458 T5080 T5082 3702823.9544660319
Rt25459 T5080 T5104 4842484.1890514698
Rt25460 T5080 T5587 4688450.3355239909
Rt25461 T5081 T5082 5057859.8195667164
Rt25462 T5081 T5083 10259737.117816053
Rt25463 T5081 T5101 3741798.7380557242
Rt25464 T5081 T5529 10378151.063960783
Rt25465 T5082 T5083 3871918.6071177484
Rt25466 T5082 T5084 4350742.2765836436
Rt25467 T5082 T5085 1863123.8070633428
Rt25468 T5082 T5587 9512960.5775296893
Rt25469 T5083 T5084 10875279.673449736
Rt25470 T5083 T5097 3884991.3362275665
Rt25471 T5083 T5101 4002244.3570630578
Rt25472 T5083 T5857 10359291.382669741
Rt25473 T5084 T5085 10070096.047721282
Rt25474 T5084 T5086 2101523.5782332574
Rt25475 T5084 T5097 5483644.421273482
Rt25476 T5084 T5631 9750573.5600607637
Rt25477 T5085 T5086 4390516.5212971549
Rt25478 T5085 T5087 5209006.6020921674
Rt25479 T5085 T5587 1758864.2617930253
Rt25480 T5085 T5779 1304789.5728465491
Rt25481 T5086 T5087 10075095.642298205
Rt25482 T5086 T5088 880604.68174055335
Rt25483 T5086 T5098 3294721.0209601
Rt25484 T5086 T5631 3747336.7803767067
Rt25485 T5087 T5088 3760496.2887416137
Rt25486 T5087 T5089 4873254.905109698
Rt25487 T5087 T5099 11713073.849147022
Rt25488 T5087 T5779 2954016.7836888009
Rt25489 T5088 T5089 10631466.692165105
Rt25490 T5088 T5090 4119152.0648473906
Rt25491 T5088 T5098 10467406.60590918
Rt25492 T5088 T5647 10436572.616575217
Rt25493 T5089 T5090 4686427.1531741098
Rt25494 T5089 T5091 5139473.6814475534
Rt25495 T5089 T5099 4323864.97413358
Rt25496 T5089 T5524 9898506.6861523092
Rt25497 T5090 T5091 2563533.9837158425
Rt25498 T5090 T5092 3807195.2927825553
Rt25499 T5090 T5093 3741722.123693346
Rt25500 T5090 T5647 4167145.2292107046
Rt25501 T5091 T5092 10551572.471380565
Rt25502 T5091 T5096 4600242.828758711
Rt25503 T5091 T5106 973649.31653053104
Rt25504 T5091 T5524 1093877.545540818
Rt25505 T5092 T5093 4301715.2272044932
Rt25506 T5092 T5094 1319336.2378813226
Rt25507 T5092 T5096 1603957.1899201088
Rt25508 T5092 T5499 10593213.372721493
Rt25509 T5093 T5094 10483024.587086929
Rt25510 T5093 T5095 2998487.0515813287
Rt25511 T5093 T5647 9833245.2707236875
Rt25512 T5093 T5825 3728164.415997806
Rt25513 T5094 T5095 4200928.2527028592
Rt25514 T5094 T5102 4337827.863490684
Rt25515 T5094 T5108 4738049.7339589959
Rt25516 T5094 T5499 3542332.4246954932
Rt25517 T5095 T5102 11086742.853175294
Rt25518 T5095 T5103 3812333.9286001581
Rt25519 T5095 T5121 21295229.059633192
Rt25520 T5095 T5825 7232367.1649733596
Rt25521 T5096 T5106 5066129.9030087534
Rt25522 T5096 T5128 10633503.944683688
Rt25523 T5096 T5129 5148311.4116583094
Rt25524 T5096 T5499 4883594.0674543409
Rt25525 T5097 T5631 3289104.3999042977
Rt25526 T5097 T5857 2623100.5426977165
Rt25527 T5097 T5861 3495382.7313243821
Rt25528 T5098 T5631 3287625.2394492645
Rt25529 T5098 T5647 3946018.901675873
Rt25530 T5098 T5648 12178290.115440896
Rt25531 T5098 T5886 9063484.4115134794
Rt25532 T5099 T5269 2902837.5133831715
Rt25533 T5099 T5524 4129068.2269459614
Rt25534 T5099 T5779 2137230.8525975915
Rt25535 T5099 T5933 2596050.0978023834
Rt25536 T5100 T5572 3513364.3679505335
Rt25537 T5100 T5960 11039830.498757441
Rt25538 T5100 T5961 3219683.6327415258
Rt25539 T5100 T6059 7103567.670600499
Rt25540 T5101 T5529 11054881.187838046
Rt25541 T5101 T5818 3454546.9101816867
Rt25542 T5101 T5819 4753017.24168998
Rt25543 T5101 T5857 8909248.6419928018
Rt25544 T5102 T5103 2713715.6428968161
Rt25545 T5102 T5105 3652695.9952245485
Rt25546 T5102 T5108 9544682.0296281353
Rt25547 T5102 T5668 10313660.169205504
Rt25548 T5103 T5105 12795316.611060634
Rt25549 T5103 T5121 3343397.5655866857
Rt25550 T5103 T5122 3517364.3472856577
Rt25551 T5103 T5929 10605152.959834358
Rt25552 T5104 T5144 10081178.957638826
Rt25553 T5104 T5389 5054746.8032650342
Rt25554 T5104 T5390 19771067.074943107
Rt25555 T5104 T5587 4478561.818685784
Rt25556 T5104 T6078 4243308.2114338242
Rt25557 T5105 T5668 3638503.8575824215
Rt25558 T5105 T5669 16945778.411219068
Rt25559 T5105 T5929 3899461.2360373386
Rt25560 T5105 T6001 3130655.3993669949
Rt25561 T5106 T5128 4446267.8818333289
Rt25562 T5106 T5313 9993493.9595553074
Rt25563 T5106 T5524 9075833.0513889398
Rt25564 T5106 T5615 2402417.3607263668
Rt25565 T5107 T5418 4773510.3828848405
Rt25566 T5107 T5566 3228259.2387184133
Rt25567 T5107 T5791 5692316.7644076673
Rt25568 T5107 T5853 1509428.0744255551
Rt25569 T5108 T5499 5025950.5011650147
Rt25570 T5108 T5633 12529625.376773834
Rt25571 T5108 T5668 898185.44828906457
Rt25572 T5108 T5736 3527852.9139506598
Rt25573 T5108 T5999 8571153.1163090505
Rt25574 T5109 T5110 2377354.0371619039
Rt25575 T5109 T5173 260281.45151561638
Rt25576 T5109 T5345 3926247.9677260891
Rt25577 T5109 T5346 3670447.4119038563
Rt25578 T5110 T5173 4487614.0454129037
Rt25579 T5110 T5174 9661146.8613423631
Rt25580 T5110 T5176 819515.7597351321
Rt25581 T5110 T5826 746025.1050108762
Rt25582 T5111 T5213 3125568.4948711097
Rt25583 T5111 T5834 2541433.6341326097
Rt25584 T5111 T5870 1722764.3287172175
Gcorr8012 T5112 T5549 T5112 T5549 -1.0502493795252988e-08
Rt25585 T5112 T5659 5964365.4334901897
Gcorr8013 T5112 T5660 T5112 T5660 -2.082807615065402e-07
Rt25586 T5112 T5883 4865454.6862500254
Rt25587 T5112 T6007 13113436.562363839
Rt25588 T5113 T5114 3172140.399127509
Gcorr8014 T5113 T5235 T5113 T5235 -4.2228083808696305e-08
Rt25589 T5113 T5765 1065620.245750451
Gcorr8015 T5113 T6019 T5113 T6019 -1.4637302743193617e-07
Rt25590 T5114 T5235 5748137.2702477165
Rt25591 T5114 T5258 6183869.1014099577
Rt25592 T5114 T5428 2619603.2385174828
Rt25593 T5114 T5776 25147268.945844039
Gcorr8016 T5115 T5162 T5115 T5162 -1.4659552979922584e-07
Gcorr8017 T5115 T5343 T5115 T5343 -2.7172373631998321e-07
Rt25594 T5115 T5616 2807961.9479129142
Rt25595 T5115 T5917 2563123.6854916112
Rt25596 T5116 T5393 5258520.2682886329
Rt25597 T5116 T5527 344816.02703522309
Rt25598 T5116 T5717 1307434.3589500145
Rt25599 T5116 T5781 1049384.0317105327
Rt25600 T5117 T5241 11367498.187265811
Rt25601 T5117 T5328 2099803.835428392
Rt25602 T5117 T5350 10856496.431102967
Rt25603 T5117 T5734 1604022.2628273384
Rt25604 T5118 T5168 2709279.9114894527
Rt25605 T5118 T5172 64516180.560364068
Rt25606 T5118 T5265 2468915.3099301434
Rt25607 T5118 T5913 20844233.603352971
Rt25608 T5119 T5177 944411.66358606203
Rt25609 T5119 T5405 13767166.395927025
Rt25610 T5119 T5859 1948992.3121235895
Rt25611 T5119 T5927 2182118.5039064507
Gcorr8018 T5120 T5295 T5120 T5295 -2.2074641622757278e-07
Rt25612 T5120 T5693 4941266.4486573003
Rt25613 T5120 T5987 1277278.8950045849
Gcorr8019 T5120 T6016 T5120 T6016 -1.5076195272805809e-08
Rt25614 T5121 T5122 11270449.105956087
Rt25615 T5121 T5648 332683866.98181772
Rt25616 T5121 T5706 3559228.2768414048
Rt25617 T5121 T5825 3045802.8927541059
Rt25618 T5121 T6051 11778134.121573221
Gcorr8020 T5122 T5367 T5122 T5367 -1.4921253603776924e-07
Rt25619 T5122 T5706 11924200.302975602
Rt25620 T5122 T5929 3340471.9214062491
Rt25621 T5122 T6041 2357635.9338929355
Rt25622 T5123 T5124 4199349.5611181697
Rt25623 T5123 T5520 8292563.4749842389
Rt25624 T5123 T5621 3774207.2672398794
Rt25625 T5123 T5682 3924525.0876275892
Rt25626 T5123 T5970 14727165.531184593
Rt25627 T5124 T5621 6721940.7262604618
Rt25628 T5124 T5695 3407394.6308976626
Rt25629 T5124 T5833 6586519.8096036855
Rt25630 T5125 T5653 10187854.015525937
Rt25631 T5125 T5750 11286837.86238073
Rt25632 T5125 T5850 4300514.7487898162
Rt25633 T5125 T6028 3279098.0906417798
Rt25634 T5126 T5304 5691142.3792652264
Rt25635 T5126 T5305 14945065.236681754
Rt25636 T5126 T5320 4278478.4933718527
Rt25637 T5126 T6066 2245515.9801293272
Rt25638 T5127 T5170 3827676.067580963
Rt25639 T5127 T5179 2856648.1226392807
Gcorr8021 T5127 T5387 T5127 T5387 -6.9395620528465814e-09
Rt25640 T5127 T5700 1304373.8470971216
Rt25641 T5128 T5129 5194950.9826873187
Rt25642 T5128 T5130 13345054.141071828
Rt25643 T5128 T5313 4477668.2048090082
Rt25644 T5128 T5813 2391589.194540923
Rt25645 T5129 T5130 4661667.9746205946
Rt25646 T5129 T5424 10648377.132829079
Rt25647 T5129 T5499 4543602.405664105
Rt25648 T5129 T5736 3337168.7252251185
Rt25649 T5130 T5424 2686542.4968612916
Rt25650 T5130 T5697 1596204.1547158733
Rt25651 T5130 T5813 3454543.9465793348
Rt25652 T5130 T6081 863762.85616628348
Rt25653 T5131 T5221 4473214.6761299139
Rt25654 T5131 T5222 4235342.8421762697
Rt25655 T5131 T5833 8938169.2679678686
Rt25656 T5131 T5900 3228619.0904269284
Gcorr8022 T5132 T5472 T5132 T5472 -1.7203681686779105e-08
Rt25657 T5132 T5742 8598051.6074155346
Rt25658 T5132 T5951 2362349.7400181121
Rt25659 T5132 T6050 2559261.1796804131
Rt25660 T5133 T5207 1809885.4215932584
Rt25661 T5133 T5224 5273145.8063292913
Rt25662 T5133 T5380 3723588.1062958706
Rt25663 T5133 T5436 10359974.893122155
Rt25664 T5133 T6020 2450550.2704597092
Rt25665 T5134 T5703 4260054.8753178213
Rt25666 T5134 T5838 9156588.6649830863
Rt25667 T5134 T5899 2485270.2426800746
Rt25668 T5134 T5902 7649790.4459110955
Rt25669 T5135 T5136 3672768.0379866459
Rt25670 T5135 T5826 2882835.9124683617
Rt25671 T5135 T5827 12109732.924659297
Gcorr8023 T5136 T5799 T5136 T5799 -2.8605909588829822e-08
Rt25672 T5136 T5816 2070813.1278279829
Rt25673 T5136 T5827 11395430.958374746
Rt25674 T5136 T6032 1915077.857444562
Rt25675 T5137 T5215 4178193.3770365915
Rt25676 T5137 T5246 10929163.249664823
Rt25677 T5137 T5638 728481.09314744791
Rt25678 T5137 T5856 3553972.6576860831
Rt25679 T5138 T5430 15103144.710707029
Rt25680 T5138 T5431 19150268.808060631
Rt25681 T5138 T5552 10251725.640353661
Rt25682 T5138 T5808 923872.54166737851
Rt25683 T5139 T5149 4105412.4767508688
Gcorr8024 T5139 T5299 T5139 T5299 -1.4987821118348076e-08
Rt25684 T5139 T5620 12963233.377240598
Rt25685 T5139 T5921 3491407.0167285907
Rt25686 T5139 T5951 3757240.2806358454
Rt25687 T5140 T5391 1732152.5692985919
Rt25688 T5140 T5617 1412009.2993517143
Rt25689 T5140 T5663 2065223.6762166983
Rt25690 T5140 T5747 1458840.0161659846
Rt25691 T5141 T5438 4920726.6966288919
Rt25692 T5141 T5448 4538959.975432313
Rt25693 T5141 T5536 4378581.0192628475
Rt25694 T5141 T5577 4701306.7212641854
Rt25695 T5142 T5232 3985988.4537151437
Rt25696 T5142 T5239 3830147.0926115322
Rt25697 T5142 T5273 1497841.6583980962
Rt25698 T5142 T5738 7107153.346576646
Rt25699 T5143 T5575 3860889.5168350083
Rt25700 T5143 T5581 5437655.2810688652
Rt25701 T5143 T5685 19046642.147534665
Rt25702 T5143 T5906 3122145.0904172864
Rt25703 T5144 T5439 7677622.8826146862
Rt25704 T5144 T5515 5580968.955112299
Rt25705 T5144 T6045 8754558.4355008584
Rt25706 T5144 T6078 2239689.9016417749
Rt25707 T5145 T5223 14243460.20188801
Rt25708 T5145 T5781 1659035.4593535338
Rt25709 T5145 T5846 6817020.7391910935
Rt25710 T5145 T5908 3866293.8151686629
Rt25711 T5146 T5417 4723102.5832368815
Rt25712 T5146 T5543 11529560.077644931
Rt25713 T5146 T5561 16273235.490007449
Rt25714 T5146 T5568 3932801.0574581609
Rt25715 T5147 T5449 4390043.7218731092
Rt25716 T5147 T5471 9468467.505146984
Rt25717 T5147 T5475 623492.94414826692
Rt25718 T5147 T5592 9510975.3521697111
Rt25719 T5148 T5372 7531408.8000733582
Rt25720 T5148 T5482 4465675.5345418183
Rt25721 T5148 T5484 11799633.671289174
Rt25722 T5148 T5950 4840207.64544849
Rt25723 T5148 T5980 11950008.865265587
Rt25724 T5149 T5492 10826851.824583964
Rt25725 T5149 T5512 3974474.7682150118
Rt25726 T5149 T5519 4129805.8398758178
Rt25727 T5149 T5620 9880175.3891403954
Gcorr8025 T5150 T5655 T5150 T5655 -1.2582877098907814e-08
Rt25728 T5150 T5681 5203288.2743193889
Rt25729 T5150 T5847 1418058.5025625725
Rt25730 T5150 T5957 10774716.484372424
Rt25731 T5151 T5152 10986312.612414679
Rt25732 T5151 T5496 10441099.279196011
Rt25733 T5151 T5521 5964325.5399703979
Rt25734 T5151 T5701 4382819.0558103602
Rt25735 T5152 T5188 4676946.8228715472
Rt25736 T5152 T5189 3958104.088853179
Rt25737 T5152 T5356 16833215.773586892
Rt25738 T5152 T5701 2126446.8136911253
Rt25739 T5153 T5154 4625249.9724882916
Rt25740 T5153 T5155 5769132.5868656151
Rt25741 T5153 T5377 8264788.2156645553
Gcorr8026 T5153 T5753 T5153 T5753 -8.0129866872385789e-08
Rt25742 T5154 T5571 4673983.7799070729
Rt25743 T5154 T5618 3448080.1311446181
Rt25744 T5154 T5753 3600766.7852640511
Rt25745 T5154 T5988 3653640.8268237743
Rt25746 T5155 T5250 3721973.8451375603
Gcorr8027 T5155 T5251 T5155 T5251 -1.6882578291392705e-08
Rt25747 T5155 T5377 6862019.102197865
Rt25748 T5155 T5868 2455054.2736333674
Rt25749 T5156 T5399 2076162.1194154012
Rt25750 T5156 T5536 5017033.1768148988
Rt25751 T5156 T5577 1692832.6160488152
Rt25752 T5156 T5650 4653132.7807020918
Rt25753 T5157 T5212 18780033.489241246
Rt25754 T5157 T5388 5412819.8894549618
Rt25755 T5157 T5715 14247396.718391517
Rt25756 T5157 T6022 2067048.2706664375
Rt25757 T5158 T5399 5198828.1509580733
Rt25758 T5158 T5650 4775032.2881722637
Rt25759 T5158 T5707 1788055.7442335023
Rt25760 T5158 T5708 3427928.2256781808
Rt25761 T5159 T5160 27766307.820990238
Rt25762 T5159 T5260 13559902.214324083
Rt25763 T5159 T5806 8461783.330493832
Rt25764 T5159 T5807 12540400.756209474
Rt25765 T5159 T6030 13595349.0461231
Gcorr8028 T5160 T5322 T5160 T5322 -7.502455803864745e-08
Rt25766 T5160 T5905 3313185.4828917016
Rt25767 T5160 T5977 6092516.9403333152
Rt25768 T5160 T6030 3898959.6238649627
Rt25769 T5161 T5433 3316715.1082211933
Rt25770 T5161 T5434 14343353.009466233
Rt25771 T5161 T5901 3136837.0137192346
Rt25772 T5161 T6003 12142048.254854329
Gcorr8029 T5162 T5616 T5162 T5616 -3.9581717548821637e-07
Gcorr8030 T5162 T5803 T5162 T5803 -1.5685932442792385e-07
Rt25773 T5162 T5804 5547511.4898030348
Rt25774 T5162 T6007 1899250.1545266714
Rt25775 T5163 T5240 20722684.493685436
Rt25776 T5163 T5641 10705389.479854541
Rt25777 T5163 T5642 1348688.4646192375
Rt25778 T5163 T5894 3706776.0760864574
Rt25779 T5164 T5425 1588933.1717055596
Gcorr8031 T5164 T5597 T5164 T5597 -3.9120794090155815e-08
Rt25780 T5164 T5724 21591678.8622819
Rt25781 T5164 T5919 40501969.439327143
Rt25782 T5164 T6069 3780443.3495577183
Rt25783 T5165 T5209 18756340.407840453
Rt25784 T5165 T5225 4915457.4908723542
Gcorr8032 T5165 T5716 T5165 T5716 -1.3413470652013799e-07
Rt25785 T5165 T5837 1878010.8981082477
Rt25786 T5166 T5167 7890601.661918804
Rt25787 T5166 T5431 4796445.2357184757
Rt25788 T5166 T5862 2576554.6429636399
Rt25789 T5167 T5270 16582115.510848295
Rt25790 T5167 T5689 3524557.7053114125
Rt25791 T5167 T5690 1854618.4037880157
Rt25792 T5167 T5862 14194992.0508347
Rt25793 T5167 T5985 1502009.4189961578
Rt25794 T5168 T5172 6482549.0468166173
Rt25795 T5168 T5607 71468565.080169767
Rt25796 T5168 T5759 8154379.0611866908
Rt25797 T5168 T5939 1720163.7684620637
Rt25798 T5169 T5365 5008437.1719307508
Rt25799 T5169 T5562 4208897.115099458
Gcorr8033 T5169 T5697 T5169 T5697 -2.5847205856060613e-09
Gcorr8034 T5169 T5813 T5169 T5813 -2.7316080965765036e-08
Rt25800 T5169 T6081 2112649.2065250617
Rt25801 T5170 T5387 1627534.0727691322
Rt25802 T5170 T5444 11537371.652059438
Rt25803 T5170 T5628 3233003.9976904681
Rt25804 T5170 T5849 4304597.3109118454
Gcorr8035 T5171 T5213 T5171 T5213 -2.301946391115734e-07
Rt25805 T5171 T5870 3666129.6486162865
Rt25806 T5171 T5949 1740995.9748586339
Gcorr8036 T5172 T5759 T5172 T5759 -7.4897486619613973e-08
Rt25807 T5172 T5777 5418259.1902817916
Rt25808 T5172 T5913 948789.0168391983
Gcorr8037 T5172 T5971 T5172 T5971 -2.6689137226091698e-08
Rt25809 T5173 T5174 5238735.0134451855
Rt25810 T5173 T5175 17579178.039938033
Rt25811 T5173 T5345 2092302.6146992489
Rt25812 T5173 T5704 2580264.6893804143
Rt25813 T5174 T5175 5377204.7243304569
Rt25814 T5174 T5176 1127526.4509425405
Rt25815 T5174 T5187 4386690.0427569989
Rt25816 T5174 T5966 6140246.638643628
Rt25817 T5175 T5187 14928551.978492545
Rt25818 T5175 T5684 4059173.1270052078
Rt25819 T5175 T5704 3917145.2465227717
Rt25820 T5175 T5802 4568529.7551614922
Rt25821 T5176 T5646 41357088.943134837
Rt25822 T5176 T5675 4104583.3872659449
Rt25823 T5176 T5826 1825591.3181226421
Rt25824 T5176 T5966 660658.6730157308
Rt25825 T5177 T5217 2694202.9476672132
Rt25826 T5177 T5376 3881147.2224707389
Rt25827 T5177 T5405 3116082.3753145747
Rt25828 T5177 T6013 5109230.5228038784
Rt25829 T5178 T5412 10506597.306419468
Rt25830 T5178 T5609 3512260.3249110263
Rt25831 T5178 T5855 3458405.3108847882
Rt25832 T5178 T5997 3012764.3144456805
Rt25833 T5179 T5445 2968747.9969624993
Rt25834 T5179 T5700 41638260.039197139
Rt25835 T5179 T5863 6248839.8725133752
Rt25836 T5179 T5888 1811527.6571169919
Gcorr8038 T5180 T5429 T5180 T5429 -2.720625577913764e-07
Gcorr8039 T5180 T5764 T5180 T5764 -2.2550965595564693e-07
Rt25837 T5180 T5875 6173233.7322799964
Rt25838 T5180 T6052 820713.11006358464
Rt25839 T5181 T5821 3715285.7066422976
Rt25840 T5181 T5822 5348233.9705736814
Gcorr8040 T5181 T5823 T5181 T5823 -5.1155829413913833e-08
Rt25841 T5181 T6088 3394280.6684816889
Rt25842 T5182 T5298 3275990.3183650509
Rt25843 T5182 T5355 6520382.3435086878
Rt25844 T5182 T5495 3684880.6654648245
Rt25845 T5182 T5794 8373570.8477435941
Gcorr8041 T5183 T5368 T5183 T5368 -2.1912316555569548e-08
Rt25846 T5183 T5564 4871438.5482453611
Rt25847 T5183 T5959 7894207.8963408098
Rt25848 T5183 T6036 706020.30326930946
Rt25849 T5184 T5362 4344830.3588280594
Rt25850 T5184 T5733 43933748.389280163
Rt25851 T5184 T5876 2943163.867267895
Rt25852 T5184 T6031 2683374.542379126
Rt25853 T5185 T5840 3216950.3079857416
Rt25854 T5185 T5912 3033764.4779062965
Rt25855 T5186 T5248 4807582.2668020325
Rt25856 T5186 T5279 5502494.8071629601
Rt25857 T5186 T5755 5643509.8002132839
Rt25858 T5186 T5928 3407015.0093470206
Rt25859 T5187 T5645 202016502.14386401
Rt25860 T5187 T5802 3891205.9744040822
Rt25861 T5187 T5966 3180311.3763052654
Rt25862 T5187 T5972 2896310.6778176054
Rt25863 T5188 T5189 4495134.8122725086
Rt25864 T5188 T5190 11399303.585384613
Rt25865 T5188 T5547 5154500.8620454064
Rt25866 T5188 T5993 3462320.0059351353
Rt25867 T5189 T5190 2723543.1872138306
Rt25868 T5189 T5191 11155564.676030381
Rt25869 T5189 T5192 4973943.6902641011
Rt25870 T5189 T5356 27649407.394712232
Rt25871 T5190 T5191 1708238.2285847152
Rt25872 T5190 T5193 5793421.5330417957
Rt25873 T5190 T5678 6193712.5028361855
Rt25874 T5190 T5993 3080821.5588361379
Rt25875 T5191 T5192 4824910.1896854155
Rt25876 T5191 T5193 15238404.013389185
Rt25877 T5191 T5194 17039834.443042524
Rt25878 T5191 T6056 3764887.0869341283
Rt25879 T5192 T5194 4853135.3662627172
Rt25880 T5192 T5195 3218939.946807038
Rt25881 T5192 T5303 17439445.693247009
Rt25882 T5192 T5356 3088316.6169044957
Gcorr8042 T5193 T5643 T5193 T5643 -6.3914324079157886e-08
Rt25883 T5193 T5678 3001408.8508174787
Rt25884 T5193 T5748 7833275.4867366171
Rt25885 T5193 T5848 33164974.898012478
Rt25886 T5193 T6056 3136806.9470887342
Rt25887 T5194 T5195 11119456.392631069
Rt25888 T5194 T5199 5976750.3739642054
Rt25889 T5194 T5340 7463007.6745508984
Rt25890 T5194 T6056 2358771.7178008766
Rt25891 T5195 T5199 12349472.500121111
Rt25892 T5195 T5303 4445820.4104773663
Rt25893 T5195 T5314 12378896.838392962
Rt25894 T5195 T5426 3771613.3456625007
Rt25895 T5196 T5198 4558389.010528083
Rt25896 T5196 T5810 5509273.6681323294
Rt25897 T5196 T5860 4358326.8953864146
Rt25898 T5196 T5975 33651511.153898165
Rt25899 T5197 T5481 10155682.161918964
Rt25900 T5197 T5588 12184342.336554218
Rt25901 T5197 T5603 5030932.6342578493
Rt25902 T5197 T5677 3619648.1551074218
Rt25903 T5198 T5426 2186533.3461247198
Rt25904 T5198 T5852 3973257.302940778
Rt25905 T5198 T5860 14277090.564212598
Rt25906 T5199 T5340 892961.23207300622
Rt25907 T5199 T5426 1808808.133347729
Rt25908 T5199 T5852 1537029.7081863347
Gcorr8043 T5200 T5810 T5200 T5810 -4.6904423901274601e-08
Rt25909 T5200 T6038 4661411.4962386368
Rt25910 T5200 T6039 1508164.6408420822
Rt25911 T5201 T5445 11535979.629487051
Rt25912 T5201 T5598 52278434.307591386
Rt25913 T5201 T5863 2791326.7169452417
Rt25914 T5201 T6064 2630321.8942915211
Rt25915 T5202 T5203 5138494.3036654107
Rt25916 T5202 T5204 3777501.2593504968
Rt25917 T5202 T5649 3958485.6010660455
Rt25918 T5202 T5750 8286102.0509551885
Rt25919 T5203 T5398 4870339.4607179249
Rt25920 T5203 T5541 5172226.3644209635
Rt25921 T5203 T5584 4326680.8108088905
Rt25922 T5203 T5649 4938838.3995518573
Rt25923 T5204 T5260 4259011.9836016214
Rt25924 T5204 T5710 19473188.757980309
Rt25925 T5204 T5750 5071260.5735410741
Rt25926 T5204 T6028 3171990.3609111384
Rt25927 T5205 T5691 41798507.270204134
Rt25928 T5205 T5872 1976755.9367424129
Rt25929 T5205 T5879 780929.92344938894
Rt25930 T5206 T5772 2617618.8555232449
Rt25931 T5206 T5801 2657704.6568817967
Rt25932 T5206 T5996 2452804.1478080759
Rt25933 T5207 T5380 10992257.873537369
Rt25934 T5207 T5743 3970970.8807110051
Rt25935 T5207 T5931 2529074.5370233306
Rt25936 T5207 T5978 41602737.423602514
Rt25937 T5208 T5360 368253.53991162946
Rt25938 T5208 T5361 14440107.455853393
Rt25939 T5208 T5760 3898057.0742049539
Rt25940 T5208 T6017 5129261.8740703641
Rt25941 T5209 T5225 4867369.2053221241
Rt25942 T5209 T5230 24496276.888626721
Rt25943 T5209 T5768 3223898.5411949032
Rt25944 T5209 T5866 2404512.1651359838
Gcorr8044 T5210 T5669 T5210 T5669 -2.7779631074503581e-08
Rt25945 T5210 T5828 5775965.1446207874
Gcorr8045 T5210 T5829 T5210 T5829 -8.8599308507525854e-08
Rt25946 T5210 T6001 1907296.6142606558
Gcorr8046 T5210 T6072 T5210 T6072 -5.7397436425982068e-08
Gcorr8047 T5211 T5244 T5211 T5244 -1.8532129174742594e-07
Rt25947 T5211 T5582 5527252.5547229601
Gcorr8048 T5211 T5627 T5211 T5627 -8.920372919558166e-08
Rt25948 T5211 T5845 1650500.2557448579
Rt25949 T5212 T5388 3606858.8298809798
Rt25950 T5212 T5838 4017373.3603694304
Rt25951 T5212 T5872 3405048.2871034103
Rt25952 T5212 T5902 21814546.389138516
Rt25953 T5213 T5821 3421574.9596033436
Rt25954 T5213 T5822 46962262.611231603
Rt25955 T5213 T5870 3380496.8343983977
Rt25956 T5213 T5949 1670166.6341612479
Rt25957 T5214 T5799 2390249.2350774589
Rt25958 T5214 T5827 1358997.5540196504
Rt25959 T5215 T5246 8376546.1619956959
Rt25960 T5215 T5525 4275970.3851335654
Rt25961 T5215 T5688 4488673.8974018572
Rt25962 T5215 T6014 3060640.1480190363
Rt25963 T5216 T5233 17526376.32652504
Rt25964 T5216 T5300 6461547.2604851704
Rt25965 T5216 T5889 2725200.3866961002
Rt25966 T5216 T6062 2031724.8342912926
Rt25967 T5217 T5376 3627575.0982553861
Rt25968 T5217 T5654 22991650.104116641
Gcorr8049 T5217 T5782 T5217 T5782 -1.2378439743611208e-08
Rt25969 T5217 T6060 4724136.7185432622
Rt25970 T5217 T6068 2791355.2377003138
Rt25971 T5218 T5835 210324314.93192711
Rt25972 T5218 T5840 1949365.4577889282
Rt25973 T5218 T5881 2764782.6687980732
Rt25974 T5218 T5912 902936.62032948481
Rt25975 T5219 T5623 8220515.005338924
Rt25976 T5219 T5651 3489999.9950340339
Rt25977 T5219 T5695 8752351.619800495
Rt25978 T5220 T5387 3711640.6170027279
Rt25979 T5220 T5727 2331513.5673616943
Rt25980 T5220 T5871 2946788.7827552008
Rt25981 T5221 T5222 9257977.677786706
Rt25982 T5221 T5402 15075210.479192449
Rt25983 T5221 T5596 10920020.732598361
Rt25984 T5221 T6079 2347026.1609885856
Rt25985 T5222 T5402 4959503.2353398558
Rt25986 T5222 T5754 4717085.7654350083
Rt25987 T5222 T5815 5174941.4960210463
Rt25988 T5222 T5900 8770112.3005837947
Rt25989 T5223 T5357 6065077.3166497042
Rt25990 T5223 T5742 4237651.3198137963
Rt25991 T5223 T5908 3040642.2182112848
Rt25992 T5223 T6050 5456957.2500925576
Rt25993 T5224 T5984 1397775.5944728637
Rt25994 T5224 T6002 1640265.7264313423
Rt25995 T5224 T6020 4034557.2753571733
Rt25996 T5225 T5769 3776416.7660445818
Rt25997 T5225 T5837 14681590.566860205
Rt25998 T5225 T5866 30285343.906866841
Rt25999 T5225 T6087 2844318.4438469284
Rt26000 T5226 T5227 13958711.869575365
Rt26001 T5226 T5228 11057149.301164217
Rt26002 T5226 T5307 4868472.4832592858
Rt26003 T5226 T5898 2113664.4936207756
Rt26004 T5227 T5307 4398812.7720818259
Rt26005 T5227 T5420 20769819.447852001
Rt26006 T5227 T6023 2495893.3795484328
Rt26007 T5228 T5229 4683430.1670834851
Rt26008 T5228 T5442 3242517.8999854936
Rt26009 T5228 T5898 8064082.190622028
Rt26010 T5229 T5372 7745079.3687258456
Rt26011 T5229 T5442 17411398.201773141
Rt26012 T5229 T6042 2545022.8878374211
Rt26013 T5229 T6080 2464384.1082653846
Rt26014 T5230 T5231 4029461.64928276
Rt26015 T5230 T5709 3662837.9361759373
Rt26016 T5230 T5768 4079825.0015152963
Rt26017 T5230 T5784 3280975.828198384
Rt26018 T5231 T5784 5912107.5503281951
Rt26019 T5231 T5858 3678611.0260192342
Rt26020 T5231 T5968 1917094.2704300294
Rt26021 T5232 T5239 10416452.121141648
Rt26022 T5232 T5311 17059639.09314163
Rt26023 T5232 T6077 1667861.5288713151
Rt26024 T5233 T5300 1600230.7330661607
Rt26025 T5233 T5698 3741954.2658183114
Rt26026 T5233 T6026 4493689.6395693738
Rt26027 T5234 T5599 8848248.4501695558
Rt26028 T5234 T5855 6099775.2043243656
Rt26029 T5234 T5997 2543525.9943279787
Rt26030 T5235 T5776 2734964.3310170108
Rt26031 T5235 T5880 36414558.599590354
Rt26032 T5235 T6019 6028333.4891880443
Rt26033 T5236 T5237 4738241.5416304599
Rt26034 T5236 T5375 6202852.8030214794
Rt26035 T5236 T5392 10056214.320063196
Rt26036 T5236 T6054 2730480.9755641166
Rt26037 T5237 T5392 2498360.8109875745
Rt26038 T5237 T5395 4703719.3453121642
Rt26039 T5237 T5396 4058489.3751938273
Rt26040 T5237 T5466 29881814.38563206
Gcorr8050 T5238 T5366 T5238 T5366 -3.1504912638159799e-08
Rt26041 T5238 T5427 2832747.569501834
Gcorr8051 T5238 T5580 T5238 T5580 -1.1972561726738674e-07
Rt26042 T5238 T5979 2480461.8000600762
Rt26043 T5239 T5311 3684840.1254974646
Rt26044 T5239 T5738 3912822.4958327548
Rt26045 T5239 T5745 2822883.6460430445
Rt26046 T5240 T5352 3633901.1102382801
Rt26047 T5240 T5894 7769077.0928404359
Gcorr8052 T5240 T5954 T5240 T5954 -7.1588901975836038e-08
Rt26048 T5240 T6011 1931717.9677656153
Rt26049 T5241 T5242 5869685.700596801
Rt26050 T5241 T5734 4257187.1160885105
Rt26051 T5241 T5814 7934494.3532321416
Rt26052 T5241 T5936 2701278.2231767019
Rt26053 T5242 T5590 9640647.3895263337
Rt26054 T5242 T5662 14860255.06570795
Rt26055 T5242 T5936 6841396.816892528
Rt26056 T5242 T6043 1296115.7811333132
Rt26057 T5243 T5559 5396353.1940856604
Rt26058 T5243 T5756 11265746.215046117
Rt26059 T5243 T6066 2119672.0894226255
Rt26060 T5244 T5582 2091055.5804869728
Rt26061 T5244 T5845 6913277.3503319845
Rt26062 T5244 T5885 2156487.5259453878
Rt26063 T5245 T5301 2136163.4567838768
Rt26064 T5245 T5772 4139540.2740625218
Rt26065 T5245 T5996 2568786.531872985
Rt26066 T5246 T5688 4697968.6717622243
Rt26067 T5246 T5856 2766915.8089253418
Rt26068 T5246 T6037 2344240.7669362081
Rt26069 T5247 T5270 11491738.650335263
Rt26070 T5247 T5918 1667483.5759910485
Rt26071 T5247 T5983 1080085.8733204068
Rt26072 T5248 T5279 4378925.2321821116
Rt26073 T5248 T5581 5157073.2001649067
Gcorr8053 T5248 T5876 T5248 T5876 -8.6241560534345012e-09
Rt26074 T5248 T6031 2600355.3576992676
Rt26075 T5249 T5326 13395400.70370443
Gcorr8054 T5249 T5349 T5249 T5349 -3.3716668991396601e-08
Rt26076 T5249 T5832 9744003.7195273098
Rt26077 T5249 T5969 2338081.2754944246
Rt26078 T5250 T5251 7174226.7313890867
Rt26079 T5250 T5339 1928508.7818167659
Rt26080 T5250 T5369 75574733.048512086
Gcorr8055 T5250 T5944 T5250 T5944 -1.1404279887515445e-09
Rt26081 T5251 T5339 1947587.7855132935
Rt26082 T5251 T5868 1154833.8641683953
Gcorr8056 T5251 T5930 T5251 T5930 -8.316388395619567e-09
Gcorr8057 T5251 T6047 T5251 T6047 -2.7725104635199657e-08
Rt26083 T5252 T5787 3159860.807361546
Rt26084 T5252 T5863 4181951.8636323186
Rt26085 T5252 T6064 2574151.8744349545
Rt26086 T5253 T5602 2577949.2868339713
Rt26087 T5253 T5771 1060804.6336081708
Rt26088 T5254 T5344 5841340.7336982386
Rt26089 T5254 T5373 2888014.3625756726
Rt26090 T5254 T5752 4267238.2872040356
Rt26091 T5254 T5884 3012123.3735319288
Rt26092 T5255 T5413 3425055.5219467278
Rt26093 T5255 T5760 2565372.3448154517
Rt26094 T5255 T5920 2071210.5208330762
Rt26095 T5255 T6017 24932996.291405804
Rt26096 T5256 T5679 49048676.971842572
Rt26097 T5256 T5748 1393801.0404283952
Rt26098 T5256 T5917 1318536.8144938236
Rt26099 T5256 T6033 12363881.825219817
Rt26100 T5257 T5326 4281873.22215469
Rt26101 T5257 T5909 2002078.5979494627
Rt26102 T5257 T5969 3234577.7024589572
Rt26103 T5258 T5259 8163244.2849790342
Rt26104 T5258 T5428 20115967.206681911
Rt26105 T5258 T5612 21395740.371357705
Rt26106 T5258 T5842 1585095.1338240048
Rt26107 T5258 T5976 5013519.3117484115
Rt26108 T5259 T5612 7158937.3608419336
Rt26109 T5259 T5639 7514378.6269367253
Rt26110 T5259 T5995 5452124.0143502411
Rt26111 T5259 T6070 2368181.7022262248
Rt26112 T5260 T5710 1408889.1072003741
Rt26113 T5260 T5806 1153066.722942322
Rt26114 T5260 T5807 1574172.2607158523
Rt26115 T5261 T5687 560670.91672914464
Rt26116 T5261 T5973 1704792.0625022762
Rt26117 T5261 T5989 3565898.1687591313
Rt26118 T5262 T5931 11916060.737318005
Rt26119 T5262 T5932 1951536.660650895
Rt26120 T5262 T5978 7395236.4320611283
Rt26121 T5262 T6058 1822386.4547238699
Rt26122 T5263 T5757 6384747.5722262356
Rt26123 T5263 T5879 864958.89672999736
Gcorr8058 T5263 T5890 T5263 T5890 -7.0124125818418033e-08
Rt26124 T5264 T5325 2170664.3195066177
Rt26125 T5264 T5626 15262944.714754805
Rt26126 T5264 T6085 1434808.7744775049
Rt26127 T5265 T5711 20303778.415279265
Rt26128 T5265 T5735 2604294.1404196816
Rt26129 T5265 T5913 1323753.3077431545
Rt26130 T5266 T5351 6764677.3979097698
Rt26131 T5266 T5381 8763053.298616644
Rt26132 T5266 T5960 13586821.056861764
Rt26133 T5267 T5268 3817550.0888431552
Rt26134 T5267 T5269 8459651.5093582235
Rt26135 T5268 T5269 6298599.4789287699
Rt26136 T5268 T5389 12099748.455363426
Rt26137 T5268 T5390 4605080.5169948535
Rt26138 T5268 T5933 2756508.1828536629
Rt26139 T5269 T5524 4602007.4902654514
Rt26140 T5269 T5615 791102.57287297514
Rt26141 T5269 T5933 4545196.4625846967
Rt26142 T5270 T5593 5088826.6889442569
Rt26143 T5270 T5690 5656148.8479760569
Rt26144 T5270 T5918 2189811.7575519322
Rt26145 T5270 T5985 11310101.632252334
Gcorr8059 T5271 T5272 T5271 T5272 -4.473967283826383e-08
Rt26146 T5271 T5383 2498958.1970592435
Rt26147 T5271 T5861 3563385.4381926777
Gcorr8060 T5272 T5706 T5272 T5706 -6.2359071109135486e-09
Rt26148 T5272 T5861 2595759.0697674914
Rt26149 T5272 T5886 3450882.1184776924
Rt26150 T5272 T6051 2381829.4243096006
Rt26151 T5273 T5274 8616246.4566569291
Rt26152 T5273 T5738 1386805.6282426212
Rt26153 T5273 T6067 10559465.068346009
Rt26154 T5274 T5364 4065583.1063270723
Rt26155 T5274 T5721 4003205.303757716
Rt26156 T5274 T5741 134161033.54734588
Rt26157 T5274 T6067 2184503.1890130155
Gcorr8061 T5275 T5276 T5275 T5276 -1.0101173794252337e-08
Rt26158 T5275 T5277 6278006.1165870661
Gcorr8062 T5275 T5878 T5275 T5878 -6.4983138061219496e-08
Rt26159 T5275 T6083 890898.69912527211
Rt26160 T5276 T5744 4847941.0296161892
Gcorr8063 T5276 T5782 T5276 T5782 -6.8576990287129752e-08
Rt26161 T5276 T5877 2526090.6543813553
Rt26162 T5276 T5878 2726834.0570892794
Rt26163 T5276 T6083 1266053.0600763909
Rt26164 T5277 T5278 6641024.6056415755
Gcorr8064 T5277 T5594 T5277 T5594 -9.9204849461889278e-09
Rt26165 T5277 T5878 5788111.0118861329
Rt26166 T5277 T5962 2314090.2894416037
Rt26167 T5278 T5576 7151381.6873657117
Rt26168 T5278 T5676 10472983.684014527
Rt26169 T5278 T5892 8791321.328261992
Gcorr8065 T5278 T5962 T5278 T5962 -3.8502146486126194e-08
Rt26170 T5278 T5974 3107840.5147738797
Rt26171 T5279 T5876 3832611.0058272304
Rt26172 T5279 T5928 8341299.513241821
Rt26173 T5279 T6065 2047620.2159562556
Rt26174 T5280 T6053 1429487.8754870465
Rt26175 T5280 T6086 1952954.2000150112
Rt26176 T5281 T5282 2649030.6300818557
Rt26177 T5281 T5283 4188723.290683032
Rt26178 T5281 T5285 2361705.3893902698
Rt26179 T5281 T5729 6244808.2661527116
Rt26180 T5281 T6086 2714733.609945768
Gcorr8066 T5282 T5283 T5282 T5283 -3.3483941282423934e-08
Rt26181 T5282 T5284 2355949.4440510119
Gcorr8067 T5282 T5292 T5282 T5292 -1.6906648388380306e-07
Rt26182 T5282 T5843 5115176.4393935399
Rt26183 T5283 T5284 2765966.8891770053
Rt26184 T5283 T5285 8150497.8514807438
Gcorr8068 T5283 T5286 T5283 T5286 -7.6498655747951091e-08
Gcorr8069 T5283 T5290 T5283 T5290 -2.0957902021889419e-08
Rt26185 T5283 T5952 1904520.9802091932
Rt26186 T5284 T5286 2299096.15052224
Rt26187 T5284 T5287 3730402.664217324
Rt26188 T5284 T5608 832366.28889015946
Gcorr8070 T5284 T5843 T5284 T5843 -1.1768053595111982e-07
Rt26189 T5285 T5290 7272438.9004125847
Rt26190 T5285 T5318 4717389.6180275474
Rt26191 T5285 T5319 5005094.9060399197
Rt26192 T5285 T5729 3901180.3986433684
Rt26193 T5286 T5287 6904739.2492783777
Rt26194 T5286 T5288 72716707.615508065
Rt26195 T5286 T5586 9198820.0547169875
Rt26196 T5286 T5713 20708003.883030076
Rt26197 T5286 T5952 2327964.2294335128
Rt26198 T5287 T5288 5307330.1434014002
Rt26199 T5287 T5293 4105521.0515481373
Gcorr8071 T5287 T5608 T5287 T5608 -2.1124616032826781e-08
Rt26200 T5287 T6015 553519.80117481446
Rt26201 T5288 T5293 6609229.6531327991
Rt26202 T5288 T5571 5048151.7271407638
Rt26203 T5288 T5579 12061429.576935831
Rt26204 T5288 T5586 5247945.4277034178
Rt26205 T5289 T5640 3771834.2131841406
Rt26206 T5289 T5729 14191025.400050156
Rt26207 T5289 T5882 3636859.8014501305
Rt26208 T5289 T6053 2830688.3968031984
Rt26209 T5289 T6086 5742806.4188045021
Rt26210 T5290 T5318 4772321.8686362309
Rt26211 T5290 T5713 12737934.88065711
Rt26212 T5290 T5795 1791147.4839478831
Rt26213 T5290 T5952 2728979.4531625644
Rt26214 T5291 T5293 10250005.53160724
Gcorr8072 T5291 T5608 T5291 T5608 -9.7449151454854581e-08
Rt26215 T5291 T6015 1823178.1371504171
Rt26216 T5292 T5843 2436841.4751933245
Gcorr8073 T5292 T5887 T5292 T5887 -4.1818722383920221e-08
Rt26217 T5293 T5571 4063936.206232965
Gcorr8074 T5293 T5753 T5293 T5753 -8.3949774315008504e-08
Rt26218 T5293 T6015 6628577.3005215833
Rt26219 T5294 T5378 3876570.8835327765
Rt26220 T5294 T5735 18040002.562413085
Rt26221 T5294 T5941 2343828.9874240584
Rt26222 T5295 T5693 4139287.18594839
Rt26223 T5295 T5873 2341334.8414380862
Rt26224 T5295 T6016 1955531.0820166524
Rt26225 T5296 T5340 12398031.818414964
Rt26226 T5296 T5643 1133945.1284448516
Rt26227 T5296 T5848 23841612.61920879
Rt26228 T5297 T5423 5300703.3107563257
Rt26229 T5297 T5766 5472860.4148061164
Rt26230 T5297 T5871 3367735.3512540828
Rt26231 T5298 T5794 3027354.9418914663
Rt26232 T5298 T5892 946400.48619576776
Rt26233 T5298 T5974 6721334.8467598045
Rt26234 T5299 T5472 4382728.5841215393
Rt26235 T5299 T5921 3025881.6570272921
Rt26236 T5299 T5951 2615624.2457410619
Rt26237 T5300 T5778 2597176.4259447404
Rt26238 T5300 T5889 593664.69988294994
Rt26239 T5300 T5981 1929559.6258334606
Rt26240 T5300 T6026 2566370.122177965
Rt26241 T5301 T5761 11588911.037006058
Rt26242 T5302 T5389 6968313.3714334071
Rt26243 T5302 T5439 10217611.467113096
Rt26244 T5302 T6078 982099.61196016066
Rt26245 T5303 T5314 4844354.5348729547
Rt26246 T5303 T5356 5782109.2022921536
Rt26247 T5303 T5567 3493185.2490006043
Rt26248 T5303 T6009 8498068.9754104372
Rt26249 T5304 T5305 3858022.8481153119
Rt26250 T5304 T5419 10075578.601327458
Rt26251 T5304 T5578 3754944.3480310692
Rt26252 T5305 T5320 43349599.929616429
Rt26253 T5305 T5419 5468832.9572836636
Gcorr8075 T5305 T5488 T5305 T5488 -8.7101709721894647e-09
Rt26254 T5305 T6046 1958792.6552522308
Rt26255 T5305 T6049 3061138.5814204863
Rt26256 T5306 T5728 4717761.2508557867
Rt26257 T5306 T5749 10168115.164435331
Rt26258 T5306 T5987 4362711.2824471798
Rt26259 T5307 T5897 2770104.2411631341
Rt26260 T5307 T5898 7500510.3098953832
Rt26261 T5307 T5964 2538559.7703936123
Rt26262 T5307 T6023 21532992.516282514
Rt26263 T5308 T5751 826533.42541282962
Rt26264 T5308 T5893 4253905.6656278241
Gcorr8076 T5308 T5978 T5308 T5978 -7.6860036395879681e-08
Rt26265 T5308 T6058 6304593.075802532
Rt26266 T5309 T5310 85663698.994130686
Rt26267 T5309 T5411 17694712.131620172
Rt26268 T5309 T5714 2744931.224248372
Rt26269 T5310 T5714 7930698.3332668412
Rt26270 T5310 T5758 4968276.3815072626
Gcorr8077 T5310 T5910 T5310 T5910 -3.4188986972952996e-08
Rt26271 T5310 T5953 2869809.8559345962
Gcorr8078 T5311 T5745 T5311 T5745 -3.7936515112841384e-08
Rt26272 T5311 T5790 2915277.4177434281
Rt26273 T5311 T6004 2897004.1277641626
Rt26274 T5311 T6077 4157160.8012758577
Rt26275 T5312 T5495 3973254.9467816339
Rt26276 T5312 T5936 2416417.3732150975
Rt26277 T5312 T6043 1650261.4582428909
Rt26278 T5313 T5615 3346328.962155174
Rt26279 T5313 T5622 3483121.5351130944
Rt26280 T5313 T5813 3912653.9618730014
Rt26281 T5314 T5426 5445262.6539608557
Rt26282 T5314 T5595 3638182.3580369842
Rt26283 T5314 T5967 7832092.9511424946
Rt26284 T5315 T5852 4486281.41379283
Rt26285 T5315 T5860 720868.73684887507
Gcorr8079 T5316 T5774 T5316 T5774 -6.8939750940096596e-09
Rt26286 T5316 T5775 6093075.074051328
Rt26287 T5316 T5776 3749019.8643871788
Gcorr8080 T5316 T5851 T5316 T5851 -1.4819655946845517e-07
Rt26288 T5317 T5786 11367025.55131774
Rt26289 T5317 T5798 995008.81057355704
Gcorr8081 T5317 T5828 T5317 T5828 -1.4200558289118332e-08
Rt26290 T5318 T5319 12655829.041078707
Rt26291 T5318 T5664 85115321.014062673
Rt26292 T5318 T5719 3094749.4168005968
Gcorr8082 T5318 T5795 T5318 T5795 -2.7060502613324735e-08
Rt26293 T5319 T5664 4762953.6257806234
Rt26294 T5319 T5729 3081117.2005963488
Rt26295 T5319 T5882 1595266.0053709762
Rt26296 T5319 T6021 4228657.5645698206
Rt26297 T5320 T5756 2611976.8770636856
Rt26298 T5320 T6046 1136887.9532221647
Rt26299 T5320 T6066 29158233.896152735
Rt26300 T5320 T6089 2579809.8090581759
Rt26301 T5321 T5330 9241953.381739486
Rt26302 T5321 T5757 673722.94573768543
Gcorr8083 T5322 T5429 T5322 T5429 -1.0790841787286751e-07
Rt26303 T5322 T5905 4483465.5875758668
Rt26304 T5322 T5977 4143118.2627596222
Rt26305 T5323 T5324 3192533.9834692278
Rt26306 T5323 T5578 19904466.734251574
Rt26307 T5323 T6048 2271154.9353599981
Rt26308 T5324 T5583 4549818.3249318227
Rt26309 T5324 T5932 3335540.8562525278
Rt26310 T5324 T6025 3356490.1598209692
Rt26311 T5325 T5604 1623776.6117851266
Rt26312 T5325 T5626 1556237.0720870765
Rt26313 T5326 T5746 3714470.4698519977
Rt26314 T5326 T5832 5313300.1897912333
Gcorr8084 T5326 T5969 T5326 T5969 -5.6911663518133358e-08
Rt26315 T5326 T6035 4308386.1739388676
Rt26316 T5327 T5384 2887169.9396328339
Rt26317 T5327 T5385 2040246.2063922889
Rt26318 T5327 T5545 4370214.860858269
Rt26319 T5328 T5350 1307608.6233811285
Rt26320 T5328 T5437 4211613.2938412633
Rt26321 T5328 T5561 1592482.7450439325
Rt26322 T5329 T5330 1216425.8090472755
Rt26323 T5329 T5759 22133436.822817009
Rt26324 T5329 T5939 1416868.5055495843
Rt26325 T5330 T5598 3547290.3684129431
Rt26326 T5331 T5332 4716511.2744278116
Rt26327 T5331 T5394 4398172.961860274
Rt26328 T5331 T5560 4708013.6048488608
Rt26329 T5332 T5333 5114285.9402581835
Rt26330 T5332 T5560 10061804.915440874
Rt26331 T5332 T5629 3739480.0403043465
Rt26332 T5332 T5686 4530931.1523228809
Rt26333 T5333 T5334 4551343.9015898965
Rt26334 T5333 T5686 4165242.7001947905
Rt26335 T5334 T5374 10317191.888328873
Rt26336 T5334 T5667 3218280.7368594734
Rt26337 T5334 T5686 27973245.971474458
Rt26338 T5334 T5725 2017521.43443865
Rt26339 T5335 T5899 5217964.285394486
Rt26340 T5335 T6010 2596862.3515117154
Rt26341 T5335 T6012 5196473.910023991
Rt26342 T5336 T5337 40004819.140651457
Rt26343 T5336 T5762 83351813.838125706
Rt26344 T5336 T5763 1134918.6476526931
Gcorr8085 T5336 T5945 T5336 T5945 -2.255172506430159e-08
Gcorr8086 T5337 T5338 T5337 T5338 -5.851259943540792e-08
Rt26345 T5337 T5762 4524786.0277470285
Rt26346 T5337 T5831 3936529.4351717113
Gcorr8087 T5338 T5672 T5338 T5672 -1.3824513768064254e-07
Rt26347 T5338 T5789 5464640.4229455171
Rt26348 T5338 T5831 57412339.544261999
Rt26349 T5338 T5874 1101563.2083462856
Rt26350 T5339 T5369 1614153.7669978319
Rt26351 T5339 T5370 6442408.3888473259
Rt26352 T5339 T5926 7409219.8796042828
Rt26353 T5339 T5930 241212.61650677337
Rt26354 T5340 T5848 3792788.0007457724
Gcorr8088 T5340 T5852 T5340 T5852 -6.7031612956319649e-08
Rt26355 T5340 T6056 10618527.765956271
Rt26356 T5341 T5754 2549434.1822405122
Rt26357 T5341 T5817 8036752.1330297664
Rt26358 T5341 T6061 163830176.04943833
Rt26359 T5342 T5504 4929456.6838355958
Rt26360 T5342 T5691 4509471.8462150563
Rt26361 T5342 T5895 2291651.8651710954
Gcorr8089 T5343 T5616 T5343 T5616 -3.0769957036862129e-07
Rt26362 T5343 T5917 786445.17364997475
Gcorr8090 T5343 T6033 T5343 T6033 -1.5757438919873192e-07
Gcorr8091 T5344 T5355 T5344 T5355 -1.3474873917492393e-08
Rt26363 T5344 T5491 7205492.3627708172
Rt26364 T5344 T5884 3707235.9480656581
Rt26365 T5344 T6073 1317511.4119975271
Rt26366 T5345 T5346 14021896.723776318
Rt26367 T5345 T5704 6311848.735028876
Rt26368 T5345 T5726 4408212.8165093977
Rt26369 T5345 T6075 5397964.3898000317
Rt26370 T5346 T5726 3944322.2557845954
Rt26371 T5346 T5904 12281084.484991033
Rt26372 T5346 T5991 2776081.4980388279
Rt26373 T5347 T5447 9616674.4753239192
Rt26374 T5347 T5627 2799955.4792242381
Rt26375 T5347 T5905 2032967.1159563118
Rt26376 T5348 T5646 13713566.171161585
Rt26377 T5348 T5675 2120525.6685918611
Rt26378 T5348 T5761 1316879.0914691498
Rt26379 T5349 T5634 3320230.2291579796
Gcorr8092 T5349 T5770 T5349 T5770 -4.8339872310436093e-08
Gcorr8093 T5349 T5969 T5349 T5969 -1.1027183788347737e-07
Rt26380 T5349 T6034 1791770.0819471546
Rt26381 T5350 T5561 9796426.0988707915
Rt26382 T5350 T5666 3752776.8422513739
Rt26383 T5350 T5734 4993337.2257690122
Rt26384 T5351 T5605 12599180.433967633
Rt26385 T5351 T5960 2533330.4506730158
Rt26386 T5351 T5961 2666631.3869903996
Rt26387 T5352 T5804 7663528.2680242853
Rt26388 T5352 T5847 1384967.633168272
Gcorr8094 T5352 T6011 T5352 T6011 -1.1055518135462295e-08
Rt26389 T5353 T5354 1730380.8334714605
Rt26390 T5353 T5451 4574835.0977855483
Rt26391 T5353 T5546 10379850.234870866
Rt26392 T5354 T5391 4570875.0674611013
Rt26393 T5354 T5481 1783625.7740118932
Rt26394 T5354 T5546 1630836.1025249474
Rt26395 T5355 T5494 4784960.4794818573
Gcorr8095 T5355 T5495 T5355 T5495 -6.2828267602839404e-09
Rt26396 T5355 T5794 2330278.1726442678
Rt26397 T5355 T6073 2111077.3388537159
Rt26398 T5356 T5701 3117362.7461426388
Rt26399 T5356 T6009 2635130.4821341634
Rt26400 T5357 T5525 4446205.0649309158
Rt26401 T5357 T5737 7180873.1145052817
Rt26402 T5357 T6050 2389297.6840501251
Gcorr8096 T5358 T5359 T5358 T5359 -4.0863617612444146e-07
Gcorr8097 T5358 T5796 T5358 T5796 -6.7501678423334495e-08
Rt26403 T5358 T5935 654703.36223080242
Gcorr8098 T5358 T6006 T5358 T6006 -2.9202786590511386e-08
Gcorr8099 T5359 T5386 T5359 T5386 -1.9370213352241017e-07
Gcorr8100 T5359 T5903 T5359 T5903 -2.8415717859296632e-07
Rt26404 T5359 T5935 1635232.5575413839
Rt26405 T5360 T5361 34333789.699385636
Rt26406 T5360 T5943 1077092.1532019894
Rt26407 T5360 T5982 1495945.7891231067
Gcorr8101 T5361 T5551 T5361 T5551 -2.9824655798100499e-08
Rt26408 T5361 T5760 1480879.1214913549
Gcorr8102 T5361 T5920 T5361 T5920 -4.38392347340226e-08
Rt26409 T5361 T5948 2362415.7872159323
Rt26410 T5361 T5982 1913508.7623293225
Rt26411 T5362 T5363 12378960.393413771
Rt26412 T5362 T5733 3463483.1334491223
Rt26413 T5363 T5573 4574262.5456444873
Rt26414 T5363 T5674 10210221.081280496
Rt26415 T5363 T5683 3333873.5800122395
Rt26416 T5363 T5733 3855490.2726436215
Rt26417 T5364 T5393 3455765.0721629728
Rt26418 T5364 T5717 5892551.5644651586
Rt26419 T5364 T5741 3097726.3423573123
Rt26420 T5365 T5553 4323554.4854224548
Rt26421 T5365 T5562 4239540.9599767495
Rt26422 T5366 T5427 666153.2057529845
Rt26423 T5366 T5805 1593112.1818434235
Gcorr8103 T5366 T5865 T5366 T5865 -3.1754053448820147e-07
Rt26424 T5366 T5940 2855805.302116272
Gcorr8104 T5367 T5706 T5367 T5706 -1.3608932601081265e-07
Rt26425 T5367 T6041 1132817.3542696454
Gcorr8105 T5368 T5575 T5368 T5575 -3.4737553357962234e-08
Rt26426 T5368 T5685 1787266.2147276748
Gcorr8106 T5368 T5907 T5368 T5907 -4.3650426234672345e-08
Rt26427 T5368 T5959 1379988.048410886
Rt26428 T5368 T6036 3208439.5216060318
Gcorr8107 T5369 T5370 T5369 T5370 -1.2361063942048838e-08
Gcorr8108 T5369 T5371 T5369 T5371 -1.8882131102107501e-08
Rt26429 T5369 T5956 1188094.9543519109
Rt26430 T5370 T5371 6576226.3964057984
Rt26431 T5370 T5925 4873226.6371414317
Rt26432 T5370 T5926 4564152.2999576386
Rt26433 T5370 T5994 5996287.5973119978
Rt26434 T5371 T5712 16809783.701157898
Rt26435 T5371 T5780 22774979.801955562
Rt26436 T5371 T5956 2615363.3435663832
Rt26437 T5371 T5994 2110694.0441020071
Rt26438 T5371 T6040 2155411.072008098
Rt26439 T5372 T5950 2690772.0286170011
Rt26440 T5372 T5980 2864460.0129242898
Gcorr8109 T5372 T6042 T5372 T6042 -2.5986811245361072e-08
Rt26441 T5372 T6080 2704566.7369161155
Rt26442 T5373 T5665 3749081.5743643809
Rt26443 T5373 T5752 6943515.9828559104
Rt26444 T5374 T5433 5265837.8412871147
Rt26445 T5374 T5725 4159874.1440957058
Rt26446 T5375 T5599 6908106.8208302865
Rt26447 T5375 T6054 2321376.7705026669
Rt26448 T5376 T5782 3375404.1725426428
Rt26449 T5376 T6013 1972885.9489394038
Rt26450 T5377 T5753 8220104.6131361611
Rt26451 T5377 T5868 5281209.2780323559
Rt26452 T5378 T5379 4629562.6208619978
Rt26453 T5378 T5696 14232379.534550041
Gcorr8110 T5378 T5941 T5378 T5941 -4.9567787910390501e-08
Rt26454 T5379 T5696 3624688.416336949
Rt26455 T5379 T5720 1850203.162550055
Rt26456 T5379 T5990 2401585.4164404599
Rt26457 T5380 T5436 4155994.5207533627
Gcorr8111 T5380 T5718 T5380 T5718 -1.3738217406983431e-08
Rt26458 T5380 T5743 9403249.9901536498
Rt26459 T5380 T5767 2178535.3670161194
Gcorr8112 T5381 T5818 T5381 T5818 -1.2295024382304277e-08
Rt26460 T5381 T5819 4589748.422642841
Rt26461 T5381 T5960 2787905.1175396307
Rt26462 T5381 T6059 5476667.6125383442
Rt26463 T5382 T5422 4338397.9147355286
Rt26464 T5382 T5601 5947614.5478060488
Rt26465 T5382 T5628 4799589.8172006812
Rt26466 T5383 T5819 2924738.1798627288
Rt26467 T5383 T5857 4546221.9483599737
Rt26468 T5383 T5861 3173645.6233103028
Rt26469 T5384 T5385 9790605.1776652448
Rt26470 T5384 T5565 4134425.4874852938
Rt26471 T5385 T5545 10627888.776891969
Rt26472 T5385 T5565 5108926.3702275455
Rt26473 T5385 T5569 4002999.9641793184
Rt26474 T5386 T5751 11727091.802857041
Gcorr8113 T5386 T5893 T5386 T5893 -5.6106498919685497e-08
Rt26475 T5387 T5700 4228139.9072407112
Gcorr8114 T5387 T5727 T5387 T5727 -2.6492095567675033e-08
Rt26476 T5387 T5849 2379707.1212296612
Gcorr8115 T5388 T5723 T5388 T5723 -5.7828141884397889e-08
Rt26477 T5388 T5838 11817479.544244437
Rt26478 T5388 T6022 60430130.406907424
Rt26479 T5389 T5390 3958780.54746453
Rt26480 T5389 T6078 4044485.5102015156
Rt26481 T5390 T5587 3911302.483207522
Rt26482 T5390 T5779 4169343.8675578227
Rt26483 T5390 T5933 6774207.8938429626
Rt26484 T5391 T5546 21976900.842449144
Rt26485 T5391 T5663 7591501.4559782883
Rt26486 T5392 T5466 4675443.6216899129
Rt26487 T5392 T6054 4494554.9072662974
Rt26488 T5392 T6071 234634.71051204027
Rt26489 T5393 T5717 6946590.5021380847
Rt26490 T5394 T5542 4194508.6994500831
Rt26491 T5394 T5560 9515709.0802844707
Rt26492 T5395 T5396 21840435.729985803
Rt26493 T5395 T6062 2492942.2594897179
Rt26494 T5396 T5466 6795912.548670684
Rt26495 T5396 T5889 1826653.933157681
Rt26496 T5396 T6062 2839687.9768751087
Rt26497 T5397 T5449 3906602.4561267691
Rt26498 T5397 T5573 4078710.2289730613
Rt26499 T5397 T5592 4223211.9353646832
Rt26500 T5398 T5453 8969092.2782940865
Rt26501 T5398 T5541 4448964.9457620205
Rt26502 T5399 T5650 4380801.9554449292
Rt26503 T5400 T5401 5122973.383138706
Rt26504 T5400 T5783 7818171.2337259119
Rt26505 T5400 T5809 6473842.436426132
Gcorr8116 T5400 T6010 T5400 T6010 -8.0335925782124103e-08
Rt26506 T5401 T5758 92419126.574633449
Rt26507 T5401 T5953 3507674.3326033251
Rt26508 T5401 T6010 3001087.3849477349
Gcorr8117 T5402 T5739 T5402 T5739 -1.2718445522564931e-08
Rt26509 T5402 T5740 3379109.2842362355
Rt26510 T5402 T5754 4603872.8220868781
Rt26511 T5402 T6079 5047460.0460107625
Rt26512 T5403 T5404 1863422.067463957
Rt26513 T5403 T5435 1625434.3972094331
Rt26514 T5403 T5965 2161671.440375091
Gcorr8118 T5404 T5410 T5404 T5410 -1.2429070221209217e-07
Rt26515 T5404 T5411 627910376.89182436
Rt26516 T5404 T5435 1033502.6804622223
Rt26517 T5404 T5891 3911461.7856025184
Rt26518 T5405 T5859 1186901.4807795193
Rt26519 T5405 T6013 848807.65886361257
Rt26520 T5406 T5407 4774130.2306386326
Rt26521 T5406 T5408 9271192.2492892593
Gcorr8119 T5406 T5613 T5406 T5613 -1.5477049617576605e-08
Rt26522 T5406 T5992 2120403.4906249074
Rt26523 T5407 T5408 4840756.2444481673
Rt26524 T5407 T5409 5420517.6638309639
Rt26525 T5407 T5854 3847621.5041282652
Rt26526 T5407 T5869 4921029.704447465
Gcorr8120 T5408 T5538 T5408 T5538 -1.2339502716407381e-08
Rt26527 T5408 T5869 979751.49731106812
Rt26528 T5408 T5992 1411562.8258585925
Rt26529 T5408 T6057 1073020.1795951573
Rt26530 T5409 T5410 5780167.992750599
Gcorr8121 T5409 T5816 T5409 T5816 -1.3164979089711626e-07
Rt26531 T5409 T5854 11864782.612741437
Rt26532 T5410 T5816 2050859.0405617533
Rt26533 T5410 T5891 2738296.5974080302
Rt26534 T5411 T5435 10906732.724039199
Rt26535 T5412 T5555 10180247.484926702
Rt26536 T5412 T5609 4335698.4576697443
Rt26537 T5413 T5414 5638060.8512273347
Rt26538 T5413 T5920 1979381.8477425682
Rt26539 T5414 T5415 1668296.9020458548
Rt26540 T5414 T5416 16571283.016766584
Rt26541 T5414 T5920 6444866.0165606365
Rt26542 T5414 T5948 3375930.4557491983
Rt26543 T5415 T5416 4734644.7353810929
Rt26544 T5415 T5591 2555535.4072092022
Rt26545 T5415 T5702 2106512.1366347829
Rt26546 T5415 T5788 6942558.4096252397
Rt26547 T5416 T5551 13017082.68554466
Rt26548 T5416 T5600 1816961.8073268756
Rt26549 T5416 T5702 9017446.0980702098
Rt26550 T5416 T5948 3195141.0492235338
Rt26551 T5417 T5543 2814759.9667541329
Rt26552 T5418 T5707 1605143.3303334825
Rt26553 T5418 T5791 7925699.7991603548
Rt26554 T5419 T5578 5556369.8708368381
Rt26555 T5419 T6018 2432977.7932641241
Rt26556 T5419 T6049 4110570.021249772
Rt26557 T5420 T5421 16979483.314592462
Rt26558 T5420 T5461 72787075.688677713
Rt26559 T5420 T5694 1645191.6121896557
Rt26560 T5420 T6023 3520627.1938149957
Gcorr8122 T5421 T5470 T5421 T5470 -4.2965591401911424e-08
Rt26561 T5421 T5694 860288.31031496637
Rt26562 T5421 T5740 4259996.5519295447
Rt26563 T5422 T5514 4233026.8778947303
Rt26564 T5422 T5601 4497206.2853445373
Rt26565 T5423 T5766 3821661.1386770923
Rt26566 T5424 T5633 13802923.114816321
Gcorr8123 T5424 T5697 T5424 T5697 -3.4128564940927219e-08
Rt26567 T5424 T5736 4534812.1312916549
Rt26568 T5424 T5824 1155414.4352199407
Rt26569 T5425 T5597 6211871.9553019553
Rt26570 T5425 T5705 2237733.8987292279
Rt26571 T5425 T5724 2572070.3645541938
Gcorr8124 T5426 T5852 T5426 T5852 -1.3902326683216675e-07
Rt26572 T5426 T5967 1246735.6579102578
Rt26573 T5427 T5446 2872061.0996611002
Rt26574 T5427 T5865 2621266.0991448225
Gcorr8125 T5427 T5979 T5427 T5979 -1.0725236232379658e-07
Gcorr8126 T5428 T5732 T5428 T5732 -5.9320080817421671e-08
Rt26575 T5428 T5775 1307028.5551627362
Gcorr8127 T5428 T5776 T5428 T5776 -5.0869300119914957e-08
Rt26576 T5428 T5976 2296780.1311742603
Rt26577 T5429 T5977 1932093.4841104539
Rt26578 T5429 T6052 2120994.4020880288
Rt26579 T5430 T5431 4429325.7704109112
Rt26580 T5430 T5783 5172016.7795951767
Rt26581 T5430 T5808 2642289.2908867439
Rt26582 T5431 T5432 1271423.795750194
Rt26583 T5431 T5862 340076557.46774781
Rt26584 T5432 T5862 3293662.027723304
Rt26585 T5433 T5434 4942566.8025756758
Rt26586 T5433 T5725 4228201.3460389655
Rt26587 T5434 T5725 11089942.420944467
Rt26588 T5434 T5797 3645361.3266977137
Rt26589 T5434 T5901 3205863.9073568792
Gcorr8128 T5435 T5965 T5435 T5965 -3.7523871654154826e-07
Rt26590 T5435 T6074 6621291.1002644012
Gcorr8129 T5436 T5537 T5436 T5537 -4.1587444239071598e-09
Rt26591 T5436 T5718 2198343.79812897
Rt26592 T5436 T6020 2289432.2229381423
Rt26593 T5438 T5448 9773095.905949207
Rt26594 T5439 T6045 2787738.1913404199
Rt26595 T5439 T6078 4886048.5386850117
Rt26596 T5440 T5441 1666544.8458276957
Rt26597 T5440 T5443 9216006.2439231947
Rt26598 T5441 T5443 3876813.8500046856
Rt26599 T5441 T5901 3455856.5197123559
Rt26600 T5441 T6003 665693.34870802972
Rt26601 T5442 T5963 2808066.8606059798
Rt26602 T5442 T6042 2467755.9725166862
Rt26603 T5443 T5522 4730791.9786536768
Rt26604 T5443 T5523 1248736.9404851261
Gcorr8130 T5443 T6003 T5443 T6003 -2.3033601982924013e-09
Rt26605 T5444 T5450 5494302.9816973973
Rt26606 T5444 T5601 9871708.4992274661
Rt26607 T5444 T5628 1202384.0325324594
Rt26608 T5445 T5863 72369254.39387922
Rt26609 T5446 T5549 9883442.4709612299
Gcorr8131 T5446 T5865 T5446 T5865 -1.6172265829221462e-07
Rt26610 T5447 T5627 5507822.2317063054
Gcorr8132 T5447 T5800 T5447 T5800 -2.4091589045753368e-08
Rt26611 T5447 T5844 2910910.3806397943
Rt26612 T5447 T6076 1819520.045277688
Rt26613 T5448 T5577 9701380.8029223755
Rt26614 T5449 T5592 4032873.4114953084
Rt26615 T5451 T5518 2967611.2806613678
Rt26616 T5451 T5546 4531625.2430495443
Rt26617 T5452 T5764 2878123.5296973614
Rt26618 T5452 T5765 1725042.1955757476
Gcorr8133 T5452 T5875 T5452 T5875 -3.5545653078388483e-07
Rt26619 T5453 T5513 4414588.4757837234
Rt26620 T5453 T5541 2982457.1242811861
Rt26621 T5454 T5455 11179447.573844872
Rt26622 T5454 T5702 11136245.543159675
Rt26623 T5454 T5788 3810263.2989430442
Rt26624 T5455 T5456 4795489.6071006572
Rt26625 T5455 T5457 10740910.502639014
Rt26626 T5455 T5788 4729101.9504455468
Rt26627 T5455 T5916 3398337.2492388948
Rt26628 T5456 T5457 2689925.2502692076
Rt26629 T5456 T5715 3735028.4208153095
Rt26630 T5456 T5723 12071152.509130647
Rt26631 T5456 T6022 7378906.2077966882
Rt26632 T5457 T5723 1578187.0303373728
Rt26633 T5457 T5916 2918748.0709849996
Rt26634 T5457 T6008 1547710.6070546724
Rt26635 T5458 T5737 3696888.9684920195
Rt26636 T5459 T5479 4767975.3235241817
Rt26637 T5459 T5684 9610494.9072038084
Rt26638 T5459 T5802 3675710.2610607287
Rt26639 T5460 T5558 1324558.9748690031
Rt26640 T5460 T5755 1369583.8839906754
Rt26641 T5460 T5928 1774398.7164431296
Rt26642 T5461 T5694 3454729.2147616469
Rt26643 T5462 T5527 3979894.9488125131
Rt26644 T5462 T5717 13157979.767348547
Rt26645 T5463 T5846 3812896.3707499388
Rt26646 T5463 T5908 6964089.7313885102
Rt26647 T5464 T5473 10696854.856798565
Rt26648 T5464 T5474 4572616.5318597388
Rt26649 T5465 T5473 10590893.09394867
Rt26650 T5466 T6071 18094095.746093404
Rt26651 T5467 T5468 8062788.0490650078
Rt26652 T5467 T5743 8218467.0083415927
Rt26653 T5468 T5743 3263258.9992651432
Rt26654 T5468 T5931 1048816.4764439743
Rt26655 T5468 T5932 2946145.215621206
Rt26656 T5468 T6025 10502218.680945013
Rt26657 T5469 T5470 5086283.4309345242
Rt26658 T5469 T5739 3494695.2278916757
Rt26659 T5470 T5694 2357001.3897003038
Rt26660 T5470 T5739 6650047.3025315497
Rt26661 T5470 T5740 4261790.1540612504
Rt26662 T5471 T5475 4199565.220565646
Rt26663 T5472 T5742 2958191.1462180382
Rt26664 T5472 T5951 6794418.8446750036
Rt26665 T5473 T5474 4680798.9772989219
Rt26666 T5473 T5606 9275752.5830846038
Rt26667 T5474 T5606 3253183.6630950151
Rt26668 T5475 T5592 3966826.6164374282
Rt26669 T5476 T5555 10472407.05253513
Rt26670 T5476 T5609 1633707.276254107
Rt26671 T5477 T5478 4388298.4207265312
Rt26672 T5477 T5485 4281027.5384138152
Rt26673 T5477 T5858 7197722.832541395
Rt26674 T5478 T5858 4776719.3989956453
Rt26675 T5478 T5968 2785390.01838317
Rt26676 T5479 T5486 4896160.3632444013
Rt26677 T5479 T5684 1445331.4096519856
Rt26678 T5480 T6018 3180188.4755564081
Rt26679 T5481 T5603 4714642.1772562563
Rt26680 T5482 T5484 3633829.105056406
Rt26681 T5483 T5493 9842589.3025089428
Rt26682 T5483 T5517 4692807.9964506049
Rt26683 T5483 T5569 4621342.5712752538
Rt26684 T5484 T5950 2980662.1953449189
Rt26685 T5485 T5784 8439654.7375710234
Rt26686 T5485 T5858 3630014.3576885848
Rt26687 T5486 T5684 3894171.8039706694
Rt26688 T5486 T5704 13044904.563753158
Rt26689 T5487 T5665 2667482.8565594377
Rt26690 T5487 T5752 7274023.8709273199
Rt26691 T5488 T6046 1180743.3325194994
Rt26692 T5488 T6049 2725382.1739242137
Rt26693 T5489 T5490 10061891.625956876
Rt26694 T5489 T5661 4295132.7363264337
Rt26695 T5490 T5656 9093745.1459728982
Rt26696 T5490 T5657 3373587.7469721641
Rt26697 T5490 T5661 3199621.9881968289
Rt26698 T5491 T5884 2742986.2981556617
Gcorr8134 T5491 T6073 T5491 T6073 -2.8661987876948227e-08
Rt26699 T5492 T5512 4097786.8926416561
Rt26700 T5493 T5517 4284545.9309665896
Rt26701 T5494 T5495 2971914.2789483578
Rt26702 T5494 T6073 35200461.508217573
Rt26703 T5496 T5521 3962939.4965214529
Rt26704 T5497 T5528 4774751.1204901496
Rt26705 T5497 T5584 4781489.1658614473
Rt26706 T5498 T5604 4844002.3152091317
Rt26707 T5498 T5626 3480819.7575481362
Rt26708 T5499 T5736 8207450.8734628679
Rt26709 T5500 T5526 1731321.7823989403
Rt26710 T5500 T5535 3965108.7059836071
Rt26711 T5500 T5538 10207550.78432616
Rt26712 T5501 T5614 18334323.289446462
Rt26713 T5501 T5689 4257756.8193523334
Rt26714 T5501 T5998 3256740.1809116257
Rt26715 T5502 T5611 10797096.823449114
Rt26716 T5502 T5639 4246155.3967595613
Rt26717 T5503 T6089 2342417.6718067238
Rt26718 T5504 T5895 10066278.71291665
Rt26719 T5505 T5535 4977713.4476617994
Rt26720 T5505 T5538 5322169.0656520966
Rt26721 T5505 T6057 3025326.1639172784
Rt26722 T5506 T5550 10039702.69633216
Rt26723 T5506 T5600 2145919.2317194431
Rt26724 T5507 T5553 2987734.7495667208
Rt26725 T5507 T5562 4979524.0630759187
Rt26726 T5508 T5544 11257209.330119358
Rt26727 T5508 T5791 3766260.2933516488
Rt26728 T5508 T5853 2711690.0976054864
Rt26729 T5509 T5510 4418024.026747752
Rt26730 T5509 T5511 4474188.3237978686
Rt26731 T5510 T5511 11207831.782886712
Rt26732 T5510 T5785 2281316.0239632446
Rt26733 T5510 T6060 7842611.62267364
Rt26734 T5510 T6068 3559849.8623528979
Rt26735 T5511 T5785 2780569.7816727138
Rt26736 T5512 T5519 4130182.734147822
Rt26737 T5513 T5541 10584079.336961862
Rt26738 T5514 T5601 10681756.717499549
Rt26739 T5515 T5566 11736867.934103226
Rt26740 T5515 T5942 3899760.4120556484
Rt26741 T5515 T6045 1080992.0796611186
Rt26742 T5516 T5630 23981136.40864294
Rt26743 T5516 T6008 1205284.7275988651
Rt26744 T5517 T5569 4568652.3608181132
Rt26745 T5518 T5546 10136619.865901703
Rt26746 T5519 T5520 3521186.8811835577
Rt26747 T5519 T5620 3543689.5336989732
Rt26748 T5519 T5682 26466474.585243177
Rt26749 T5520 T5563 4729725.6395232165
Rt26750 T5520 T5682 3229372.5596460071
Rt26751 T5520 T5970 2880131.2109552221
Rt26752 T5521 T5701 4388870.7928790525
Rt26753 T5522 T5523 10735297.141397411
Rt26754 T5522 T5558 3733685.3024693825
Rt26755 T5523 T5530 2458613.5405212273
Rt26756 T5523 T5558 4218961.3709971365
Rt26757 T5524 T5615 1375840.0512801437
Rt26758 T5525 T5737 5141174.6795810228
Rt26759 T5525 T6014 3036470.7854296528
Rt26760 T5526 T5538 1818751.2027066697
Rt26761 T5526 T5869 2075539.8707601144
Rt26762 T5527 T5717 22580562.709274869
Rt26763 T5527 T5781 2889395.3585896716
Rt26764 T5527 T5846 1639616.9788247172
Rt26765 T5528 T5584 5032949.6745611243
Rt26766 T5528 T5649 1784639.0703484039
Rt26767 T5529 T5572 4472814.1286374833
Rt26768 T5529 T5818 3482395.2491017752
Rt26769 T5531 T5532 9675176.6430739183
Rt26770 T5531 T5664 4603635.1597656766
Rt26771 T5532 T5533 3886856.4835202983
Rt26772 T5532 T5534 14003838.099919604
Rt26773 T5532 T5664 3178820.1776328846
Rt26774 T5532 T6021 3276664.0728141335
Rt26775 T5533 T5534 4703492.9516852237
Rt26776 T5533 T5574 3780439.7829829119
Rt26777 T5533 T5937 4054909.4258203777
Rt26778 T5533 T6005 8161577.8032331448
Rt26779 T5534 T5640 15460101.992672665
Rt26780 T5534 T5882 3365678.8941997834
Rt26781 T5534 T6005 2582729.1301376293
Rt26782 T5534 T6021 3318020.2691173991
Rt26783 T5535 T5538 5032801.2658444652
Rt26784 T5536 T5577 11216808.743226103
Rt26785 T5537 T6002 5925491.7475424539
Rt26786 T5537 T6020 2310314.7432727185
Rt26787 T5538 T5869 5798994.7213189667
Rt26788 T5538 T6057 3195048.7015310195
Rt26789 T5539 T5554 10412452.53714874
Rt26790 T5539 T5570 4684429.3813351225
Rt26791 T5540 T5768 3952909.9289934631
Rt26792 T5540 T5866 3219218.4157827194
Rt26793 T5541 T5584 5041392.8800071618
Rt26794 T5542 T5560 3931178.7099050679
Rt26795 T5543 T5568 1866932.6255244717
Rt26796 T5544 T5853 2069264.9765003999
Rt26797 T5544 T5942 1512508.8420667259
Rt26798 T5547 T5993 3339237.4936848637
Rt26799 T5548 T5610 3509772.8894969211
Rt26800 T5548 T5769 4605248.4377649799
Rt26801 T5548 T6087 5871131.5590592055
Gcorr8135 T5549 T5660 T5549 T5660 -1.1306321564756717e-07
Rt26802 T5549 T5803 7916058.6279029381
Rt26803 T5549 T6007 10264108.710214213
Rt26804 T5550 T5551 5144955.4892795831
Rt26805 T5550 T5600 2793260.8734459635
Rt26806 T5551 T5600 3585145.0276507195
Rt26807 T5551 T5948 5106028.4377265815
Rt26808 T5551 T5982 2297368.8841044274
Rt26809 T5552 T5808 5237384.5867935438
Rt26810 T5553 T5562 17636686.072137918
Rt26811 T5554 T5570 4648436.3240013747
Rt26812 T5555 T5609 4731727.1123048533
Rt26813 T5556 T5557 4575005.2164218798
Rt26814 T5556 T5839 10568514.759108674
Rt26815 T5557 T5839 1891160.1659859195
Rt26816 T5557 T5840 3366969.3196435086
Rt26817 T5557 T6044 6400971.7174806958
Rt26818 T5558 T5755 10525380.547404306
Rt26819 T5559 T5756 3766495.0563655924
Rt26820 T5560 T5629 4579514.0927438494
Rt26821 T5561 T5568 7752536.7787713725
Rt26822 T5562 T5697 3080729.7113582939
Rt26823 T5563 T5970 3188173.2030388131
Rt26824 T5564 T5959 3185905.4075981798
Rt26825 T5564 T6024 2549772.9634034112
Rt26826 T5564 T6044 1059637.5133088771
Rt26827 T5565 T5569 28743080.245432787
Rt26828 T5565 T5747 6791435.0606855648
Rt26829 T5566 T5853 16987882.598539107
Rt26830 T5566 T5942 3177526.5329973958
Rt26831 T5567 T6009 2581149.5323423091
Rt26832 T5570 T5766 3192525.905516474
Rt26833 T5571 T5579 4012383.3021579129
Gcorr8136 T5571 T5618 T5571 T5618 -6.0845078100602982e-08
Rt26834 T5571 T5753 3125286.0118718925
Rt26835 T5572 T5818 9784213.0658586696
Rt26836 T5572 T6059 3371488.0882486366
Rt26837 T5573 T5592 5400034.0518558314
Rt26838 T5573 T5674 855356.69465342758
Rt26839 T5574 T5937 21677433.841580253
Rt26840 T5575 T5685 2650696.4527389263
Rt26841 T5576 T5892 2492765.4012498097
Rt26842 T5576 T5973 13424345.755723065
Rt26843 T5577 T5650 12591531.535595393
Rt26844 T5578 T6018 67409807.818681538
Rt26845 T5578 T6048 3074232.5814318806
Rt26846 T5579 T5586 8909927.9008455239
Rt26847 T5579 T5618 3071631.2855896908
Rt26848 T5579 T5867 2143008.7332541551
Rt26849 T5580 T5698 27701425.733251441
Rt26850 T5580 T5699 5776671.6413932042
Rt26851 T5580 T5979 2883470.3971200287
Rt26852 T5580 T6055 3385086.5998210441
Rt26853 T5581 T5906 2991661.1940754019
Rt26854 T5581 T6031 5406427.8843081044
Rt26855 T5582 T5805 622722.66455108323
Rt26856 T5583 T6025 3174085.8533380786
Rt26857 T5584 T5649 11228148.040218437
Rt26858 T5585 T5586 4336721.2035295498
Rt26859 T5585 T5713 12705590.685748775
Rt26860 T5585 T5795 3841173.091498123
Rt26861 T5586 T5713 3498843.6476755464
Rt26862 T5587 T5779 13623593.815327322
Rt26863 T5588 T5589 3901793.6168790748
Rt26864 T5588 T5677 1137313.4629363262
Rt26865 T5589 T5618 3146315.3317325716
Rt26866 T5589 T5677 7594865.3542838497
Rt26867 T5589 T5988 2355833.5703328913
Rt26868 T5590 T5662 5115389.0792629747
Rt26869 T5591 T5788 1602876.766325502
Rt26870 T5591 T5916 6264190.7538787285
Rt26871 T5593 T5985 3069666.9620486954
Rt26872 T5593 T6085 2277018.2932300167
Rt26873 T5594 T5878 3706009.4361129305
Rt26874 T5594 T5962 2941739.6751901745
Rt26875 T5595 T5967 3296622.0744560487
Rt26876 T5596 T6079 3726431.0161168887
Rt26877 T5597 T5919 2657007.4994056965
Rt26878 T5598 T6064 4532709.4089399427
Rt26879 T5599 T5855 404722.20851315279
Rt26880 T5600 T5702 3826216.5701883454
Rt26881 T5601 T5628 5704191.970322296
Rt26882 T5602 T5907 2231790.8269016622
Rt26883 T5602 T6027 2015758.2797715056
Rt26884 T5603 T5677 3431639.893655017
Rt26885 T5604 T5626 12179491.073462242
Rt26886 T5605 T5859 1768937.9973383106
Rt26887 T5605 T5927 44748110.46391923
Rt26888 T5605 T5938 2061459.2771884017
Rt26889 T5605 T5961 9040913.7818595003
Rt26890 T5606 T5637 4867103.0426500877
Rt26891 T5606 T5712 4101697.9588552737
Rt26892 T5607 T5841 2587813.4811656834
Rt26893 T5607 T5939 1284002.9198883229
Rt26894 T5608 T5843 4161648.4088671482
Rt26895 T5608 T6015 2714314.8819066361
Rt26896 T5609 T5855 6670185.4341769414
Rt26897 T5610 T5769 11780740.922422718
Rt26898 T5610 T5911 3203939.5635067606
Rt26899 T5611 T5612 11180546.289698817
Rt26900 T5611 T5639 4092739.5677388702
Rt26901 T5612 T5639 3269951.8691327488
Rt26902 T5612 T5842 2666165.2605986223
Rt26903 T5613 T5992 2926184.4154686583
Rt26904 T5614 T5998 3302723.3185118814
Gcorr8137 T5615 T5622 T5615 T5622 -7.902356967851402e-09
Rt26905 T5617 T5663 9566854.7396598812
Rt26906 T5617 T5747 31090787.314611323
Rt26907 T5618 T5867 1811438.1984707287
Gcorr8138 T5618 T5988 T5618 T5988 -2.6362782410570931e-08
Rt26908 T5619 T5817 3343115.8602392352
Rt26909 T5619 T5922 1083250.2852136199
Rt26910 T5620 T5682 12673005.444755554
Rt26911 T5620 T5921 2796638.7026260733
Rt26912 T5621 T5651 16312245.902818881
Rt26913 T5621 T5695 10877170.612734908
Rt26914 T5621 T5970 2861232.1389487912
Rt26915 T5623 T5695 1302538.1841815249
Rt26916 T5623 T5833 2369818.1792417243
Rt26917 T5623 T6029 1470677.5316623182
Rt26918 T5624 T5671 2146849.9641759349
Rt26919 T5624 T5672 25180361.309824999
Rt26920 T5624 T5789 4757633.3665581625
Rt26921 T5625 T5711 95570001.468084157
Rt26922 T5625 T5786 2545394.9958310528
Gcorr8139 T5625 T6000 T5625 T6000 -7.9379472449695162e-09
Rt26923 T5626 T6085 2925497.9734067768
Gcorr8140 T5627 T5844 T5627 T5844 -4.2954762573414571e-08
Rt26924 T5627 T5845 3747184.0079615405
Rt26925 T5628 T5849 3733059.2817702964
Rt26926 T5629 T5686 10321116.355246615
Gcorr8141 T5630 T5723 T5630 T5723 -9.0363384294934003e-10
Rt26927 T5630 T6008 1521299.1807952079
Gcorr8142 T5631 T5861 T5631 T5861 -3.5055389309292201e-08
Rt26928 T5631 T5886 2653015.5543970708
Rt26929 T5632 T5633 11886107.384706466
Rt26930 T5632 T5999 1985876.436145812
Rt26931 T5633 T5736 3249904.9844293795
Rt26932 T5633 T5999 995291.78262121626
Rt26933 T5634 T5969 12222197.187271778
Gcorr8143 T5634 T6034 T5634 T6034 -6.8979480336527321e-08
Rt26934 T5635 T5984 10656374.217097307
Rt26935 T5635 T6002 4542611.9564440884
Rt26936 T5636 T5842 11097130.552813187
Rt26937 T5636 T5976 4018437.6388298217
Rt26938 T5637 T5712 9416160.2585540954
Rt26939 T5637 T6040 3266687.0450440291
Rt26940 T5638 T5670 8326592.8547262186
Rt26941 T5638 T5856 10737534.586457968
Rt26942 T5638 T5958 3626337.1738329465
Rt26943 T5639 T6070 6373288.7095070798
Rt26944 T5640 T5641 4209290.0217689853
Rt26945 T5640 T5882 5996389.5824708575
Gcorr8144 T5640 T6005 T5640 T6005 -6.5232861759775939e-08
Gcorr8145 T5641 T5642 T5641 T5642 -3.9284800584908172e-08
Rt26946 T5642 T5894 46493141.157162331
Rt26947 T5643 T5748 2942408.8920229725
Rt26948 T5643 T5848 3338909.46428977
Rt26949 T5643 T6033 5273334.0375621645
Rt26950 T5644 T5645 5926721.24200691
Rt26951 T5644 T5972 7988247.5782421585
Rt26952 T5645 T5646 3476747.7489353199
Rt26953 T5645 T5966 18427213.78077253
Rt26954 T5645 T5972 2373637.93962747
Rt26955 T5646 T5675 9273858.873695299
Rt26956 T5646 T5966 1181219.7178898519
Rt26957 T5647 T5648 3426333.887994701
Rt26958 T5647 T5825 8858620.4317164626
Rt26959 T5648 T5825 2710822.5653821602
Rt26960 T5648 T5886 3528359.3394172061
Rt26961 T5648 T6051 2731710.5616524215
Rt26962 T5649 T5750 3768588.1935087587
Rt26963 T5650 T5708 8712576.6146226879
Rt26964 T5651 T5695 3537453.1306295181
Rt26965 T5652 T5800 12590231.205909321
Rt26966 T5652 T6076 3438058.1384364404
Rt26967 T5653 T5850 3703636.1965066842
Rt26968 T5654 T6060 3058465.9693945362
Gcorr8146 T5655 T5681 T5655 T5681 -7.939641539280455e-09
Rt26969 T5655 T5847 2670835.0332724922
Rt26970 T5656 T5657 2769929.842630933
Rt26971 T5656 T5896 2380480.0891104806
Rt26972 T5657 T5658 3883317.7961801142
Rt26973 T5657 T5896 2804392.8268660456
Rt26974 T5658 T5659 20416304.575761918
Rt26975 T5658 T5864 1822203.8152908052
Rt26976 T5659 T5660 4906339.3005645135
Rt26977 T5659 T5883 13708331.51244648
Rt26978 T5660 T5915 115999462.788886
Rt26979 T5662 T6043 1801266.4764170295
Rt26980 T5664 T6021 6243162.0038349954
Rt26981 T5665 T5752 5165366.6428857129
Rt26982 T5666 T5734 60373615.241883554
Rt26983 T5667 T5686 4194040.1759927412
Rt26984 T5667 T5725 4371940.0016343873
Rt26985 T5668 T5669 6067090.0907875197
Rt26986 T5668 T5999 2682721.3526440505
Rt26987 T5669 T6001 3240337.3170449804
Rt26988 T5669 T6072 1384769.8091265424
Rt26989 T5670 T5671 10276722.174246034
Rt26990 T5670 T5958 5770313.4400366899
Rt26991 T5671 T5672 1654199.8737273633
Rt26992 T5671 T5958 1242015.8146918623
Rt26993 T5672 T5789 18097288.80704008
Rt26994 T5672 T5792 23403139.920664109
Rt26995 T5672 T5874 813618.47257178614
Rt26996 T5673 T5724 1521441.5047534015
Rt26997 T5673 T5875 4889038.7162124077
Rt26998 T5673 T6069 2775924.4425201705
Rt26999 T5674 T5683 1725583.3345477181
Rt27000 T5675 T5826 4070073.1969944998
Rt27001 T5676 T5962 2248301.4981782259
Rt27002 T5676 T5974 3007900.4103794708
Gcorr8147 T5677 T5988 T5677 T5988 -2.6973422083706497e-08
Rt27003 T5678 T5679 4482543.4971459173
Rt27004 T5678 T5748 9326829.6660491917
Rt27005 T5678 T5993 23988488.571150634
Rt27006 T5679 T5748 1434814.5234845118
Rt27007 T5680 T5681 14562004.085587811
Rt27008 T5680 T5957 6521491.1908744555
Rt27009 T5681 T5957 3913861.784647549
Rt27010 T5683 T5733 9896679.3301364072
Rt27011 T5684 T5704 8348302.3204126991
Rt27012 T5684 T5802 4395600.4839741699
Rt27013 T5685 T5906 8866463.166916253
Rt27014 T5685 T5907 1921286.7279949458
Rt27015 T5687 T5793 4388367.2393456921
Rt27016 T5687 T5925 16009996.213065248
Rt27017 T5687 T5926 2485423.2283500833
Rt27018 T5687 T5989 27862784.463192429
Rt27019 T5688 T6014 2632133.4257131438
Rt27020 T5689 T5690 11616090.799406182
Rt27021 T5689 T5862 5763038.8699047985
Rt27022 T5689 T5998 5201631.9111993536
Rt27023 T5690 T5918 3196700.0838748412
Rt27024 T5690 T5998 1593164.5569486183
Rt27025 T5692 T5956 4665602.444888154
Gcorr8148 T5693 T5751 T5693 T5751 -3.8210922332888123e-08
Gcorr8149 T5695 T5833 T5695 T5833 -3.7351408348884492e-08
Rt27026 T5696 T5990 7027864.2885009693
Rt27027 T5697 T5824 6328585.8739315895
Rt27028 T5697 T6081 4665945.6368279988
Rt27029 T5698 T5699 3532059.851538307
Rt27030 T5698 T6026 5104385.6632293044
Rt27031 T5699 T6055 3424684.1433228063
Rt27032 T5700 T5888 2934572.6901430171
Rt27033 T5701 T6009 2336001.552510302
Rt27034 T5702 T5788 2794374.5659183497
Gcorr8150 T5703 T5899 T5703 T5899 -2.5712580984791933e-07
Rt27035 T5703 T5902 3165419.881152106
Rt27036 T5706 T6051 2260557.0987478388
Rt27037 T5707 T5708 7049122.7361462619
Rt27038 T5707 T5791 4023329.0529131726
Rt27039 T5709 T5768 9621219.017076835
Rt27040 T5709 T5784 20690163.82773779
Gcorr8151 T5710 T5807 T5710 T5807 -2.9683757547744088e-08
Rt27041 T5710 T5850 6576159.4953701906
Rt27042 T5710 T6028 3092323.9640849973
Rt27043 T5711 T5786 199497467.9590281
Gcorr8152 T5711 T5913 T5711 T5913 -7.1769408588037387e-08
Rt27044 T5712 T5780 3297463.6217677277
Rt27045 T5712 T6040 3419247.1318774787
Rt27046 T5713 T5795 1841238.3816177486
Rt27047 T5713 T5952 3659469.7437124839
Rt27048 T5714 T5910 5655941.3776985044
Rt27049 T5715 T6022 3183816.8844316346
Rt27050 T5716 T5796 5522628.6125318762
Rt27051 T5716 T5837 3047016.047041106
Rt27052 T5718 T5767 2139066.0390878352
Rt27053 T5719 T5795 1522296.8069289392
Rt27054 T5721 T5741 4269326.5426398646
Rt27055 T5721 T6067 5389653.9265951747
Rt27056 T5722 T5995 13126906.265194302
Rt27057 T5722 T6070 12045094.638809489
Gcorr8153 T5723 T6008 T5723 T6008 -1.0970154626706656e-08
Rt27058 T5723 T6022 2606048.7826921879
Rt27059 T5724 T6069 18819971.730530117
Rt27060 T5726 T5904 2948156.4012380769
Rt27061 T5726 T6075 2716819.0164168435
Rt27062 T5727 T5849 5915619.9422134571
Gcorr8154 T5727 T5871 T5727 T5871 -4.5545528644752782e-08
Rt27063 T5728 T5749 12541403.82335221
Rt27064 T5728 T5934 2825324.6761029046
Gcorr8155 T5729 T5882 T5729 T5882 -8.6370932575125906e-09
Rt27065 T5729 T6086 2867471.5127515877
Rt27066 T5730 T5731 3104223.3165783868
Rt27067 T5730 T5811 1913163.9982696939
Rt27068 T5731 T5832 4595662.3183407653
Rt27069 T5731 T6035 5541149.3646841515
Rt27070 T5732 T5775 1098832.5688697065
Rt27071 T5732 T5851 2483350.4628659929
Rt27072 T5733 T5876 3453229.6445142818
Rt27073 T5734 T5814 1259480.62615588
Rt27074 T5737 T6014 27552638.59934596
Rt27075 T5738 T6067 4591370.1617051428
Rt27076 T5739 T5740 4791453.7753642956
Rt27077 T5739 T6079 1275063.413038149
Rt27078 T5742 T5908 153339021.87949046
Rt27079 T5742 T6050 2633571.5711540664
Rt27080 T5743 T5931 10347536.63544159
Rt27081 T5744 T5877 6618967.057314083
Rt27082 T5744 T5878 3409413.3338414878
Rt27083 T5745 T5790 3485657.2384925601
Rt27084 T5746 T6035 5390998.7977205794
Rt27085 T5748 T6033 2881836.8082501744
Rt27086 T5749 T5934 3913622.6963714878
Rt27087 T5749 T5987 9910158.2724784985
Rt27088 T5749 T6016 5351186.7832381194
Rt27089 T5750 T6028 3419954.5510403272
Rt27090 T5751 T5893 10337814.091579823
Rt27091 T5751 T6058 3632112.406597707
Rt27092 T5752 T5884 17441031.911093567
Rt27093 T5754 T5815 12526032.476161918
Rt27094 T5755 T5928 13617901.801805075
Rt27095 T5756 T6066 2921439.1463060309
Rt27096 T5757 T5890 3288598.949043368
Rt27097 T5758 T5953 31561527.637412343
Rt27098 T5758 T5955 13778292.955529531
Rt27099 T5759 T5777 6374618.2646979606
Rt27100 T5759 T5939 4046459.2854279494
Rt27101 T5760 T5920 2511746.4255329343
Rt27102 T5760 T6017 1489728.2544087537
Rt27103 T5762 T5763 3249684.7503446969
Rt27104 T5762 T6082 1083743.1727287106
Rt27105 T5763 T5945 2245111.8846291522
Gcorr8156 T5763 T6082 T5763 T6082 -4.8884332987475182e-08
Rt27106 T5763 T6084 1895329.04071831
Rt27107 T5764 T5875 2569094.337027492
Rt27108 T5764 T6052 640903.50092388911
Rt27109 T5765 T6019 1987775.9278244991
Rt27110 T5766 T5871 14585704.746202342
Rt27111 T5768 T5866 17079603.334465496
Rt27112 T5769 T5837 4766630.5507670753
Rt27113 T5769 T5911 2220668.069707728
Rt27114 T5769 T6087 4972303.8729385221
Rt27115 T5770 T5880 658963.65026970557
Gcorr8157 T5770 T6019 T5770 T6019 -3.5503889262214526e-07
Rt27116 T5770 T6034 2208310.4129093648
Rt27117 T5771 T5801 6651719.1664588433
Rt27118 T5771 T5996 3596294.8562606815
Gcorr8158 T5772 T5996 T5772 T5996 -3.5786408039206526e-08
Rt27119 T5773 T5774 104846671.25955133
Rt27120 T5773 T5836 3357629.2547475682
Rt27121 T5774 T5836 2205579.3535373746
Rt27122 T5775 T5776 1634132.7539336639
Rt27123 T5775 T5851 9487225.517626781
Gcorr8159 T5776 T5880 T5776 T5880 -1.5296543867138113e-07
Rt27124 T5777 T5971 1151992.2034795599
Gcorr8160 T5778 T5981 T5778 T5981 -2.8671469703850233e-08
Rt27125 T5778 T6026 3265142.1717947433
Rt27126 T5779 T5933 4463326.4261938222
Rt27127 T5780 T5994 3655619.3224841761
Rt27128 T5781 T5846 97986488.149696767
Rt27129 T5782 T5785 1545641.1376986599
Rt27130 T5782 T5877 32735976.690376692
Rt27131 T5782 T6068 3960054.0717437877
Rt27132 T5783 T5808 5922928.2719372688
Rt27133 T5783 T5809 2779862.4108644677
Rt27134 T5784 T5858 5417239.0931260101
Rt27135 T5785 T5877 1452582.4083727067
Rt27136 T5785 T6068 1419307.6984627056
Gcorr8161 T5787 T6064 T5787 T6064 -3.7903742122659943e-08
Rt27137 T5788 T5916 5114003.5571714742
Rt27138 T5791 T5853 11440064.903487323
Rt27139 T5793 T5924 2888085.2220960511
Rt27140 T5793 T5925 4062158.6736680111
Rt27141 T5796 T5935 3867172.1075199605
Rt27142 T5796 T6006 2876478.1044660825
Rt27143 T5797 T5901 16608348.350732941
Rt27144 T5798 T5828 2161978.8798656114
Rt27145 T5799 T5816 217024956.30286387
Gcorr8162 T5799 T5827 T5799 T5827 -2.3308383987531903e-07
Gcorr8163 T5799 T5891 T5799 T5891 -1.7282056797560797e-09
Rt27146 T5800 T6076 2279998.3851366281
Gcorr8164 T5801 T5996 T5801 T5996 -3.9210616689622518e-08
Rt27147 T5802 T5972 5424951.5433865776
Rt27148 T5803 T5804 7610192.1327059371
Rt27149 T5803 T6007 1882903.890938519
Rt27150 T5804 T6011 13023644.868099036
Rt27151 T5805 T5940 10505904.70247723
Rt27152 T5807 T6030 2077895.1923367728
Rt27153 T5810 T5975 2326564.4936284376
Gcorr8165 T5810 T6038 T5810 T6038 -1.0690626861642924e-07
Rt27154 T5812 T5914 2816521.6682819487
Gcorr8166 T5812 T6084 T5812 T6084 -6.8515820487471364e-08
Rt27155 T5813 T6081 2323314.9241570225
Rt27156 T5814 T5936 6609923.2537513366
Rt27157 T5815 T5900 3533454.8184216432
Gcorr8167 T5815 T5986 T5815 T5986 -3.8006605876125439e-08
Gcorr8168 T5816 T5891 T5816 T5891 -1.0104677110524458e-07
Rt27158 T5816 T6032 1000856.0259686521
Rt27159 T5817 T6061 1241063.3520927904
Rt27160 T5818 T5819 3943308.523396045
Rt27161 T5818 T6059 3140218.2564851884
Rt27162 T5819 T5857 3485681.0567059973
Rt27163 T5820 T5821 3129519.6864925148
Rt27164 T5821 T5822 4559461.9048088603
Rt27165 T5822 T5823 3174557.3824685533
Rt27166 T5822 T5949 4371726.782397557
Rt27167 T5823 T5922 3878317.196522071
Rt27168 T5823 T5947 2966520.9507841105
Rt27169 T5823 T6088 3181376.6499932758
Rt27170 T5826 T5827 660627.93143925699
Gcorr8169 T5828 T5829 T5828 T5829 -1.8259023999375117e-07
Rt27171 T5829 T5929 2832235.4466887689
Rt27172 T5829 T6001 3232425.0020674267
Rt27173 T5829 T6041 3071329.3321594223
Rt27174 T5830 T5831 4671543.927991922
Rt27175 T5830 T5874 45203730.852445506
Rt27176 T5831 T5874 2097132.478017739
Rt27177 T5832 T6035 8129031.5528308721
Rt27178 T5833 T5900 3211747.8804544923
Rt27179 T5834 T5835 2441472.4140117494
Gcorr8170 T5834 T5870 T5834 T5870 -9.7551510881538973e-08
Rt27180 T5835 T5870 5526015.3181642257
Rt27181 T5835 T5881 2714527.3775540553
Rt27182 T5835 T5912 4932694.4973899247
Rt27183 T5838 T5902 3048471.2132550036
Gcorr8171 T5840 T5912 T5840 T5912 -1.2571221111106132e-07
Rt27184 T5840 T6044 2293750.9234753791
Rt27185 T5842 T5976 6915500.4671108164
Gcorr8172 T5843 T5887 T5843 T5887 -1.7405425959830322e-07
Rt27186 T5844 T5845 3830165.4326427048
Rt27187 T5844 T6063 2066081.4726639092
Gcorr8173 T5844 T6076 T5844 T6076 -5.6808812933416096e-08
Rt27188 T5846 T5908 3225044.0307066273
Rt27189 T5848 T6056 2515203.0105911931
Rt27190 T5850 T6028 7650620.7051777644
Gcorr8174 T5852 T5860 T5852 T5860 -1.1264060430088144e-07
Rt27191 T5853 T5942 18918946.431986146
Rt27192 T5855 T5997 19752910.28442071
Rt27193 T5856 T5958 3037079.2090604273
Rt27194 T5856 T6037 8879513.1688744761
Gcorr8175 T5857 T5861 T5857 T5861 -3.5395193101970153e-08
Rt27195 T5858 T5968 31577322.884497073
Rt27196 T5859 T5927 18460989.414521165
Rt27197 T5860 T5975 2816865.5291786417
Rt27198 T5861 T5886 11188659.206748346
Rt27199 T5863 T5888 10871636.617927372
Gcorr8176 T5863 T6064 T5863 T6064 -6.6975396234930199e-09
Rt27200 T5866 T6087 11394023.18009684
Rt27201 T5868 T6047 1546414.5381592133
Rt27202 T5872 T5902 3227253.9621793437
Gcorr8177 T5873 T6016 T5873 T6016 -1.1577463514181727e-07
Rt27203 T5876 T6031 25544418.991826426
Rt27204 T5876 T6065 6923502.547638543
Rt27205 T5879 T5890 9077022.4058721364
Rt27206 T5880 T6019 1516553.9785835957
Rt27207 T5882 T6021 5753555.8035578243
Rt27208 T5886 T6051 10144477.469951849
Rt27209 T5889 T5981 2117138.3853789442
Gcorr8178 T5889 T6062 T5889 T6062 -1.5392671751055653e-08
Rt27210 T5892 T5974 3451583.7652465678
Rt27211 T5894 T5954 5639336.9424262801
Gcorr8179 T5897 T5964 T5897 T5964 -3.500348835768532e-08
Rt27212 T5897 T6023 3065586.4458588599
Rt27213 T5898 T5964 3223813.511999581
Rt27214 T5899 T6012 2841956.581642515
Gcorr8180 T5901 T6003 T5901 T6003 -1.5645266113429594e-08
Gcorr8181 T5903 T5935 T5903 T5935 -1.0862339970223643e-07
Rt27215 T5904 T5991 21844296.840015329
Rt27216 T5906 T5907 4310023.0251156762
Rt27217 T5907 T6027 6315984.0280848192
Gcorr8182 T5909 T5969 T5909 T5969 -6.5705880823941394e-08
Rt27218 T5910 T5953 6292498.987379577
Rt27219 T5913 T5971 1744239.6368413456
Rt27220 T5914 T6084 1186853.6856053392
Gcorr8183 T5916 T6008 T5916 T6008 -3.4854366261016134e-08
Rt27221 T5917 T6033 9983717.3351488151
Rt27222 T5918 T5983 3738308.3756185709
Gcorr8184 T5918 T5998 T5918 T5998 -3.4041941317766514e-08
Rt27223 T5920 T5948 3105793.0751885199
Gcorr8185 T5922 T5947 T5922 T5947 -9.8444567598255026e-08
Rt27224 T5923 T5945 1144845.1822671227
Rt27225 T5923 T6006 17601193.521512009
Rt27226 T5924 T5925 20573993.057427377
Rt27227 T5925 T5926 26689966.169362471
Rt27228 T5925 T5994 3425191.6647100979
Rt27229 T5927 T5938 2465727.9400561252
Rt27230 T5929 T6001 23203181.7886893
Gcorr8186 T5929 T6041 T5929 T6041 -7.669342782073191e-08
Rt27231 T5930 T6047 5020128.8530317498
Gcorr8187 T5931 T5932 T5931 T5932 -2.6722879252608801e-08
Rt27232 T5931 T5978 2888137.7712003104
Rt27233 T5932 T6025 2867408.8084026342
Rt27234 T5936 T6043 23583140.333269875
Rt27235 T5937 T6005 781570.90453222312
Rt27236 T5942 T6045 28973820.504541069
Rt27237 T5945 T6006 14570712.220921537
Rt27238 T5946 T6038 58081007.137434445
Rt27239 T5946 T6039 26952179.987693526
Rt27240 T5947 T6088 16306602.840866784
Rt27241 T5950 T6042 3438018.3672295157
Gcorr8188 T5953 T6010 T5953 T6010 -1.3800298606979914e-07
Rt27242 T5954 T6011 5151413.3142088195
Rt27243 T5956 T6040 7010330.1907168487
Rt27244 T5959 T6024 37769345.157315895
Rt27245 T5960 T5961 5190676.4266011175
Rt27246 T5960 T6059 819195.51870383124
Rt27247 T5963 T6042 65211732.728958361
Rt27248 T5965 T6074 1813483.2828745882
Rt27249 T5975 T6038 4042723.7166177747
Rt27250 T5977 T6030 3148315.035825368
Rt27251 T5978 T6058 2974975.4638372082
Rt27252 T5984 T6002 1602073.7760543989
Rt27253 T5986 T6029 3225796.200174904
Rt27254 T5987 T6016 911206.44028886931
Rt27255 T5992 T6057 13378032.419652477
Rt27256 T5995 T6070 2711302.5266300067
Rt27257 T6002 T6020 7213128.4145296318
Rt27258 T6004 T6077 3404903.3900535046
Rt27259 T6024 T6044 2833018.5266377595
Rt27260 T6038 T6039 6722666.8580627395
Rt27261 T6046 T6089 10546472.51287315
Rt27262 T6053 T6086 7275561.9213107834
Rt27263 T6060 T6068 3775575.8116067406
Rt27264 T6082 T6084 4488736.3831732357
Vfixed1 T1 0 DC 500
Vfixed2 T2 0 DC 500
Vfixed3 T3 0 DC 500
Vfixed4 T4 0 DC 500
Vfixed5 T5 0 DC 500
Vfixed6 T6 0 DC 500
Vfixed7 T7 0 DC 500
Vfixed8 T8 0 DC 500
Vfixed9 T9 0 DC 500
Vfixed10 T10 0 DC 500
Vfixed11 T11 0 DC 500
Vfixed12 T12 0 DC 500
Vfixed13 T13 0 DC 500
Vfixed14 T14 0 DC 500
Vfixed15 T15 0 DC 500
Vfixed16 T16 0 DC 500
Vfixed17 T17 0 DC 500
Vfixed18 T18 0 DC 500
Vfixed19 T19 0 DC 500
Vfixed20 T20 0 DC 500
Vfixed21 T21 0 DC 500
Vfixed22 T22 0 DC 500
Vfixed23 T23 0 DC 500
Vfixed24 T24 0 DC 500
Vfixed25 T25 0 DC 500
Vfixed26 T26 0 DC 500
Vfixed27 T27 0 DC 500
Vfixed28 T28 0 DC 500
Vfixed29 T29 0 DC 500
Vfixed30 T30 0 DC 500
Vfixed31 T31 0 DC 500
Vfixed32 T32 0 DC 500
Vfixed33 T33 0 DC 500
Vfixed34 T34 0 DC 500
Vfixed35 T35 0 DC 500
Vfixed36 T36 0 DC 500
Vfixed37 T37 0 DC 500
Vfixed38 T38 0 DC 500
Vfixed39 T39 0 DC 500
Vfixed40 T40 0 DC 500
Vfixed41 T41 0 DC 500
Vfixed42 T42 0 DC 500
Vfixed43 T43 0 DC 500
Vfixed44 T44 0 DC 500
Vfixed45 T45 0 DC 500
Vfixed46 T46 0 DC 500
Vfixed47 T47 0 DC 500
Vfixed48 T48 0 DC 500
Vfixed49 T49 0 DC 500
Vfixed50 T50 0 DC 500
Vfixed51 T51 0 DC 500
Vfixed52 T52 0 DC 500
Vfixed53 T53 0 DC 500
Vfixed54 T54 0 DC 500
Vfixed55 T55 0 DC 500
Vfixed56 T56 0 DC 500
Vfixed57 T57 0 DC 500
Vfixed58 T58 0 DC 500
Vfixed59 T59 0 DC 500
Vfixed60 T60 0 DC 500
Vfixed61 T61 0 DC 500
Vfixed62 T62 0 DC 500
Vfixed63 T63 0 DC 500
Vfixed64 T72 0 DC 293.14999999999998
Vfixed65 T73 0 DC 293.14999999999998
Vfixed66 T74 0 DC 293.14999999999998
Vfixed67 T75 0 DC 293.14999999999998
Vfixed68 T76 0 DC 500
Vfixed69 T77 0 DC 500
Vfixed70 T78 0 DC 500
Vfixed71 T79 0 DC 500
Vfixed72 T80 0 DC 500
Vfixed73 T81 0 DC 500
Vfixed74 T82 0 DC 500
Vfixed75 T83 0 DC 500
Vfixed76 T84 0 DC 500
Vfixed77 T85 0 DC 500
Vfixed78 T86 0 DC 500
Vfixed79 T87 0 DC 500
Vfixed80 T88 0 DC 500
Vfixed81 T89 0 DC 500
Vfixed82 T90 0 DC 500
Vfixed83 T91 0 DC 500
Vfixed84 T92 0 DC 500
Vfixed85 T93 0 DC 500
Vfixed86 T94 0 DC 500
Vfixed87 T95 0 DC 500
Vfixed88 T96 0 DC 500
Vfixed89 T97 0 DC 500
Vfixed90 T98 0 DC 500
Vfixed91 T99 0 DC 500
Vfixed92 T100 0 DC 500
Vfixed93 T101 0 DC 500
Vfixed94 T102 0 DC 500
Vfixed95 T103 0 DC 500
Vfixed96 T104 0 DC 500
Vfixed97 T105 0 DC 500
Vfixed98 T106 0 DC 500
Vfixed99 T107 0 DC 500
Vfixed100 T108 0 DC 500
Vfixed101 T109 0 DC 500
Vfixed102 T110 0 DC 500
Vfixed103 T111 0 DC 500
Vfixed104 T112 0 DC 500
Vfixed105 T113 0 DC 500
Vfixed106 T114 0 DC 500
Vfixed107 T115 0 DC 500
Vfixed108 T116 0 DC 500
Vfixed109 T117 0 DC 500
Vfixed110 T118 0 DC 500
Vfixed111 T119 0 DC 500
Vfixed112 T120 0 DC 500
Vfixed113 T121 0 DC 500
Vfixed114 T122 0 DC 500
Vfixed115 T123 0 DC 500
Vfixed116 T124 0 DC 500
Vfixed117 T125 0 DC 500
Vfixed118 T126 0 DC 500
Vfixed119 T127 0 DC 500
Vfixed120 T128 0 DC 500
Vfixed121 T129 0 DC 500
Vfixed122 T130 0 DC 500
Vfixed123 T131 0 DC 500
Vfixed124 T132 0 DC 500
Vfixed125 T133 0 DC 500
Vfixed126 T134 0 DC 500
Vfixed127 T135 0 DC 500
Vfixed128 T136 0 DC 500
Vfixed129 T137 0 DC 500
Vfixed130 T138 0 DC 500
Vfixed131 T139 0 DC 500
Vfixed132 T140 0 DC 500
Vfixed133 T141 0 DC 500
Vfixed134 T142 0 DC 500
Vfixed135 T143 0 DC 500
Vfixed136 T144 0 DC 500
Vfixed137 T145 0 DC 500
Vfixed138 T146 0 DC 500
Vfixed139 T147 0 DC 500
Vfixed140 T148 0 DC 500
Vfixed141 T149 0 DC 500
Vfixed142 T150 0 DC 500
Vfixed143 T151 0 DC 500
Vfixed144 T152 0 DC 500
Vfixed145 T153 0 DC 500
Vfixed146 T154 0 DC 500
Vfixed147 T155 0 DC 500
Vfixed148 T156 0 DC 500
Vfixed149 T157 0 DC 500
Vfixed150 T158 0 DC 500
Vfixed151 T159 0 DC 500
Vfixed152 T160 0 DC 500
Vfixed153 T161 0 DC 500
Vfixed154 T162 0 DC 500
Vfixed155 T163 0 DC 500
Vfixed156 T164 0 DC 500
Vfixed157 T165 0 DC 500
Vfixed158 T166 0 DC 500
Vfixed159 T167 0 DC 500
Vfixed160 T168 0 DC 500
Vfixed161 T169 0 DC 500
Vfixed162 T170 0 DC 500
Vfixed163 T171 0 DC 500
Vfixed164 T172 0 DC 500
Vfixed165 T173 0 DC 500
Vfixed166 T174 0 DC 500
Vfixed167 T175 0 DC 500
Vfixed168 T176 0 DC 500
Vfixed169 T177 0 DC 500
Vfixed170 T178 0 DC 500
Vfixed171 T179 0 DC 500
Vfixed172 T180 0 DC 500
Vfixed173 T181 0 DC 500
Vfixed174 T182 0 DC 500
Vfixed175 T183 0 DC 500
Vfixed176 T184 0 DC 500
Vfixed177 T185 0 DC 500
Vfixed178 T186 0 DC 500
Vfixed179 T187 0 DC 500
Vfixed180 T188 0 DC 500
Vfixed181 T189 0 DC 500
Vfixed182 T190 0 DC 500
Vfixed183 T191 0 DC 500
Vfixed184 T192 0 DC 500
Vfixed185 T193 0 DC 500
Vfixed186 T194 0 DC 500
Vfixed187 T195 0 DC 500
Vfixed188 T196 0 DC 500
Vfixed189 T197 0 DC 500
Vfixed190 T198 0 DC 500
Vfixed191 T199 0 DC 500
Vfixed192 T200 0 DC 500
Vfixed193 T201 0 DC 500
Vfixed194 T202 0 DC 500
Vfixed195 T203 0 DC 500
Vfixed196 T204 0 DC 500
Vfixed197 T205 0 DC 500
Vfixed198 T206 0 DC 500
Vfixed199 T207 0 DC 500
Vfixed200 T208 0 DC 500
Vfixed201 T209 0 DC 500
Vfixed202 T210 0 DC 500
Vfixed203 T211 0 DC 500
Vfixed204 T212 0 DC 500
Vfixed205 T213 0 DC 500
Vfixed206 T214 0 DC 500
Vfixed207 T215 0 DC 500
Vfixed208 T216 0 DC 500
Vfixed209 T217 0 DC 500
Vfixed210 T218 0 DC 500
Vfixed211 T219 0 DC 500
Vfixed212 T220 0 DC 500
Vfixed213 T221 0 DC 500
Vfixed214 T222 0 DC 500
Vfixed215 T223 0 DC 500
Vfixed216 T224 0 DC 500
Vfixed217 T225 0 DC 500
Vfixed218 T226 0 DC 500
Vfixed219 T227 0 DC 500
Vfixed220 T228 0 DC 500
Vfixed221 T229 0 DC 500
Vfixed222 T230 0 DC 500
Vfixed223 T231 0 DC 500
Vfixed224 T232 0 DC 500
Vfixed225 T233 0 DC 500
Vfixed226 T234 0 DC 500
Vfixed227 T235 0 DC 500
Vfixed228 T236 0 DC 500
Vfixed229 T237 0 DC 500
Vfixed230 T238 0 DC 500
Vfixed231 T239 0 DC 500
Vfixed232 T240 0 DC 500
Vfixed233 T241 0 DC 500
Vfixed234 T242 0 DC 500
Vfixed235 T243 0 DC 500
Vfixed236 T244 0 DC 500
Vfixed237 T245 0 DC 500
Vfixed238 T246 0 DC 500
Vfixed239 T247 0 DC 500
Vfixed240 T248 0 DC 500
Vfixed241 T249 0 DC 500
Vfixed242 T250 0 DC 500
Vfixed243 T251 0 DC 500
Vfixed244 T252 0 DC 500
Vfixed245 T253 0 DC 500
Vfixed246 T254 0 DC 500
Vfixed247 T255 0 DC 500
Vfixed248 T256 0 DC 500
Vfixed249 T257 0 DC 500
Vfixed250 T258 0 DC 500
Vfixed251 T259 0 DC 500
Vfixed252 T260 0 DC 500
Vfixed253 T261 0 DC 500
Vfixed254 T262 0 DC 500
Vfixed255 T263 0 DC 500
Vfixed256 T264 0 DC 500
Vfixed257 T265 0 DC 500
Vfixed258 T266 0 DC 500
Vfixed259 T267 0 DC 500
Vfixed260 T268 0 DC 500
Vfixed261 T269 0 DC 500
Vfixed262 T270 0 DC 500
Vfixed263 T271 0 DC 500
Vfixed264 T272 0 DC 500
Vfixed265 T273 0 DC 500
Vfixed266 T274 0 DC 500
Vfixed267 T275 0 DC 500
Vfixed268 T276 0 DC 500
Vfixed269 T277 0 DC 500
Vfixed270 T278 0 DC 500
Vfixed271 T279 0 DC 500
Vfixed272 T280 0 DC 500
Vfixed273 T281 0 DC 500
Vfixed274 T282 0 DC 500
Vfixed275 T283 0 DC 500
Vfixed276 T284 0 DC 500
Vfixed277 T285 0 DC 500
Vfixed278 T286 0 DC 500
Vfixed279 T287 0 DC 500
Vfixed280 T288 0 DC 500
Vfixed281 T289 0 DC 500
Vfixed282 T290 0 DC 500
Vfixed283 T291 0 DC 500
Vfixed284 T292 0 DC 500
Vfixed285 T293 0 DC 500
Vfixed286 T294 0 DC 500
Vfixed287 T295 0 DC 500
Vfixed288 T296 0 DC 500
Vfixed289 T297 0 DC 500
Vfixed290 T298 0 DC 500
Vfixed291 T299 0 DC 500
Vfixed292 T300 0 DC 500
Vfixed293 T451 0 DC 293.14999999999998
Vfixed294 T452 0 DC 293.14999999999998
Vfixed295 T453 0 DC 293.14999999999998
Vfixed296 T454 0 DC 293.14999999999998
Vfixed297 T455 0 DC 293.14999999999998
Vfixed298 T456 0 DC 293.14999999999998
Vfixed299 T457 0 DC 293.14999999999998
Vfixed300 T458 0 DC 293.14999999999998
Vfixed301 T459 0 DC 293.14999999999998
Vfixed302 T460 0 DC 293.14999999999998
Vfixed303 T461 0 DC 293.14999999999998
Vfixed304 T462 0 DC 293.14999999999998
Vfixed305 T463 0 DC 293.14999999999998
Vfixed306 T464 0 DC 293.14999999999998
Vfixed307 T465 0 DC 293.14999999999998
Vfixed308 T466 0 DC 293.14999999999998
Vfixed309 T467 0 DC 293.14999999999998
Vfixed310 T468 0 DC 293.14999999999998
Vfixed311 T469 0 DC 293.14999999999998
Vfixed312 T470 0 DC 293.14999999999998
Vfixed313 T471 0 DC 293.14999999999998
Vfixed314 T472 0 DC 293.14999999999998
Vfixed315 T473 0 DC 293.14999999999998
Vfixed316 T474 0 DC 293.14999999999998
Vfixed317 T475 0 DC 293.14999999999998
Vfixed318 T476 0 DC 293.14999999999998
Vfixed319 T477 0 DC 293.14999999999998
Vfixed320 T478 0 DC 293.14999999999998
Vfixed321 T479 0 DC 293.14999999999998
Vfixed322 T480 0 DC 293.14999999999998
Vfixed323 T481 0 DC 293.14999999999998
Vfixed324 T482 0 DC 293.14999999999998
Vfixed325 T483 0 DC 293.14999999999998
Vfixed326 T484 0 DC 293.14999999999998
Vfixed327 T485 0 DC 293.14999999999998
Vfixed328 T486 0 DC 293.14999999999998
Vfixed329 T487 0 DC 293.14999999999998
Vfixed330 T488 0 DC 293.14999999999998
Vfixed331 T489 0 DC 293.14999999999998
Vfixed332 T490 0 DC 293.14999999999998
Vfixed333 T491 0 DC 293.14999999999998
Vfixed334 T492 0 DC 293.14999999999998
Vfixed335 T493 0 DC 293.14999999999998
Vfixed336 T494 0 DC 293.14999999999998
Vfixed337 T495 0 DC 293.14999999999998
Vfixed338 T496 0 DC 293.14999999999998
Vfixed339 T497 0 DC 293.14999999999998
Vfixed340 T498 0 DC 293.14999999999998
Vfixed341 T499 0 DC 293.14999999999998
Vfixed342 T500 0 DC 293.14999999999998
Vfixed343 T501 0 DC 293.14999999999998
Vfixed344 T502 0 DC 293.14999999999998
Vfixed345 T503 0 DC 293.14999999999998
Vfixed346 T504 0 DC 293.14999999999998
Vfixed347 T505 0 DC 293.14999999999998
Vfixed348 T506 0 DC 293.14999999999998
Vfixed349 T507 0 DC 293.14999999999998
Vfixed350 T508 0 DC 293.14999999999998
Vfixed351 T509 0 DC 293.14999999999998
Vfixed352 T510 0 DC 293.14999999999998
Vfixed353 T511 0 DC 293.14999999999998
Vfixed354 T512 0 DC 293.14999999999998
Vfixed355 T513 0 DC 293.14999999999998
Vfixed356 T514 0 DC 293.14999999999998
Vfixed357 T515 0 DC 293.14999999999998
Vfixed358 T516 0 DC 293.14999999999998
Vfixed359 T517 0 DC 293.14999999999998
Vfixed360 T518 0 DC 293.14999999999998
Vfixed361 T519 0 DC 293.14999999999998
Vfixed362 T520 0 DC 293.14999999999998
Vfixed363 T521 0 DC 293.14999999999998
Vfixed364 T522 0 DC 293.14999999999998
Vfixed365 T523 0 DC 293.14999999999998
Vfixed366 T524 0 DC 293.14999999999998
Vfixed367 T525 0 DC 500
Vfixed368 T526 0 DC 500
Vfixed369 T527 0 DC 500
Vfixed370 T528 0 DC 500
Vfixed371 T529 0 DC 500
Vfixed372 T530 0 DC 500
Vfixed373 T531 0 DC 500
Vfixed374 T532 0 DC 500
Vfixed375 T533 0 DC 500
Vfixed376 T534 0 DC 500
Vfixed377 T535 0 DC 500
Vfixed378 T536 0 DC 500
Vfixed379 T537 0 DC 500
Vfixed380 T538 0 DC 500
Vfixed381 T539 0 DC 500
Vfixed382 T540 0 DC 500
Vfixed383 T541 0 DC 500
Vfixed384 T542 0 DC 500
Vfixed385 T543 0 DC 500
Vfixed386 T544 0 DC 500
Vfixed387 T545 0 DC 500
Vfixed388 T546 0 DC 500
Vfixed389 T547 0 DC 500
Vfixed390 T548 0 DC 500
Vfixed391 T549 0 DC 500
Vfixed392 T550 0 DC 500
Vfixed393 T551 0 DC 500
Vfixed394 T552 0 DC 500
Vfixed395 T553 0 DC 500
Vfixed396 T554 0 DC 500
Vfixed397 T555 0 DC 500
Vfixed398 T556 0 DC 500
Vfixed399 T557 0 DC 500
Vfixed400 T558 0 DC 500
Vfixed401 T559 0 DC 500
Vfixed402 T560 0 DC 500
Vfixed403 T561 0 DC 500
Vfixed404 T562 0 DC 500
Vfixed405 T563 0 DC 500
Vfixed406 T564 0 DC 500
Vfixed407 T565 0 DC 500
Vfixed408 T566 0 DC 500
Vfixed409 T567 0 DC 500
Vfixed410 T568 0 DC 500
Vfixed411 T569 0 DC 500
Vfixed412 T570 0 DC 500
Vfixed413 T571 0 DC 500
Vfixed414 T572 0 DC 500
Vfixed415 T573 0 DC 500
Vfixed416 T574 0 DC 500
Vfixed417 T575 0 DC 500
Vfixed418 T576 0 DC 500
Vfixed419 T577 0 DC 500
Vfixed420 T578 0 DC 500
Vfixed421 T579 0 DC 500
Vfixed422 T580 0 DC 500
Vfixed423 T581 0 DC 500
Vfixed424 T582 0 DC 500
Vfixed425 T583 0 DC 500
Vfixed426 T584 0 DC 500
Vfixed427 T585 0 DC 500
Vfixed428 T586 0 DC 500
Vfixed429 T587 0 DC 500
Vfixed430 T588 0 DC 500
Vfixed431 T589 0 DC 500
Vfixed432 T590 0 DC 500
Vfixed433 T591 0 DC 500
Vfixed434 T592 0 DC 500
Vfixed435 T593 0 DC 500
Vfixed436 T594 0 DC 500
Vfixed437 T595 0 DC 500
Vfixed438 T596 0 DC 500
Vfixed439 T597 0 DC 500
Vfixed440 T598 0 DC 500
Vfixed441 T599 0 DC 500
Vfixed442 T600 0 DC 500
Vfixed443 T601 0 DC 500
Vfixed444 T602 0 DC 500
Vfixed445 T603 0 DC 500
Vfixed446 T604 0 DC 500
Vfixed447 T605 0 DC 500
Vfixed448 T606 0 DC 500
Vfixed449 T607 0 DC 500
Vfixed450 T608 0 DC 500
Vfixed451 T609 0 DC 500
Vfixed452 T610 0 DC 500
Vfixed453 T611 0 DC 500
Vfixed454 T612 0 DC 500
Vfixed455 T613 0 DC 500
Vfixed456 T614 0 DC 500
Vfixed457 T615 0 DC 500
Vfixed458 T616 0 DC 500
Vfixed459 T617 0 DC 500
Vfixed460 T618 0 DC 500
Vfixed461 T619 0 DC 500
Vfixed462 T620 0 DC 500
Vfixed463 T621 0 DC 500
Vfixed464 T622 0 DC 500
Vfixed465 T623 0 DC 500
Vfixed466 T624 0 DC 500
Vfixed467 T625 0 DC 500
Vfixed468 T626 0 DC 500
Vfixed469 T627 0 DC 500
Vfixed470 T628 0 DC 500
Vfixed471 T629 0 DC 500
Vfixed472 T630 0 DC 500
Vfixed473 T631 0 DC 500
Vfixed474 T632 0 DC 500
Vfixed475 T633 0 DC 500
Vfixed476 T634 0 DC 500
Vfixed477 T635 0 DC 500
Vfixed478 T636 0 DC 500
Vfixed479 T637 0 DC 500
Vfixed480 T638 0 DC 500
Vfixed481 T639 0 DC 500
Vfixed482 T640 0 DC 500
Vfixed483 T641 0 DC 500
Vfixed484 T642 0 DC 500
Vfixed485 T643 0 DC 500
Vfixed486 T644 0 DC 500
Vfixed487 T645 0 DC 500
Vfixed488 T646 0 DC 500
Vfixed489 T647 0 DC 500
Vfixed490 T648 0 DC 500
Vfixed491 T649 0 DC 500
Vfixed492 T650 0 DC 500
Vfixed493 T651 0 DC 500
Vfixed494 T652 0 DC 500
Vfixed495 T653 0 DC 500
Vfixed496 T654 0 DC 500
Vfixed497 T655 0 DC 500
Vfixed498 T656 0 DC 500
Vfixed499 T657 0 DC 500
Vfixed500 T658 0 DC 500
Vfixed501 T659 0 DC 500
Vfixed502 T660 0 DC 500
Vfixed503 T661 0 DC 500
Vfixed504 T662 0 DC 500
Vfixed505 T663 0 DC 500
Vfixed506 T664 0 DC 500
Vfixed507 T665 0 DC 500
Vfixed508 T666 0 DC 500
Vfixed509 T667 0 DC 500
Vfixed510 T668 0 DC 500
Vfixed511 T669 0 DC 500
Vfixed512 T670 0 DC 500
Vfixed513 T671 0 DC 500
Vfixed514 T672 0 DC 500
Vfixed515 T673 0 DC 500
Vfixed516 T674 0 DC 500
Vfixed517 T675 0 DC 500
Vfixed518 T676 0 DC 500
Vfixed519 T677 0 DC 500
Vfixed520 T678 0 DC 500
Vfixed521 T679 0 DC 500
Vfixed522 T680 0 DC 500
Vfixed523 T681 0 DC 500
Vfixed524 T682 0 DC 500
Vfixed525 T683 0 DC 500
Vfixed526 T684 0 DC 500
Vfixed527 T685 0 DC 500
Vfixed528 T686 0 DC 500
Vfixed529 T687 0 DC 500
Vfixed530 T688 0 DC 500
Vfixed531 T689 0 DC 500
Vfixed532 T690 0 DC 500
Vfixed533 T691 0 DC 500
Vfixed534 T692 0 DC 500
Vfixed535 T693 0 DC 500
Vfixed536 T694 0 DC 500
Vfixed537 T695 0 DC 500
Vfixed538 T696 0 DC 500
Vfixed539 T697 0 DC 500
Vfixed540 T698 0 DC 500
Vfixed541 T699 0 DC 500
Vfixed542 T700 0 DC 500
Vfixed543 T701 0 DC 500
Vfixed544 T702 0 DC 500
Vfixed545 T703 0 DC 500
Vfixed546 T704 0 DC 500
Vfixed547 T705 0 DC 500
Vfixed548 T706 0 DC 500
Vfixed549 T707 0 DC 500
Vfixed550 T708 0 DC 500
Vfixed551 T709 0 DC 500
Vfixed552 T710 0 DC 500
Vfixed553 T711 0 DC 500
Vfixed554 T712 0 DC 500
Vfixed555 T713 0 DC 500
Vfixed556 T714 0 DC 500
Vfixed557 T715 0 DC 500
Vfixed558 T716 0 DC 500
Vfixed559 T717 0 DC 500
Vfixed560 T718 0 DC 500
Vfixed561 T719 0 DC 500
Vfixed562 T720 0 DC 500
Vfixed563 T721 0 DC 500
Vfixed564 T722 0 DC 500
Vfixed565 T723 0 DC 500
Vfixed566 T724 0 DC 500
Vfixed567 T725 0 DC 500
Vfixed568 T726 0 DC 500
Vfixed569 T727 0 DC 500
Vfixed570 T728 0 DC 500
Vfixed571 T729 0 DC 500
Vfixed572 T730 0 DC 500
Vfixed573 T731 0 DC 500
Vfixed574 T732 0 DC 500
Vfixed575 T733 0 DC 500
Vfixed576 T734 0 DC 500
Vfixed577 T735 0 DC 500
Vfixed578 T736 0 DC 500
Vfixed579 T737 0 DC 500
Vfixed580 T738 0 DC 500
Vfixed581 T739 0 DC 500
Vfixed582 T740 0 DC 500
Vfixed583 T741 0 DC 500
Vfixed584 T742 0 DC 500
Vfixed585 T743 0 DC 500
Vfixed586 T744 0 DC 500
Vfixed587 T745 0 DC 500
Vfixed588 T746 0 DC 500
Vfixed589 T747 0 DC 500
Vfixed590 T748 0 DC 500
Vfixed591 T749 0 DC 500
Vfixed592 T750 0 DC 500
Vfixed593 T751 0 DC 500
Vfixed594 T752 0 DC 500
Vfixed595 T753 0 DC 500
Vfixed596 T754 0 DC 500
Vfixed597 T755 0 DC 500
Vfixed598 T756 0 DC 500
Vfixed599 T757 0 DC 500
Vfixed600 T758 0 DC 500
Vfixed601 T759 0 DC 500
Vfixed602 T760 0 DC 500
Vfixed603 T761 0 DC 500
Vfixed604 T762 0 DC 500
Vfixed605 T763 0 DC 500
Vfixed606 T764 0 DC 500
Vfixed607 T765 0 DC 500
Vfixed608 T766 0 DC 500
Vfixed609 T767 0 DC 500
Vfixed610 T768 0 DC 500
Vfixed611 T769 0 DC 500
Vfixed612 T770 0 DC 500
Vfixed613 T771 0 DC 500
Vfixed614 T772 0 DC 500
Vfixed615 T773 0 DC 500
Vfixed616 T774 0 DC 500
Vfixed617 T775 0 DC 500
Vfixed618 T776 0 DC 500
Vfixed619 T777 0 DC 500
Vfixed620 T778 0 DC 500
Vfixed621 T779 0 DC 500
Vfixed622 T780 0 DC 500
Vfixed623 T781 0 DC 500
Vfixed624 T782 0 DC 500
Vfixed625 T783 0 DC 500
Vfixed626 T784 0 DC 500
Vfixed627 T785 0 DC 500
Vfixed628 T786 0 DC 500
Vfixed629 T787 0 DC 500
Vfixed630 T788 0 DC 500
Vfixed631 T789 0 DC 500
Vfixed632 T790 0 DC 500
Vfixed633 T791 0 DC 500
Vfixed634 T792 0 DC 500
Vfixed635 T793 0 DC 500
Vfixed636 T794 0 DC 500
Vfixed637 T795 0 DC 500
Vfixed638 T796 0 DC 500
Vfixed639 T797 0 DC 500
Vfixed640 T798 0 DC 500
Vfixed641 T799 0 DC 500
Vfixed642 T800 0 DC 500
Vfixed643 T801 0 DC 500
Vfixed644 T802 0 DC 500
Vfixed645 T803 0 DC 500
Vfixed646 T804 0 DC 500
Vfixed647 T805 0 DC 500
Vfixed648 T806 0 DC 500
Vfixed649 T807 0 DC 500
Vfixed650 T808 0 DC 500
Vfixed651 T809 0 DC 500
Vfixed652 T810 0 DC 500
Vfixed653 T811 0 DC 500
Vfixed654 T812 0 DC 500
Vfixed655 T813 0 DC 500
Vfixed656 T814 0 DC 500
Vfixed657 T815 0 DC 500
Vfixed658 T816 0 DC 500
Vfixed659 T817 0 DC 500
Vfixed660 T818 0 DC 500
Vfixed661 T819 0 DC 500
Vfixed662 T820 0 DC 500
Vfixed663 T821 0 DC 500
Vfixed664 T822 0 DC 500
Vfixed665 T823 0 DC 500
Vfixed666 T824 0 DC 500
Vfixed667 T825 0 DC 500
Vfixed668 T826 0 DC 500
Vfixed669 T827 0 DC 500
Vfixed670 T828 0 DC 500
Vfixed671 T829 0 DC 500
Vfixed672 T830 0 DC 500
Vfixed673 T831 0 DC 500
Vfixed674 T832 0 DC 500
Vfixed675 T833 0 DC 500
Vfixed676 T834 0 DC 500
Vfixed677 T835 0 DC 500
Vfixed678 T836 0 DC 500
Vfixed679 T837 0 DC 500
Vfixed680 T838 0 DC 500
Vfixed681 T839 0 DC 500
Vfixed682 T840 0 DC 500
Vfixed683 T841 0 DC 500
Vfixed684 T842 0 DC 500
Vfixed685 T843 0 DC 500
Vfixed686 T844 0 DC 500
Vfixed687 T4207 0 DC 293.14999999999998
Vfixed688 T4208 0 DC 293.14999999999998
Vfixed689 T4209 0 DC 293.14999999999998
Vfixed690 T4210 0 DC 293.14999999999998
Vfixed691 T4211 0 DC 293.14999999999998
Vfixed692 T4212 0 DC 293.14999999999998
Vfixed693 T4213 0 DC 293.14999999999998
Vfixed694 T4214 0 DC 293.14999999999998
Vfixed695 T4215 0 DC 293.14999999999998
Vfixed696 T4216 0 DC 293.14999999999998
Vfixed697 T4217 0 DC 293.14999999999998
Vfixed698 T4218 0 DC 293.14999999999998
Vfixed699 T4219 0 DC 293.14999999999998
Vfixed700 T4220 0 DC 293.14999999999998
Vfixed701 T4221 0 DC 293.14999999999998
Vfixed702 T4222 0 DC 293.14999999999998
Vfixed703 T4223 0 DC 293.14999999999998
Vfixed704 T4224 0 DC 293.14999999999998
Vfixed705 T4225 0 DC 293.14999999999998
Vfixed706 T4226 0 DC 293.14999999999998
Vfixed707 T4227 0 DC 293.14999999999998
Vfixed708 T4228 0 DC 293.14999999999998
Vfixed709 T4229 0 DC 293.14999999999998
Vfixed710 T4230 0 DC 293.14999999999998
Vfixed711 T4231 0 DC 293.14999999999998
Vfixed712 T4232 0 DC 293.14999999999998
Vfixed713 T4233 0 DC 293.14999999999998
Vfixed714 T4234 0 DC 293.14999999999998
Vfixed715 T4235 0 DC 293.14999999999998
Vfixed716 T4236 0 DC 293.14999999999998
Vfixed717 T4237 0 DC 293.14999999999998
Vfixed718 T4238 0 DC 293.14999999999998
Vfixed719 T4239 0 DC 293.14999999999998
Vfixed720 T4240 0 DC 293.14999999999998
Vfixed721 T4241 0 DC 293.14999999999998
Vfixed722 T4242 0 DC 293.14999999999998
Vfixed723 T4243 0 DC 293.14999999999998
Vfixed724 T4244 0 DC 293.14999999999998
Vfixed725 T4245 0 DC 293.14999999999998
Vfixed726 T4246 0 DC 293.14999999999998
Vfixed727 T4247 0 DC 293.14999999999998
Vfixed728 T4248 0 DC 293.14999999999998
Vfixed729 T4249 0 DC 293.14999999999998
Vfixed730 T4250 0 DC 293.14999999999998
Vfixed731 T4251 0 DC 293.14999999999998
Vfixed732 T4252 0 DC 293.14999999999998
Vfixed733 T4253 0 DC 293.14999999999998
Vfixed734 T4254 0 DC 293.14999999999998
Vfixed735 T4255 0 DC 293.14999999999998
Vfixed736 T4256 0 DC 293.14999999999998
Vfixed737 T4257 0 DC 293.14999999999998
Vfixed738 T4258 0 DC 293.14999999999998
Vfixed739 T4259 0 DC 293.14999999999998
Vfixed740 T4260 0 DC 293.14999999999998
Vfixed741 T4261 0 DC 293.14999999999998
Vfixed742 T4262 0 DC 293.14999999999998
Vfixed743 T4263 0 DC 293.14999999999998
Vfixed744 T4264 0 DC 293.14999999999998
Vfixed745 T4265 0 DC 293.14999999999998
Vfixed746 T4266 0 DC 293.14999999999998
Vfixed747 T4267 0 DC 293.14999999999998
Vfixed748 T4268 0 DC 293.14999999999998
Vfixed749 T4269 0 DC 293.14999999999998
Vfixed750 T4270 0 DC 293.14999999999998
Vfixed751 T4271 0 DC 293.14999999999998
Vfixed752 T4272 0 DC 293.14999999999998
Vfixed753 T4273 0 DC 293.14999999999998
Vfixed754 T4274 0 DC 293.14999999999998
Vfixed755 T4275 0 DC 293.14999999999998
Vfixed756 T4276 0 DC 293.14999999999998
Vfixed757 T4277 0 DC 293.14999999999998
Vfixed758 T4278 0 DC 293.14999999999998
Vfixed759 T4279 0 DC 293.14999999999998
Vfixed760 T4280 0 DC 293.14999999999998
Vfixed761 T4281 0 DC 293.14999999999998
Vfixed762 T4282 0 DC 293.14999999999998
Vfixed763 T4283 0 DC 293.14999999999998
Vfixed764 T4284 0 DC 293.14999999999998
Vfixed765 T4285 0 DC 293.14999999999998
Vfixed766 T4286 0 DC 293.14999999999998
Vfixed767 T4287 0 DC 293.14999999999998
Vfixed768 T4288 0 DC 293.14999999999998
Vfixed769 T4289 0 DC 293.14999999999998
Vfixed770 T4290 0 DC 293.14999999999998
Vfixed771 T4291 0 DC 293.14999999999998
Vfixed772 T4292 0 DC 293.14999999999998
Vfixed773 T4293 0 DC 293.14999999999998
Vfixed774 T4294 0 DC 293.14999999999998
Vfixed775 T4295 0 DC 293.14999999999998
Vfixed776 T4296 0 DC 293.14999999999998
Vfixed777 T4297 0 DC 293.14999999999998
Vfixed778 T4298 0 DC 293.14999999999998
Vfixed779 T4299 0 DC 293.14999999999998
Vfixed780 T4300 0 DC 293.14999999999998
Vfixed781 T4301 0 DC 293.14999999999998
Vfixed782 T4302 0 DC 293.14999999999998
Vfixed783 T4303 0 DC 293.14999999999998
Vfixed784 T4304 0 DC 293.14999999999998
Vfixed785 T4305 0 DC 293.14999999999998
Vfixed786 T4306 0 DC 293.14999999999998
Vfixed787 T4307 0 DC 293.14999999999998
Vfixed788 T4308 0 DC 293.14999999999998
Vfixed789 T4309 0 DC 293.14999999999998
Vfixed790 T4310 0 DC 293.14999999999998
Vfixed791 T4311 0 DC 293.14999999999998
Vfixed792 T4312 0 DC 293.14999999999998
Vfixed793 T4313 0 DC 293.14999999999998
Vfixed794 T4314 0 DC 293.14999999999998
Vfixed795 T4315 0 DC 293.14999999999998
Vfixed796 T4316 0 DC 293.14999999999998
Vfixed797 T4317 0 DC 293.14999999999998
Vfixed798 T4318 0 DC 293.14999999999998
Vfixed799 T4319 0 DC 293.14999999999998
Vfixed800 T4320 0 DC 293.14999999999998
Vfixed801 T4321 0 DC 293.14999999999998
Vfixed802 T4322 0 DC 293.14999999999998
Vfixed803 T4323 0 DC 293.14999999999998
Vfixed804 T4324 0 DC 293.14999999999998
Vfixed805 T4325 0 DC 293.14999999999998
Vfixed806 T4326 0 DC 293.14999999999998
Vfixed807 T4327 0 DC 293.14999999999998
Vfixed808 T4328 0 DC 293.14999999999998
Vfixed809 T4329 0 DC 293.14999999999998
Vfixed810 T4330 0 DC 293.14999999999998
Vfixed811 T4331 0 DC 293.14999999999998
Vfixed812 T4332 0 DC 293.14999999999998
Vfixed813 T4333 0 DC 293.14999999999998
Vfixed814 T4334 0 DC 293.14999999999998
Vfixed815 T4335 0 DC 293.14999999999998
Vfixed816 T4336 0 DC 293.14999999999998
Vfixed817 T4337 0 DC 293.14999999999998
Vfixed818 T4338 0 DC 293.14999999999998
Vfixed819 T4339 0 DC 293.14999999999998
Vfixed820 T4340 0 DC 293.14999999999998
Vfixed821 T4341 0 DC 293.14999999999998
Vfixed822 T4342 0 DC 293.14999999999998
Vfixed823 T4343 0 DC 293.14999999999998
Vfixed824 T4344 0 DC 293.14999999999998
Vfixed825 T4345 0 DC 293.14999999999998
Vfixed826 T4346 0 DC 293.14999999999998
Vfixed827 T4347 0 DC 293.14999999999998
Vfixed828 T4348 0 DC 293.14999999999998
Vfixed829 T4349 0 DC 293.14999999999998
Vfixed830 T4350 0 DC 293.14999999999998
Vfixed831 T4351 0 DC 293.14999999999998
Vfixed832 T4352 0 DC 293.14999999999998
Vfixed833 T4353 0 DC 293.14999999999998
Vfixed834 T4354 0 DC 293.14999999999998
Vfixed835 T4355 0 DC 293.14999999999998
Vfixed836 T4356 0 DC 293.14999999999998
Vfixed837 T4357 0 DC 293.14999999999998
Vfixed838 T4358 0 DC 293.14999999999998
Vfixed839 T4359 0 DC 293.14999999999998
Vfixed840 T4360 0 DC 293.14999999999998
Vfixed841 T4361 0 DC 293.14999999999998
Vfixed842 T4362 0 DC 293.14999999999998
Vfixed843 T4363 0 DC 293.14999999999998
Vfixed844 T4364 0 DC 293.14999999999998
Vfixed845 T4365 0 DC 293.14999999999998
Vfixed846 T4366 0 DC 293.14999999999998
Vfixed847 T4367 0 DC 293.14999999999998
Vfixed848 T4368 0 DC 293.14999999999998
Vfixed849 T4369 0 DC 293.14999999999998
Vfixed850 T4370 0 DC 293.14999999999998
Vfixed851 T4371 0 DC 293.14999999999998
Vfixed852 T4372 0 DC 293.14999999999998
Vfixed853 T4373 0 DC 293.14999999999998
Vfixed854 T4374 0 DC 293.14999999999998
Vfixed855 T4375 0 DC 293.14999999999998
Vfixed856 T4376 0 DC 293.14999999999998
Vfixed857 T4377 0 DC 293.14999999999998
Vfixed858 T4378 0 DC 293.14999999999998
Vfixed859 T4379 0 DC 293.14999999999998
Vfixed860 T4380 0 DC 293.14999999999998
Vfixed861 T4381 0 DC 293.14999999999998
Vfixed862 T4382 0 DC 293.14999999999998
Vfixed863 T4383 0 DC 293.14999999999998
Vfixed864 T4384 0 DC 293.14999999999998
Vfixed865 T4385 0 DC 293.14999999999998
Vfixed866 T4386 0 DC 293.14999999999998
Vfixed867 T4387 0 DC 293.14999999999998
Vfixed868 T4388 0 DC 293.14999999999998
Vfixed869 T4389 0 DC 293.14999999999998
Vfixed870 T4390 0 DC 293.14999999999998
Vfixed871 T4391 0 DC 293.14999999999998
Vfixed872 T4392 0 DC 293.14999999999998
Vfixed873 T4393 0 DC 293.14999999999998
Vfixed874 T4394 0 DC 293.14999999999998
Vfixed875 T4395 0 DC 293.14999999999998
Vfixed876 T4396 0 DC 293.14999999999998
Vfixed877 T4397 0 DC 293.14999999999998
Vfixed878 T4398 0 DC 293.14999999999998
Vfixed879 T4399 0 DC 293.14999999999998
Vfixed880 T4400 0 DC 293.14999999999998
Vfixed881 T4401 0 DC 293.14999999999998
Vfixed882 T4402 0 DC 293.14999999999998
Vfixed883 T4403 0 DC 293.14999999999998
Vfixed884 T4404 0 DC 293.14999999999998
Vfixed885 T4405 0 DC 293.14999999999998
Vfixed886 T4406 0 DC 293.14999999999998
Vfixed887 T4407 0 DC 293.14999999999998
Vfixed888 T4408 0 DC 293.14999999999998
Vfixed889 T4409 0 DC 293.14999999999998
Vfixed890 T4410 0 DC 293.14999999999998
Vfixed891 T4411 0 DC 293.14999999999998
Vfixed892 T4412 0 DC 293.14999999999998
Vfixed893 T4413 0 DC 293.14999999999998
Vfixed894 T4414 0 DC 293.14999999999998
Vfixed895 T4415 0 DC 293.14999999999998
Vfixed896 T4416 0 DC 293.14999999999998
Vfixed897 T4417 0 DC 293.14999999999998
Vfixed898 T4418 0 DC 293.14999999999998
Vfixed899 T4419 0 DC 293.14999999999998
Vfixed900 T4420 0 DC 293.14999999999998
Vfixed901 T4421 0 DC 293.14999999999998
Vfixed902 T4422 0 DC 293.14999999999998
Vfixed903 T4423 0 DC 293.14999999999998
Vfixed904 T4424 0 DC 293.14999999999998
Vfixed905 T4425 0 DC 293.14999999999998
Vfixed906 T4426 0 DC 293.14999999999998
Vfixed907 T4427 0 DC 293.14999999999998
Vfixed908 T4428 0 DC 293.14999999999998
Vfixed909 T4429 0 DC 293.14999999999998
Vfixed910 T4430 0 DC 293.14999999999998
Vfixed911 T4431 0 DC 293.14999999999998
Vfixed912 T4432 0 DC 293.14999999999998
Vfixed913 T4433 0 DC 293.14999999999998
Vfixed914 T4434 0 DC 293.14999999999998
Vfixed915 T4435 0 DC 293.14999999999998
Vfixed916 T4436 0 DC 293.14999999999998
Vfixed917 T4437 0 DC 293.14999999999998
Vfixed918 T4438 0 DC 293.14999999999998
Vfixed919 T4439 0 DC 293.14999999999998
Vfixed920 T4440 0 DC 293.14999999999998
Vfixed921 T4441 0 DC 293.14999999999998
Vfixed922 T4442 0 DC 293.14999999999998
Vfixed923 T4443 0 DC 293.14999999999998
Vfixed924 T4444 0 DC 293.14999999999998
Vfixed925 T4445 0 DC 293.14999999999998
Vfixed926 T4446 0 DC 293.14999999999998
Vfixed927 T4447 0 DC 293.14999999999998
Vfixed928 T4448 0 DC 293.14999999999998
Vfixed929 T4449 0 DC 293.14999999999998
Vfixed930 T4450 0 DC 293.14999999999998
Vfixed931 T4451 0 DC 293.14999999999998
Vfixed932 T4452 0 DC 293.14999999999998
Vfixed933 T4453 0 DC 293.14999999999998
Vfixed934 T4454 0 DC 293.14999999999998
Vfixed935 T4455 0 DC 293.14999999999998
Vfixed936 T4456 0 DC 293.14999999999998
Vfixed937 T4457 0 DC 293.14999999999998
Vfixed938 T4458 0 DC 293.14999999999998
Vfixed939 T4459 0 DC 293.14999999999998
Vfixed940 T4460 0 DC 293.14999999999998
Vfixed941 T4461 0 DC 293.14999999999998
Vfixed942 T4462 0 DC 293.14999999999998
Vfixed943 T4463 0 DC 293.14999999999998
Vfixed944 T4464 0 DC 293.14999999999998
Vfixed945 T4465 0 DC 293.14999999999998
Vfixed946 T4466 0 DC 293.14999999999998
Vfixed947 T4467 0 DC 293.14999999999998
Vfixed948 T4468 0 DC 293.14999999999998
Vfixed949 T4469 0 DC 293.14999999999998
Vfixed950 T4470 0 DC 293.14999999999998
Vfixed951 T4471 0 DC 293.14999999999998
Vfixed952 T4472 0 DC 293.14999999999998
Vfixed953 T4473 0 DC 293.14999999999998
Vfixed954 T4474 0 DC 293.14999999999998
Vfixed955 T4475 0 DC 293.14999999999998
Vfixed956 T4476 0 DC 293.14999999999998
Vfixed957 T4477 0 DC 293.14999999999998
Vfixed958 T4478 0 DC 293.14999999999998
Vfixed959 T4479 0 DC 293.14999999999998
Vfixed960 T4480 0 DC 293.14999999999998
Vfixed961 T4481 0 DC 293.14999999999998
Vfixed962 T4482 0 DC 293.14999999999998
Vfixed963 T4483 0 DC 293.14999999999998
Vfixed964 T4484 0 DC 293.14999999999998
Vfixed965 T4485 0 DC 293.14999999999998
Vfixed966 T4486 0 DC 293.14999999999998
Vfixed967 T4487 0 DC 293.14999999999998
Vfixed968 T4488 0 DC 293.14999999999998
Vfixed969 T4489 0 DC 293.14999999999998
Vfixed970 T4490 0 DC 293.14999999999998
Vfixed971 T4491 0 DC 293.14999999999998
Vfixed972 T4492 0 DC 293.14999999999998
Vfixed973 T4493 0 DC 293.14999999999998
Vfixed974 T4494 0 DC 293.14999999999998
Vfixed975 T4495 0 DC 293.14999999999998
Vfixed976 T4496 0 DC 293.14999999999998
Vfixed977 T4497 0 DC 293.14999999999998
Vfixed978 T4498 0 DC 293.14999999999998
Vfixed979 T4499 0 DC 293.14999999999998
Vfixed980 T4500 0 DC 293.14999999999998
Vfixed981 T4501 0 DC 293.14999999999998
Vfixed982 T4502 0 DC 293.14999999999998
Vfixed983 T4503 0 DC 293.14999999999998
Vfixed984 T4504 0 DC 293.14999999999998
Vfixed985 T4505 0 DC 293.14999999999998
Vfixed986 T4506 0 DC 293.14999999999998
Vfixed987 T4507 0 DC 293.14999999999998
Vfixed988 T4508 0 DC 293.14999999999998
Vfixed989 T4509 0 DC 293.14999999999998
Vfixed990 T4510 0 DC 293.14999999999998
Vfixed991 T4511 0 DC 293.14999999999998
Vfixed992 T4512 0 DC 293.14999999999998
Vfixed993 T4513 0 DC 293.14999999999998
Vfixed994 T4514 0 DC 293.14999999999998
Vfixed995 T4515 0 DC 293.14999999999998
Vfixed996 T4516 0 DC 293.14999999999998
Vfixed997 T4517 0 DC 293.14999999999998
Vfixed998 T4518 0 DC 293.14999999999998
Vfixed999 T4519 0 DC 293.14999999999998
Vfixed1000 T4520 0 DC 293.14999999999998
Vfixed1001 T4521 0 DC 293.14999999999998
Vfixed1002 T4522 0 DC 293.14999999999998
Vfixed1003 T4523 0 DC 293.14999999999998
Vfixed1004 T4524 0 DC 293.14999999999998
Vfixed1005 T4525 0 DC 293.14999999999998
Vfixed1006 T4526 0 DC 293.14999999999998
Vfixed1007 T4527 0 DC 293.14999999999998
Vfixed1008 T4528 0 DC 293.14999999999998
Vfixed1009 T4529 0 DC 293.14999999999998
Vfixed1010 T4530 0 DC 293.14999999999998
Vfixed1011 T4531 0 DC 293.14999999999998
Vfixed1012 T4532 0 DC 293.14999999999998
Vfixed1013 T4533 0 DC 293.14999999999998
Vfixed1014 T4534 0 DC 293.14999999999998
Vfixed1015 T4535 0 DC 293.14999999999998
Vfixed1016 T4536 0 DC 293.14999999999998
Vfixed1017 T4537 0 DC 293.14999999999998
Vfixed1018 T4538 0 DC 293.14999999999998
Vfixed1019 T4539 0 DC 293.14999999999998
Vfixed1020 T4540 0 DC 293.14999999999998
Vfixed1021 T4541 0 DC 293.14999999999998
Vfixed1022 T4542 0 DC 293.14999999999998
Vfixed1023 T4543 0 DC 293.14999999999998
Vfixed1024 T4544 0 DC 293.14999999999998
Vfixed1025 T4545 0 DC 293.14999999999998
Vfixed1026 T4546 0 DC 293.14999999999998
Vfixed1027 T4547 0 DC 293.14999999999998
Vfixed1028 T4548 0 DC 293.14999999999998
Vfixed1029 T4549 0 DC 293.14999999999998
Vfixed1030 T4550 0 DC 293.14999999999998
Vfixed1031 T4551 0 DC 293.14999999999998
Vfixed1032 T4552 0 DC 293.14999999999998
Vfixed1033 T4553 0 DC 293.14999999999998
Vfixed1034 T4554 0 DC 293.14999999999998
Vfixed1035 T4555 0 DC 293.14999999999998
Vfixed1036 T4556 0 DC 293.14999999999998
Vfixed1037 T4557 0 DC 293.14999999999998
Vfixed1038 T4558 0 DC 293.14999999999998
Vfixed1039 T4559 0 DC 293.14999999999998
Vfixed1040 T4560 0 DC 293.14999999999998
Vfixed1041 T4561 0 DC 293.14999999999998
Vfixed1042 T4562 0 DC 293.14999999999998
Vfixed1043 T4563 0 DC 293.14999999999998
Vfixed1044 T4564 0 DC 293.14999999999998
Vfixed1045 T4565 0 DC 293.14999999999998
Vfixed1046 T4566 0 DC 293.14999999999998
Vfixed1047 T4567 0 DC 293.14999999999998
Vfixed1048 T4568 0 DC 293.14999999999998
Vfixed1049 T4569 0 DC 293.14999999999998
Vfixed1050 T4570 0 DC 293.14999999999998
Vfixed1051 T4571 0 DC 293.14999999999998
Vfixed1052 T4572 0 DC 293.14999999999998
Vfixed1053 T4573 0 DC 293.14999999999998
Vfixed1054 T4574 0 DC 293.14999999999998
Vfixed1055 T4575 0 DC 293.14999999999998
Vfixed1056 T4576 0 DC 293.14999999999998
Vfixed1057 T4577 0 DC 293.14999999999998
Vfixed1058 T4578 0 DC 293.14999999999998
Vfixed1059 T4579 0 DC 293.14999999999998
Vfixed1060 T4580 0 DC 293.14999999999998
Vfixed1061 T4581 0 DC 293.14999999999998
Vfixed1062 T4582 0 DC 293.14999999999998
Vfixed1063 T4583 0 DC 293.14999999999998
Vfixed1064 T4584 0 DC 293.14999999999998
Vfixed1065 T4585 0 DC 293.14999999999998
Vfixed1066 T4586 0 DC 293.14999999999998
Vfixed1067 T4587 0 DC 293.14999999999998
Vfixed1068 T4588 0 DC 293.14999999999998
Vfixed1069 T4589 0 DC 293.14999999999998
Vfixed1070 T4590 0 DC 293.14999999999998
Vfixed1071 T4591 0 DC 293.14999999999998
Vfixed1072 T4592 0 DC 293.14999999999998
Vfixed1073 T4593 0 DC 293.14999999999998
Vfixed1074 T4594 0 DC 293.14999999999998
Vfixed1075 T4595 0 DC 293.14999999999998
Vfixed1076 T4596 0 DC 293.14999999999998
Vfixed1077 T4597 0 DC 293.14999999999998
Vfixed1078 T4598 0 DC 293.14999999999998
Vfixed1079 T4599 0 DC 293.14999999999998
Vfixed1080 T4600 0 DC 293.14999999999998
Vfixed1081 T4601 0 DC 293.14999999999998
Vfixed1082 T4602 0 DC 293.14999999999998
Vfixed1083 T4603 0 DC 293.14999999999998
Vfixed1084 T4604 0 DC 293.14999999999998
Vfixed1085 T4605 0 DC 293.14999999999998
Vfixed1086 T4606 0 DC 293.14999999999998
Vfixed1087 T4607 0 DC 293.14999999999998
Vfixed1088 T4608 0 DC 293.14999999999998
Vfixed1089 T4609 0 DC 293.14999999999998
Vfixed1090 T4610 0 DC 293.14999999999998
Vfixed1091 T4611 0 DC 293.14999999999998
Vfixed1092 T4612 0 DC 293.14999999999998
Vfixed1093 T4613 0 DC 293.14999999999998
Vfixed1094 T4614 0 DC 293.14999999999998
Vfixed1095 T4615 0 DC 293.14999999999998
Vfixed1096 T4616 0 DC 293.14999999999998
Vfixed1097 T4617 0 DC 293.14999999999998
Vfixed1098 T4618 0 DC 293.14999999999998
Vfixed1099 T4619 0 DC 293.14999999999998
Vfixed1100 T4620 0 DC 293.14999999999998
Vfixed1101 T4621 0 DC 293.14999999999998
Vfixed1102 T4622 0 DC 293.14999999999998
Vfixed1103 T4623 0 DC 293.14999999999998
Vfixed1104 T4624 0 DC 293.14999999999998
Vfixed1105 T4625 0 DC 293.14999999999998
Vfixed1106 T4626 0 DC 293.14999999999998
Vfixed1107 T4627 0 DC 293.14999999999998
Vfixed1108 T4628 0 DC 293.14999999999998
Vfixed1109 T4629 0 DC 293.14999999999998
Vfixed1110 T4630 0 DC 293.14999999999998
Vfixed1111 T4631 0 DC 293.14999999999998
Vfixed1112 T4632 0 DC 293.14999999999998
Vfixed1113 T4633 0 DC 293.14999999999998
Vfixed1114 T4634 0 DC 293.14999999999998
Vfixed1115 T4635 0 DC 293.14999999999998
Vfixed1116 T4636 0 DC 293.14999999999998
Vfixed1117 T4637 0 DC 293.14999999999998
Vfixed1118 T4638 0 DC 293.14999999999998
Vfixed1119 T4639 0 DC 293.14999999999998
Vfixed1120 T4640 0 DC 293.14999999999998
Vfixed1121 T4641 0 DC 293.14999999999998
Vfixed1122 T4642 0 DC 293.14999999999998
Vfixed1123 T4643 0 DC 293.14999999999998
Vfixed1124 T4644 0 DC 293.14999999999998
Vfixed1125 T4645 0 DC 293.14999999999998
Vfixed1126 T4646 0 DC 293.14999999999998
Vfixed1127 T4647 0 DC 293.14999999999998
Vfixed1128 T4648 0 DC 293.14999999999998
Vfixed1129 T4649 0 DC 293.14999999999998
Vfixed1130 T4650 0 DC 293.14999999999998
Vfixed1131 T4651 0 DC 293.14999999999998
Vfixed1132 T4652 0 DC 293.14999999999998
Vfixed1133 T4653 0 DC 293.14999999999998
Vfixed1134 T4654 0 DC 293.14999999999998
Vfixed1135 T4655 0 DC 293.14999999999998
Vfixed1136 T4656 0 DC 293.14999999999998
Vfixed1137 T4657 0 DC 293.14999999999998
Vfixed1138 T4658 0 DC 293.14999999999998
Vfixed1139 T4659 0 DC 293.14999999999998
Vfixed1140 T4660 0 DC 293.14999999999998
Vfixed1141 T4661 0 DC 293.14999999999998
Vfixed1142 T4662 0 DC 293.14999999999998
Vfixed1143 T4663 0 DC 293.14999999999998
Vfixed1144 T4664 0 DC 293.14999999999998
Vfixed1145 T4665 0 DC 293.14999999999998
Vfixed1146 T4666 0 DC 293.14999999999998
Vfixed1147 T4667 0 DC 293.14999999999998
Vfixed1148 T4668 0 DC 293.14999999999998
Vfixed1149 T4669 0 DC 293.14999999999998
Vfixed1150 T4670 0 DC 293.14999999999998
Vfixed1151 T4671 0 DC 293.14999999999998
Vfixed1152 T4672 0 DC 293.14999999999998
Vfixed1153 T4673 0 DC 293.14999999999998
Vfixed1154 T4674 0 DC 293.14999999999998
Vfixed1155 T4675 0 DC 293.14999999999998
Vfixed1156 T4676 0 DC 293.14999999999998
Vfixed1157 T4677 0 DC 293.14999999999998
Vfixed1158 T4678 0 DC 293.14999999999998
Vfixed1159 T4679 0 DC 293.14999999999998
Vfixed1160 T4680 0 DC 293.14999999999998
Vfixed1161 T4681 0 DC 293.14999999999998
Vfixed1162 T4682 0 DC 293.14999999999998
Vfixed1163 T4683 0 DC 293.14999999999998
Vfixed1164 T4684 0 DC 293.14999999999998
Vfixed1165 T4685 0 DC 293.14999999999998
Vfixed1166 T4686 0 DC 293.14999999999998
Vfixed1167 T4687 0 DC 293.14999999999998
Vfixed1168 T4688 0 DC 293.14999999999998
Vfixed1169 T4689 0 DC 293.14999999999998
Vfixed1170 T4690 0 DC 293.14999999999998
Vfixed1171 T4691 0 DC 293.14999999999998
Vfixed1172 T4692 0 DC 293.14999999999998
Vfixed1173 T4693 0 DC 293.14999999999998
Vfixed1174 T4694 0 DC 293.14999999999998
Vfixed1175 T4695 0 DC 293.14999999999998
Vfixed1176 T4696 0 DC 293.14999999999998
Vfixed1177 T4697 0 DC 293.14999999999998
Vfixed1178 T4698 0 DC 293.14999999999998
Vfixed1179 T4699 0 DC 293.14999999999998
Vfixed1180 T4700 0 DC 293.14999999999998
Vfixed1181 T4701 0 DC 293.14999999999998
Vfixed1182 T4702 0 DC 293.14999999999998
Vfixed1183 T4703 0 DC 293.14999999999998
Vfixed1184 T4704 0 DC 293.14999999999998
Vfixed1185 T4705 0 DC 293.14999999999998
Vfixed1186 T4706 0 DC 293.14999999999998
Vfixed1187 T4707 0 DC 293.14999999999998
Vfixed1188 T4708 0 DC 293.14999999999998
Vfixed1189 T4709 0 DC 293.14999999999998
Vfixed1190 T4710 0 DC 293.14999999999998
Vfixed1191 T4711 0 DC 293.14999999999998
Vfixed1192 T4712 0 DC 293.14999999999998
Vfixed1193 T4713 0 DC 293.14999999999998
Vfixed1194 T4714 0 DC 293.14999999999998
Vfixed1195 T4715 0 DC 293.14999999999998
Vfixed1196 T4716 0 DC 293.14999999999998
Vfixed1197 T4717 0 DC 293.14999999999998
Vfixed1198 T4718 0 DC 293.14999999999998
Vfixed1199 T4719 0 DC 293.14999999999998
Vfixed1200 T4720 0 DC 293.14999999999998
Vfixed1201 T4721 0 DC 293.14999999999998
Vfixed1202 T4722 0 DC 293.14999999999998
Vfixed1203 T4723 0 DC 293.14999999999998
Vfixed1204 T4724 0 DC 293.14999999999998
Vfixed1205 T4725 0 DC 293.14999999999998
Vfixed1206 T4726 0 DC 293.14999999999998
Vfixed1207 T4727 0 DC 293.14999999999998
Vfixed1208 T4728 0 DC 293.14999999999998
Vfixed1209 T4729 0 DC 293.14999999999998
Vfixed1210 T4730 0 DC 293.14999999999998
Vfixed1211 T4731 0 DC 293.14999999999998
Vfixed1212 T4732 0 DC 293.14999999999998
Vfixed1213 T4733 0 DC 293.14999999999998
Vfixed1214 T4734 0 DC 293.14999999999998
Vfixed1215 T4735 0 DC 293.14999999999998
Vfixed1216 T4736 0 DC 293.14999999999998
Vfixed1217 T4737 0 DC 293.14999999999998
Vfixed1218 T4738 0 DC 293.14999999999998
Vfixed1219 T4739 0 DC 293.14999999999998
Vfixed1220 T4740 0 DC 293.14999999999998
Vfixed1221 T4741 0 DC 293.14999999999998
Vfixed1222 T4742 0 DC 293.14999999999998
Vfixed1223 T4743 0 DC 293.14999999999998
Vfixed1224 T4744 0 DC 293.14999999999998
Vfixed1225 T4745 0 DC 293.14999999999998
Vfixed1226 T4746 0 DC 293.14999999999998
Vfixed1227 T4747 0 DC 293.14999999999998
Vfixed1228 T4748 0 DC 293.14999999999998
Vfixed1229 T4749 0 DC 293.14999999999998
Vfixed1230 T4750 0 DC 293.14999999999998
Vfixed1231 T4751 0 DC 293.14999999999998
Vfixed1232 T4752 0 DC 293.14999999999998
Vfixed1233 T4753 0 DC 293.14999999999998
Vfixed1234 T4754 0 DC 293.14999999999998
Vfixed1235 T4755 0 DC 293.14999999999998
Vfixed1236 T4756 0 DC 293.14999999999998
Vfixed1237 T4757 0 DC 293.14999999999998
Vfixed1238 T4758 0 DC 293.14999999999998
Vfixed1239 T4759 0 DC 293.14999999999998
Vfixed1240 T4760 0 DC 293.14999999999998
Vfixed1241 T4761 0 DC 293.14999999999998
Vfixed1242 T4762 0 DC 293.14999999999998
Vfixed1243 T4763 0 DC 293.14999999999998
Vfixed1244 T4764 0 DC 293.14999999999998
Vfixed1245 T4765 0 DC 293.14999999999998
Vfixed1246 T4766 0 DC 293.14999999999998
Vfixed1247 T4767 0 DC 293.14999999999998
Vfixed1248 T4768 0 DC 293.14999999999998
Vfixed1249 T4769 0 DC 293.14999999999998
Vfixed1250 T4770 0 DC 293.14999999999998
Vfixed1251 T4771 0 DC 293.14999999999998
Vfixed1252 T4772 0 DC 293.14999999999998
Vfixed1253 T4773 0 DC 293.14999999999998
Vfixed1254 T4774 0 DC 293.14999999999998
Vfixed1255 T4775 0 DC 293.14999999999998
Vfixed1256 T4776 0 DC 293.14999999999998
Vfixed1257 T4777 0 DC 293.14999999999998
Vfixed1258 T4778 0 DC 293.14999999999998
Vfixed1259 T4779 0 DC 293.14999999999998
Vfixed1260 T4780 0 DC 293.14999999999998
Vfixed1261 T4781 0 DC 293.14999999999998
Vfixed1262 T4782 0 DC 293.14999999999998
Vfixed1263 T4783 0 DC 293.14999999999998
Vfixed1264 T4784 0 DC 293.14999999999998
Vfixed1265 T4785 0 DC 293.14999999999998
Vfixed1266 T4786 0 DC 293.14999999999998
Vfixed1267 T4787 0 DC 293.14999999999998
Vfixed1268 T4788 0 DC 293.14999999999998
Vfixed1269 T4789 0 DC 293.14999999999998
Vfixed1270 T4790 0 DC 293.14999999999998
Vfixed1271 T4791 0 DC 293.14999999999998
Vfixed1272 T4792 0 DC 293.14999999999998
Vfixed1273 T4793 0 DC 293.14999999999998
Vfixed1274 T4794 0 DC 293.14999999999998
Vfixed1275 T4795 0 DC 293.14999999999998
Vfixed1276 T4796 0 DC 293.14999999999998
Vfixed1277 T4797 0 DC 293.14999999999998
Vfixed1278 T4798 0 DC 293.14999999999998
Vfixed1279 T4799 0 DC 293.14999999999998
Vfixed1280 T4800 0 DC 293.14999999999998
Vfixed1281 T4801 0 DC 293.14999999999998
Vfixed1282 T4802 0 DC 293.14999999999998
Vfixed1283 T4803 0 DC 293.14999999999998
Vfixed1284 T4804 0 DC 293.14999999999998
Vfixed1285 T4805 0 DC 293.14999999999998
Vfixed1286 T4806 0 DC 293.14999999999998
Vfixed1287 T4807 0 DC 293.14999999999998
Vfixed1288 T4808 0 DC 293.14999999999998
Vfixed1289 T4809 0 DC 293.14999999999998
Vfixed1290 T4810 0 DC 293.14999999999998
Vfixed1291 T4811 0 DC 293.14999999999998
Vfixed1292 T4812 0 DC 293.14999999999998
Vfixed1293 T4813 0 DC 293.14999999999998
Vfixed1294 T4814 0 DC 293.14999999999998
Vfixed1295 T4815 0 DC 293.14999999999998
Vfixed1296 T4816 0 DC 293.14999999999998
Vfixed1297 T4817 0 DC 293.14999999999998
Vfixed1298 T4818 0 DC 293.14999999999998
Vfixed1299 T4819 0 DC 293.14999999999998
Vfixed1300 T4820 0 DC 293.14999999999998
Vfixed1301 T4821 0 DC 293.14999999999998
Vfixed1302 T4822 0 DC 293.14999999999998
Vfixed1303 T4823 0 DC 293.14999999999998
Vfixed1304 T4824 0 DC 293.14999999999998
Vfixed1305 T4825 0 DC 293.14999999999998
Vfixed1306 T4826 0 DC 293.14999999999998
Vfixed1307 T4827 0 DC 293.14999999999998
Vfixed1308 T4828 0 DC 293.14999999999998
Vfixed1309 T4829 0 DC 293.14999999999998
Vfixed1310 T4830 0 DC 293.14999999999998
Vfixed1311 T4831 0 DC 293.14999999999998
Vfixed1312 T4832 0 DC 293.14999999999998
Vfixed1313 T4833 0 DC 293.14999999999998
Vfixed1314 T4834 0 DC 293.14999999999998
Vfixed1315 T4835 0 DC 293.14999999999998
Vfixed1316 T4836 0 DC 293.14999999999998
Vfixed1317 T4837 0 DC 293.14999999999998
Vfixed1318 T4838 0 DC 293.14999999999998
Vfixed1319 T4839 0 DC 293.14999999999998
Vfixed1320 T4840 0 DC 293.14999999999998
Vfixed1321 T4841 0 DC 293.14999999999998
Vfixed1322 T4842 0 DC 293.14999999999998
Vfixed1323 T4843 0 DC 293.14999999999998
Vfixed1324 T4844 0 DC 293.14999999999998
Vfixed1325 T4845 0 DC 293.14999999999998
Vfixed1326 T4846 0 DC 293.14999999999998
Vfixed1327 T4847 0 DC 293.14999999999998
Vfixed1328 T4848 0 DC 293.14999999999998
Vfixed1329 T4849 0 DC 293.14999999999998
Vfixed1330 T4850 0 DC 293.14999999999998
Vfixed1331 T4851 0 DC 293.14999999999998
Vfixed1332 T4852 0 DC 293.14999999999998
Vfixed1333 T4853 0 DC 293.14999999999998
Vfixed1334 T4854 0 DC 293.14999999999998
Vfixed1335 T4855 0 DC 293.14999999999998
Vfixed1336 T4856 0 DC 293.14999999999998
Vfixed1337 T4857 0 DC 293.14999999999998
Vfixed1338 T4858 0 DC 293.14999999999998
Vfixed1339 T4859 0 DC 293.14999999999998
Vfixed1340 T4860 0 DC 293.14999999999998
Vfixed1341 T4861 0 DC 293.14999999999998
Vfixed1342 T4862 0 DC 293.14999999999998
Vfixed1343 T4863 0 DC 293.14999999999998
Vfixed1344 T4864 0 DC 293.14999999999998
Vfixed1345 T4865 0 DC 293.14999999999998
Vfixed1346 T4866 0 DC 293.14999999999998
Vfixed1347 T4867 0 DC 293.14999999999998
Vfixed1348 T4868 0 DC 293.14999999999998
Vfixed1349 T4869 0 DC 293.14999999999998
Vfixed1350 T4870 0 DC 293.14999999999998
Vfixed1351 T4871 0 DC 293.14999999999998
Vfixed1352 T4872 0 DC 293.14999999999998
Vfixed1353 T4873 0 DC 293.14999999999998
Vfixed1354 T4874 0 DC 293.14999999999998
Vfixed1355 T4875 0 DC 293.14999999999998
Vfixed1356 T4876 0 DC 293.14999999999998
Vfixed1357 T4877 0 DC 293.14999999999998
Vfixed1358 T4878 0 DC 293.14999999999998
Vfixed1359 T4879 0 DC 293.14999999999998
Vfixed1360 T4880 0 DC 293.14999999999998
Vfixed1361 T4881 0 DC 293.14999999999998
Vfixed1362 T4882 0 DC 293.14999999999998
Vfixed1363 T4883 0 DC 293.14999999999998
Vfixed1364 T4884 0 DC 293.14999999999998
Vfixed1365 T4885 0 DC 293.14999999999998
Vfixed1366 T4886 0 DC 293.14999999999998
Vfixed1367 T4887 0 DC 293.14999999999998
Vfixed1368 T4888 0 DC 293.14999999999998
Vfixed1369 T4889 0 DC 293.14999999999998
Vfixed1370 T4890 0 DC 293.14999999999998
Vfixed1371 T4891 0 DC 293.14999999999998
Vfixed1372 T4892 0 DC 293.14999999999998
Vfixed1373 T4893 0 DC 293.14999999999998
Vfixed1374 T4894 0 DC 293.14999999999998
Vfixed1375 T4895 0 DC 293.14999999999998
Vfixed1376 T4896 0 DC 293.14999999999998
Vfixed1377 T4897 0 DC 293.14999999999998
Vfixed1378 T4898 0 DC 293.14999999999998
Vfixed1379 T4899 0 DC 293.14999999999998
Vfixed1380 T4900 0 DC 293.14999999999998
Vfixed1381 T4901 0 DC 293.14999999999998
Vfixed1382 T4902 0 DC 293.14999999999998
Vfixed1383 T4903 0 DC 293.14999999999998
Vfixed1384 T4904 0 DC 293.14999999999998
Vfixed1385 T4905 0 DC 293.14999999999998
Vfixed1386 T4906 0 DC 293.14999999999998
Vfixed1387 T4907 0 DC 293.14999999999998
Vfixed1388 T4908 0 DC 293.14999999999998
Vfixed1389 T4909 0 DC 293.14999999999998
Vfixed1390 T4910 0 DC 293.14999999999998
Vfixed1391 T4911 0 DC 293.14999999999998
Vfixed1392 T4912 0 DC 293.14999999999998
Vfixed1393 T4913 0 DC 293.14999999999998
Vfixed1394 T4914 0 DC 293.14999999999998
Vfixed1395 T4915 0 DC 293.14999999999998
Vfixed1396 T4916 0 DC 293.14999999999998
Vfixed1397 T4917 0 DC 293.14999999999998
Vfixed1398 T4918 0 DC 293.14999999999998
Vfixed1399 T4919 0 DC 293.14999999999998
Vfixed1400 T4920 0 DC 293.14999999999998
Vfixed1401 T4921 0 DC 293.14999999999998
Vfixed1402 T4922 0 DC 293.14999999999998
Vfixed1403 T4923 0 DC 293.14999999999998
Vfixed1404 T4924 0 DC 293.14999999999998
Vfixed1405 T4925 0 DC 293.14999999999998
Vfixed1406 T4926 0 DC 293.14999999999998
Vfixed1407 T4927 0 DC 293.14999999999998
Vfixed1408 T4928 0 DC 293.14999999999998
Vfixed1409 T4929 0 DC 293.14999999999998
Vfixed1410 T4930 0 DC 293.14999999999998
Vfixed1411 T4931 0 DC 293.14999999999998
Vfixed1412 T4932 0 DC 293.14999999999998
Vfixed1413 T4933 0 DC 293.14999999999998
Vfixed1414 T4934 0 DC 293.14999999999998
Vfixed1415 T4935 0 DC 293.14999999999998
Vfixed1416 T4936 0 DC 293.14999999999998
Vfixed1417 T4937 0 DC 293.14999999999998
Vfixed1418 T4938 0 DC 293.14999999999998
Vfixed1419 T4939 0 DC 293.14999999999998
Vfixed1420 T4940 0 DC 293.14999999999998
Vfixed1421 T4941 0 DC 293.14999999999998
Vfixed1422 T4942 0 DC 293.14999999999998
Vfixed1423 T4943 0 DC 293.14999999999998
Vfixed1424 T4944 0 DC 293.14999999999998
Vfixed1425 T4945 0 DC 293.14999999999998
Vfixed1426 T4946 0 DC 293.14999999999998
Vfixed1427 T4947 0 DC 293.14999999999998
Vfixed1428 T4948 0 DC 293.14999999999998
Vfixed1429 T4949 0 DC 293.14999999999998
Vfixed1430 T4950 0 DC 293.14999999999998
Vfixed1431 T4951 0 DC 293.14999999999998
Vfixed1432 T4952 0 DC 293.14999999999998
Vfixed1433 T4953 0 DC 293.14999999999998
Vfixed1434 T4954 0 DC 293.14999999999998
Vfixed1435 T4955 0 DC 293.14999999999998
Vfixed1436 T4956 0 DC 293.14999999999998
Vfixed1437 T4957 0 DC 293.14999999999998
Vfixed1438 T4958 0 DC 293.14999999999998
Vfixed1439 T4959 0 DC 293.14999999999998
Vfixed1440 T4960 0 DC 293.14999999999998
Vfixed1441 T4961 0 DC 293.14999999999998
Vfixed1442 T4962 0 DC 293.14999999999998
Vfixed1443 T4963 0 DC 293.14999999999998
Vfixed1444 T4964 0 DC 293.14999999999998
Vfixed1445 T4965 0 DC 293.14999999999998
Vfixed1446 T4966 0 DC 293.14999999999998
Vfixed1447 T4967 0 DC 293.14999999999998
Vfixed1448 T4968 0 DC 293.14999999999998
Vfixed1449 T4969 0 DC 293.14999999999998
Vfixed1450 T4970 0 DC 293.14999999999998
Vfixed1451 T4971 0 DC 293.14999999999998
Vfixed1452 T4972 0 DC 293.14999999999998
Vfixed1453 T4973 0 DC 293.14999999999998
Vfixed1454 T4974 0 DC 293.14999999999998
Vfixed1455 T4975 0 DC 293.14999999999998
Vfixed1456 T4976 0 DC 293.14999999999998
Vfixed1457 T4977 0 DC 293.14999999999998
Vfixed1458 T4978 0 DC 293.14999999999998
Vfixed1459 T4979 0 DC 293.14999999999998
Vfixed1460 T4980 0 DC 293.14999999999998
Vfixed1461 T4981 0 DC 293.14999999999998
Vfixed1462 T4982 0 DC 293.14999999999998
Vfixed1463 T4983 0 DC 293.14999999999998
Vfixed1464 T4984 0 DC 293.14999999999998
Vfixed1465 T4985 0 DC 293.14999999999998
Vfixed1466 T4986 0 DC 293.14999999999998
Vfixed1467 T4987 0 DC 293.14999999999998
Vfixed1468 T4988 0 DC 293.14999999999998
Vfixed1469 T4989 0 DC 293.14999999999998
Vfixed1470 T4990 0 DC 293.14999999999998
Vfixed1471 T4991 0 DC 293.14999999999998
Vfixed1472 T4992 0 DC 293.14999999999998
Vfixed1473 T4993 0 DC 293.14999999999998
Vfixed1474 T4994 0 DC 293.14999999999998
Vfixed1475 T4995 0 DC 293.14999999999998
Vfixed1476 T4996 0 DC 293.14999999999998
Vfixed1477 T4997 0 DC 293.14999999999998
Vfixed1478 T4998 0 DC 293.14999999999998
Vfixed1479 T4999 0 DC 293.14999999999998
Vfixed1480 T5000 0 DC 293.14999999999998
Vfixed1481 T5001 0 DC 293.14999999999998
Vfixed1482 T5002 0 DC 293.14999999999998
Vfixed1483 T5003 0 DC 293.14999999999998
Vfixed1484 T5004 0 DC 293.14999999999998
Vfixed1485 T5005 0 DC 293.14999999999998
Vfixed1486 T5006 0 DC 293.14999999999998
Vfixed1487 T5007 0 DC 293.14999999999998
Vfixed1488 T5008 0 DC 293.14999999999998
Vfixed1489 T5009 0 DC 293.14999999999998
Vfixed1490 T5010 0 DC 293.14999999999998
Vfixed1491 T5011 0 DC 293.14999999999998
Vfixed1492 T5012 0 DC 293.14999999999998
Vfixed1493 T5013 0 DC 293.14999999999998
Vfixed1494 T5014 0 DC 293.14999999999998
Vfixed1495 T5015 0 DC 293.14999999999998
Vfixed1496 T5016 0 DC 293.14999999999998
Vfixed1497 T5017 0 DC 293.14999999999998
Vfixed1498 T5018 0 DC 293.14999999999998
Vfixed1499 T5019 0 DC 293.14999999999998
Vfixed1500 T5020 0 DC 293.14999999999998
Vfixed1501 T5021 0 DC 293.14999999999998
Vfixed1502 T5022 0 DC 293.14999999999998
Vfixed1503 T5023 0 DC 293.14999999999998
Vfixed1504 T5024 0 DC 293.14999999999998
Vfixed1505 T5025 0 DC 293.14999999999998
Vfixed1506 T5026 0 DC 293.14999999999998
Vfixed1507 T5027 0 DC 293.14999999999998
Vfixed1508 T5028 0 DC 293.14999999999998
Vfixed1509 T5029 0 DC 293.14999999999998
Vfixed1510 T5030 0 DC 293.14999999999998
Vfixed1511 T5031 0 DC 293.14999999999998
Vfixed1512 T5032 0 DC 293.14999999999998
Vfixed1513 T5033 0 DC 293.14999999999998
Vfixed1514 T5034 0 DC 293.14999999999998
Vfixed1515 T5035 0 DC 293.14999999999998
Vfixed1516 T5036 0 DC 293.14999999999998
Vfixed1517 T5037 0 DC 293.14999999999998
Vfixed1518 T5038 0 DC 293.14999999999998
Vfixed1519 T5039 0 DC 293.14999999999998
Vfixed1520 T5040 0 DC 293.14999999999998
Vfixed1521 T5041 0 DC 293.14999999999998
Vfixed1522 T5042 0 DC 293.14999999999998
Vfixed1523 T5043 0 DC 293.14999999999998
Vfixed1524 T5044 0 DC 293.14999999999998
Vfixed1525 T5045 0 DC 293.14999999999998
Vfixed1526 T5046 0 DC 293.14999999999998
Vfixed1527 T5047 0 DC 293.14999999999998
Vfixed1528 T5048 0 DC 293.14999999999998
Vfixed1529 T5049 0 DC 293.14999999999998
Vfixed1530 T5050 0 DC 293.14999999999998
Vfixed1531 T5051 0 DC 293.14999999999998
Vfixed1532 T5052 0 DC 293.14999999999998
Vfixed1533 T5053 0 DC 293.14999999999998
Vfixed1534 T5054 0 DC 293.14999999999998
Vfixed1535 T5055 0 DC 293.14999999999998
Vfixed1536 T5056 0 DC 293.14999999999998
Vfixed1537 T5057 0 DC 293.14999999999998
Vfixed1538 T5058 0 DC 293.14999999999998
Vfixed1539 T5059 0 DC 293.14999999999998
Vfixed1540 T5060 0 DC 293.14999999999998
Vfixed1541 T5061 0 DC 293.14999999999998
Vfixed1542 T5062 0 DC 293.14999999999998
Vfixed1543 T5063 0 DC 293.14999999999998
Vfixed1544 T5064 0 DC 293.14999999999998
Vfixed1545 T5065 0 DC 293.14999999999998
Vfixed1546 T5066 0 DC 293.14999999999998
Vfixed1547 T5067 0 DC 293.14999999999998
Vfixed1548 T5068 0 DC 293.14999999999998
Vfixed1549 T5069 0 DC 293.14999999999998
Vfixed1550 T5070 0 DC 293.14999999999998
Vfixed1551 T5071 0 DC 293.14999999999998
Vfixed1552 T5072 0 DC 293.14999999999998
Vfixed1553 T5073 0 DC 293.14999999999998
Vfixed1554 T5074 0 DC 293.14999999999998
Vfixed1555 T5075 0 DC 293.14999999999998
Vfixed1556 T5076 0 DC 293.14999999999998
Vfixed1557 T5077 0 DC 293.14999999999998
Vfixed1558 T5078 0 DC 293.14999999999998
Vfixed1559 T5079 0 DC 293.14999999999998
Vfixed1560 T5080 0 DC 293.14999999999998
Vfixed1561 T5081 0 DC 293.14999999999998
Vfixed1562 T5082 0 DC 293.14999999999998
Vfixed1563 T5083 0 DC 293.14999999999998
Vfixed1564 T5084 0 DC 293.14999999999998
Vfixed1565 T5085 0 DC 293.14999999999998
Vfixed1566 T5086 0 DC 293.14999999999998
Vfixed1567 T5087 0 DC 293.14999999999998
Vfixed1568 T5088 0 DC 293.14999999999998
Vfixed1569 T5089 0 DC 293.14999999999998
Vfixed1570 T5090 0 DC 293.14999999999998
Vfixed1571 T5091 0 DC 293.14999999999998
Vfixed1572 T5092 0 DC 293.14999999999998
Vfixed1573 T5093 0 DC 293.14999999999998
Vfixed1574 T5094 0 DC 293.14999999999998
Vfixed1575 T5095 0 DC 293.14999999999998
Vfixed1576 T5096 0 DC 293.14999999999998
Vfixed1577 T5097 0 DC 293.14999999999998
Vfixed1578 T5098 0 DC 293.14999999999998
Vfixed1579 T5099 0 DC 293.14999999999998
Vfixed1580 T5100 0 DC 293.14999999999998
Vfixed1581 T5101 0 DC 293.14999999999998
Vfixed1582 T5102 0 DC 293.14999999999998
Vfixed1583 T5103 0 DC 293.14999999999998
Vfixed1584 T5104 0 DC 293.14999999999998
Vfixed1585 T5105 0 DC 293.14999999999998
Vfixed1586 T5106 0 DC 293.14999999999998
Vfixed1587 T5107 0 DC 293.14999999999998
Vfixed1588 T5108 0 DC 293.14999999999998
Vfixed1589 T5109 0 DC 293.14999999999998
Vfixed1590 T5110 0 DC 293.14999999999998
Vfixed1591 T5111 0 DC 293.14999999999998
Vfixed1592 T5112 0 DC 293.14999999999998
Vfixed1593 T5113 0 DC 293.14999999999998
Vfixed1594 T5114 0 DC 293.14999999999998
Vfixed1595 T5115 0 DC 293.14999999999998
Vfixed1596 T5116 0 DC 293.14999999999998
Vfixed1597 T5117 0 DC 293.14999999999998
Vfixed1598 T5118 0 DC 293.14999999999998
Vfixed1599 T5119 0 DC 293.14999999999998
Vfixed1600 T5120 0 DC 293.14999999999998
Vfixed1601 T5121 0 DC 293.14999999999998
Vfixed1602 T5122 0 DC 293.14999999999998
Vfixed1603 T5123 0 DC 293.14999999999998
Vfixed1604 T5124 0 DC 293.14999999999998
Vfixed1605 T5125 0 DC 293.14999999999998
Vfixed1606 T5126 0 DC 293.14999999999998
Vfixed1607 T5127 0 DC 293.14999999999998
Vfixed1608 T5128 0 DC 293.14999999999998
Vfixed1609 T5129 0 DC 293.14999999999998
Vfixed1610 T5130 0 DC 293.14999999999998
Vfixed1611 T5131 0 DC 293.14999999999998
Vfixed1612 T5132 0 DC 293.14999999999998
Vfixed1613 T5133 0 DC 293.14999999999998
Vfixed1614 T5134 0 DC 293.14999999999998
Vfixed1615 T5135 0 DC 293.14999999999998
Vfixed1616 T5136 0 DC 293.14999999999998
Vfixed1617 T5137 0 DC 293.14999999999998
Vfixed1618 T5138 0 DC 293.14999999999998
Vfixed1619 T5139 0 DC 293.14999999999998
Vfixed1620 T5140 0 DC 293.14999999999998
Vfixed1621 T5141 0 DC 293.14999999999998
Vfixed1622 T5142 0 DC 293.14999999999998
Vfixed1623 T5143 0 DC 293.14999999999998
Vfixed1624 T5144 0 DC 293.14999999999998
Vfixed1625 T5145 0 DC 293.14999999999998
Vfixed1626 T5146 0 DC 293.14999999999998
Vfixed1627 T5147 0 DC 293.14999999999998
Vfixed1628 T5148 0 DC 293.14999999999998
Vfixed1629 T5149 0 DC 293.14999999999998
Vfixed1630 T5150 0 DC 293.14999999999998
Vfixed1631 T5151 0 DC 293.14999999999998
Vfixed1632 T5152 0 DC 293.14999999999998
Vfixed1633 T5153 0 DC 293.14999999999998
Vfixed1634 T5154 0 DC 293.14999999999998
Vfixed1635 T5155 0 DC 293.14999999999998
Vfixed1636 T5156 0 DC 293.14999999999998
Vfixed1637 T5157 0 DC 293.14999999999998
Vfixed1638 T5158 0 DC 293.14999999999998
Vfixed1639 T5159 0 DC 293.14999999999998
Vfixed1640 T5160 0 DC 293.14999999999998
Vfixed1641 T5161 0 DC 293.14999999999998
Vfixed1642 T5162 0 DC 293.14999999999998
Vfixed1643 T5163 0 DC 293.14999999999998
Vfixed1644 T5164 0 DC 293.14999999999998
Vfixed1645 T5165 0 DC 293.14999999999998
Vfixed1646 T5166 0 DC 293.14999999999998
Vfixed1647 T5167 0 DC 293.14999999999998
Vfixed1648 T5168 0 DC 293.14999999999998
Vfixed1649 T5169 0 DC 293.14999999999998
Vfixed1650 T5170 0 DC 293.14999999999998
Vfixed1651 T5171 0 DC 293.14999999999998
Vfixed1652 T5172 0 DC 293.14999999999998
Vfixed1653 T5173 0 DC 293.14999999999998
Vfixed1654 T5174 0 DC 293.14999999999998
Vfixed1655 T5175 0 DC 293.14999999999998
Vfixed1656 T5176 0 DC 293.14999999999998
Vfixed1657 T5177 0 DC 293.14999999999998
Vfixed1658 T5178 0 DC 293.14999999999998
Vfixed1659 T5179 0 DC 293.14999999999998
Vfixed1660 T5180 0 DC 293.14999999999998
Vfixed1661 T5181 0 DC 293.14999999999998
Vfixed1662 T5182 0 DC 293.14999999999998
Vfixed1663 T5183 0 DC 293.14999999999998
Vfixed1664 T5184 0 DC 293.14999999999998
Vfixed1665 T5185 0 DC 293.14999999999998
Vfixed1666 T5186 0 DC 293.14999999999998
Vfixed1667 T5187 0 DC 293.14999999999998
Vfixed1668 T5188 0 DC 293.14999999999998
Vfixed1669 T5189 0 DC 293.14999999999998
Vfixed1670 T5190 0 DC 293.14999999999998
Vfixed1671 T5191 0 DC 293.14999999999998
Vfixed1672 T5192 0 DC 293.14999999999998
Vfixed1673 T5193 0 DC 293.14999999999998
Vfixed1674 T5194 0 DC 293.14999999999998
Vfixed1675 T5195 0 DC 293.14999999999998
Vfixed1676 T5196 0 DC 293.14999999999998
Vfixed1677 T5197 0 DC 293.14999999999998
Vfixed1678 T5198 0 DC 293.14999999999998
Vfixed1679 T5199 0 DC 293.14999999999998
Vfixed1680 T5200 0 DC 293.14999999999998
Vfixed1681 T5201 0 DC 293.14999999999998
Vfixed1682 T5202 0 DC 293.14999999999998
Vfixed1683 T5203 0 DC 293.14999999999998
Vfixed1684 T5204 0 DC 293.14999999999998
Vfixed1685 T5205 0 DC 293.14999999999998
Vfixed1686 T5206 0 DC 293.14999999999998
Vfixed1687 T5207 0 DC 293.14999999999998
Vfixed1688 T5208 0 DC 293.14999999999998
Vfixed1689 T5209 0 DC 293.14999999999998
Vfixed1690 T5210 0 DC 293.14999999999998
Vfixed1691 T5211 0 DC 293.14999999999998
Vfixed1692 T5212 0 DC 293.14999999999998
Vfixed1693 T5213 0 DC 293.14999999999998
Vfixed1694 T5214 0 DC 293.14999999999998
Vfixed1695 T5215 0 DC 293.14999999999998
Vfixed1696 T5216 0 DC 293.14999999999998
Vfixed1697 T5217 0 DC 293.14999999999998
Vfixed1698 T5218 0 DC 293.14999999999998
Vfixed1699 T5219 0 DC 293.14999999999998
Vfixed1700 T5220 0 DC 293.14999999999998
Vfixed1701 T5221 0 DC 293.14999999999998
Vfixed1702 T5222 0 DC 293.14999999999998
Vfixed1703 T5223 0 DC 293.14999999999998
Vfixed1704 T5224 0 DC 293.14999999999998
Vfixed1705 T5225 0 DC 293.14999999999998
Vfixed1706 T5226 0 DC 293.14999999999998
Vfixed1707 T5227 0 DC 293.14999999999998
Vfixed1708 T5228 0 DC 293.14999999999998
Vfixed1709 T5229 0 DC 293.14999999999998
Vfixed1710 T5230 0 DC 293.14999999999998
Vfixed1711 T5231 0 DC 293.14999999999998
Vfixed1712 T5232 0 DC 293.14999999999998
Vfixed1713 T5233 0 DC 293.14999999999998
Vfixed1714 T5234 0 DC 293.14999999999998
Vfixed1715 T5235 0 DC 293.14999999999998
Vfixed1716 T5236 0 DC 293.14999999999998
Vfixed1717 T5237 0 DC 293.14999999999998
Vfixed1718 T5238 0 DC 293.14999999999998
Vfixed1719 T5239 0 DC 293.14999999999998
Vfixed1720 T5240 0 DC 293.14999999999998
Vfixed1721 T5241 0 DC 293.14999999999998
Vfixed1722 T5242 0 DC 293.14999999999998
Vfixed1723 T5243 0 DC 293.14999999999998
Vfixed1724 T5244 0 DC 293.14999999999998
Vfixed1725 T5245 0 DC 293.14999999999998
Vfixed1726 T5246 0 DC 293.14999999999998
Vfixed1727 T5247 0 DC 293.14999999999998
Vfixed1728 T5248 0 DC 293.14999999999998
Vfixed1729 T5249 0 DC 293.14999999999998
Vfixed1730 T5250 0 DC 293.14999999999998
Vfixed1731 T5251 0 DC 293.14999999999998
Vfixed1732 T5252 0 DC 293.14999999999998
Vfixed1733 T5253 0 DC 293.14999999999998
Vfixed1734 T5254 0 DC 293.14999999999998
Vfixed1735 T5255 0 DC 293.14999999999998
Vfixed1736 T5256 0 DC 293.14999999999998
Vfixed1737 T5257 0 DC 293.14999999999998
Vfixed1738 T5258 0 DC 293.14999999999998
Vfixed1739 T5259 0 DC 293.14999999999998
Vfixed1740 T5260 0 DC 293.14999999999998
Vfixed1741 T5261 0 DC 293.14999999999998
Vfixed1742 T5262 0 DC 293.14999999999998
Vfixed1743 T5263 0 DC 293.14999999999998
Vfixed1744 T5264 0 DC 293.14999999999998
Vfixed1745 T5265 0 DC 293.14999999999998
Vfixed1746 T5266 0 DC 293.14999999999998
Vfixed1747 T5267 0 DC 293.14999999999998
Vfixed1748 T5268 0 DC 293.14999999999998
Vfixed1749 T5269 0 DC 293.14999999999998
Vfixed1750 T5270 0 DC 293.14999999999998
Vfixed1751 T5271 0 DC 293.14999999999998
Vfixed1752 T5272 0 DC 293.14999999999998
Vfixed1753 T5273 0 DC 293.14999999999998
Vfixed1754 T5274 0 DC 293.14999999999998
Vfixed1755 T5275 0 DC 293.14999999999998
Vfixed1756 T5276 0 DC 293.14999999999998
Vfixed1757 T5277 0 DC 293.14999999999998
Vfixed1758 T5278 0 DC 293.14999999999998
Vfixed1759 T5279 0 DC 293.14999999999998
Vfixed1760 T5280 0 DC 293.14999999999998
Vfixed1761 T5281 0 DC 293.14999999999998
Vfixed1762 T5282 0 DC 293.14999999999998
Vfixed1763 T5283 0 DC 293.14999999999998
Vfixed1764 T5284 0 DC 293.14999999999998
Vfixed1765 T5285 0 DC 293.14999999999998
Vfixed1766 T5286 0 DC 293.14999999999998
Vfixed1767 T5287 0 DC 293.14999999999998
Vfixed1768 T5288 0 DC 293.14999999999998
Vfixed1769 T5289 0 DC 293.14999999999998
Vfixed1770 T5290 0 DC 293.14999999999998
Vfixed1771 T5291 0 DC 293.14999999999998
Vfixed1772 T5292 0 DC 293.14999999999998
Vfixed1773 T5293 0 DC 293.14999999999998
Vfixed1774 T5294 0 DC 293.14999999999998
Vfixed1775 T5295 0 DC 293.14999999999998
Vfixed1776 T5296 0 DC 293.14999999999998
Vfixed1777 T5297 0 DC 293.14999999999998
Vfixed1778 T5298 0 DC 293.14999999999998
Vfixed1779 T5299 0 DC 293.14999999999998
Vfixed1780 T5300 0 DC 293.14999999999998
Vfixed1781 T5301 0 DC 293.14999999999998
Vfixed1782 T5302 0 DC 293.14999999999998
Vfixed1783 T5303 0 DC 293.14999999999998
Vfixed1784 T5304 0 DC 293.14999999999998
Vfixed1785 T5305 0 DC 293.14999999999998
Vfixed1786 T5306 0 DC 293.14999999999998
Vfixed1787 T5307 0 DC 293.14999999999998
Vfixed1788 T5308 0 DC 293.14999999999998
Vfixed1789 T5309 0 DC 293.14999999999998
Vfixed1790 T5310 0 DC 293.14999999999998
Vfixed1791 T5311 0 DC 293.14999999999998
Vfixed1792 T5312 0 DC 293.14999999999998
Vfixed1793 T5313 0 DC 293.14999999999998
Vfixed1794 T5314 0 DC 293.14999999999998
Vfixed1795 T5315 0 DC 293.14999999999998
Vfixed1796 T5316 0 DC 293.14999999999998
Vfixed1797 T5317 0 DC 293.14999999999998
Vfixed1798 T5318 0 DC 293.14999999999998
Vfixed1799 T5319 0 DC 293.14999999999998
Vfixed1800 T5320 0 DC 293.14999999999998
Vfixed1801 T5321 0 DC 293.14999999999998
Vfixed1802 T5322 0 DC 293.14999999999998
Vfixed1803 T5323 0 DC 293.14999999999998
Vfixed1804 T5324 0 DC 293.14999999999998
Vfixed1805 T5325 0 DC 293.14999999999998
Vfixed1806 T5326 0 DC 293.14999999999998
Vfixed1807 T5327 0 DC 293.14999999999998
Vfixed1808 T5328 0 DC 293.14999999999998
Vfixed1809 T5329 0 DC 293.14999999999998
Vfixed1810 T5330 0 DC 293.14999999999998
Vfixed1811 T5331 0 DC 293.14999999999998
Vfixed1812 T5332 0 DC 293.14999999999998
Vfixed1813 T5333 0 DC 293.14999999999998
Vfixed1814 T5334 0 DC 293.14999999999998
Vfixed1815 T5335 0 DC 293.14999999999998
Vfixed1816 T5336 0 DC 293.14999999999998
Vfixed1817 T5337 0 DC 293.14999999999998
Vfixed1818 T5338 0 DC 293.14999999999998
Vfixed1819 T5339 0 DC 293.14999999999998
Vfixed1820 T5340 0 DC 293.14999999999998
Vfixed1821 T5341 0 DC 293.14999999999998
Vfixed1822 T5342 0 DC 293.14999999999998
Vfixed1823 T5343 0 DC 293.14999999999998
Vfixed1824 T5344 0 DC 293.14999999999998
Vfixed1825 T5345 0 DC 293.14999999999998
Vfixed1826 T5346 0 DC 293.14999999999998
Vfixed1827 T5347 0 DC 293.14999999999998
Vfixed1828 T5348 0 DC 293.14999999999998
Vfixed1829 T5349 0 DC 293.14999999999998
Vfixed1830 T5350 0 DC 293.14999999999998
Vfixed1831 T5351 0 DC 293.14999999999998
Vfixed1832 T5352 0 DC 293.14999999999998
Vfixed1833 T5353 0 DC 293.14999999999998
Vfixed1834 T5354 0 DC 293.14999999999998
Vfixed1835 T5355 0 DC 293.14999999999998
Vfixed1836 T5356 0 DC 293.14999999999998
Vfixed1837 T5357 0 DC 293.14999999999998
Vfixed1838 T5358 0 DC 293.14999999999998
Vfixed1839 T5359 0 DC 293.14999999999998
Vfixed1840 T5360 0 DC 293.14999999999998
Vfixed1841 T5361 0 DC 293.14999999999998
Vfixed1842 T5362 0 DC 293.14999999999998
Vfixed1843 T5363 0 DC 293.14999999999998
Vfixed1844 T5364 0 DC 293.14999999999998
Vfixed1845 T5365 0 DC 293.14999999999998
Vfixed1846 T5366 0 DC 293.14999999999998
Vfixed1847 T5367 0 DC 293.14999999999998
Vfixed1848 T5368 0 DC 293.14999999999998
Vfixed1849 T5369 0 DC 293.14999999999998
Vfixed1850 T5370 0 DC 293.14999999999998
Vfixed1851 T5371 0 DC 293.14999999999998
Vfixed1852 T5372 0 DC 293.14999999999998
Vfixed1853 T5373 0 DC 293.14999999999998
Vfixed1854 T5374 0 DC 293.14999999999998
Vfixed1855 T5375 0 DC 293.14999999999998
Vfixed1856 T5376 0 DC 293.14999999999998
Vfixed1857 T5377 0 DC 293.14999999999998
Vfixed1858 T5378 0 DC 293.14999999999998
Vfixed1859 T5379 0 DC 293.14999999999998
Vfixed1860 T5380 0 DC 293.14999999999998
Vfixed1861 T5381 0 DC 293.14999999999998
Vfixed1862 T5382 0 DC 293.14999999999998
Vfixed1863 T5383 0 DC 293.14999999999998
Vfixed1864 T5384 0 DC 293.14999999999998
Vfixed1865 T5385 0 DC 293.14999999999998
Vfixed1866 T5386 0 DC 293.14999999999998
Vfixed1867 T5387 0 DC 293.14999999999998
Vfixed1868 T5388 0 DC 293.14999999999998
Vfixed1869 T5389 0 DC 293.14999999999998
Vfixed1870 T5390 0 DC 293.14999999999998
Vfixed1871 T5391 0 DC 293.14999999999998
Vfixed1872 T5392 0 DC 293.14999999999998
Vfixed1873 T5393 0 DC 293.14999999999998
Vfixed1874 T5394 0 DC 293.14999999999998
Vfixed1875 T5395 0 DC 293.14999999999998
Vfixed1876 T5396 0 DC 293.14999999999998
Vfixed1877 T5397 0 DC 293.14999999999998
Vfixed1878 T5398 0 DC 293.14999999999998
Vfixed1879 T5399 0 DC 293.14999999999998
Vfixed1880 T5400 0 DC 293.14999999999998
Vfixed1881 T5401 0 DC 293.14999999999998
Vfixed1882 T5402 0 DC 293.14999999999998
Vfixed1883 T5403 0 DC 293.14999999999998
Vfixed1884 T5404 0 DC 293.14999999999998
Vfixed1885 T5405 0 DC 293.14999999999998
Vfixed1886 T5406 0 DC 293.14999999999998
Vfixed1887 T5407 0 DC 293.14999999999998
Vfixed1888 T5408 0 DC 293.14999999999998
Vfixed1889 T5409 0 DC 293.14999999999998
Vfixed1890 T5410 0 DC 293.14999999999998
Vfixed1891 T5411 0 DC 293.14999999999998
Vfixed1892 T5412 0 DC 293.14999999999998
Vfixed1893 T5413 0 DC 293.14999999999998
Vfixed1894 T5414 0 DC 293.14999999999998
Vfixed1895 T5415 0 DC 293.14999999999998
Vfixed1896 T5416 0 DC 293.14999999999998
Vfixed1897 T5417 0 DC 293.14999999999998
Vfixed1898 T5418 0 DC 293.14999999999998
Vfixed1899 T5419 0 DC 293.14999999999998
Vfixed1900 T5420 0 DC 293.14999999999998
Vfixed1901 T5421 0 DC 293.14999999999998
Vfixed1902 T5422 0 DC 293.14999999999998
Vfixed1903 T5423 0 DC 293.14999999999998
Vfixed1904 T5424 0 DC 293.14999999999998
Vfixed1905 T5425 0 DC 293.14999999999998
Vfixed1906 T5426 0 DC 293.14999999999998
Vfixed1907 T5427 0 DC 293.14999999999998
Vfixed1908 T5428 0 DC 293.14999999999998
Vfixed1909 T5429 0 DC 293.14999999999998
Vfixed1910 T5430 0 DC 293.14999999999998
Vfixed1911 T5431 0 DC 293.14999999999998
Vfixed1912 T5432 0 DC 293.14999999999998
Vfixed1913 T5433 0 DC 293.14999999999998
Vfixed1914 T5434 0 DC 293.14999999999998
Vfixed1915 T5435 0 DC 293.14999999999998
Vfixed1916 T5436 0 DC 293.14999999999998
Vfixed1917 T5437 0 DC 293.14999999999998
Vfixed1918 T5438 0 DC 293.14999999999998
Vfixed1919 T5439 0 DC 293.14999999999998
Vfixed1920 T5440 0 DC 293.14999999999998
Vfixed1921 T5441 0 DC 293.14999999999998
Vfixed1922 T5442 0 DC 293.14999999999998
Vfixed1923 T5443 0 DC 293.14999999999998
Vfixed1924 T5444 0 DC 293.14999999999998
Vfixed1925 T5445 0 DC 293.14999999999998
Vfixed1926 T5446 0 DC 293.14999999999998
Vfixed1927 T5447 0 DC 293.14999999999998
Vfixed1928 T5448 0 DC 293.14999999999998
Vfixed1929 T5449 0 DC 293.14999999999998
Vfixed1930 T5450 0 DC 293.14999999999998
Vfixed1931 T5451 0 DC 293.14999999999998
Vfixed1932 T5452 0 DC 293.14999999999998
Vfixed1933 T5453 0 DC 293.14999999999998
Vfixed1934 T5454 0 DC 293.14999999999998
Vfixed1935 T5455 0 DC 293.14999999999998
Vfixed1936 T5456 0 DC 293.14999999999998
Vfixed1937 T5457 0 DC 293.14999999999998
Vfixed1938 T5458 0 DC 293.14999999999998
Vfixed1939 T5459 0 DC 293.14999999999998
Vfixed1940 T5460 0 DC 293.14999999999998
Vfixed1941 T5461 0 DC 293.14999999999998
Vfixed1942 T5462 0 DC 293.14999999999998
Vfixed1943 T5463 0 DC 293.14999999999998
Vfixed1944 T5464 0 DC 293.14999999999998
Vfixed1945 T5465 0 DC 293.14999999999998
Vfixed1946 T5466 0 DC 293.14999999999998
Vfixed1947 T5467 0 DC 293.14999999999998
Vfixed1948 T5468 0 DC 293.14999999999998
Vfixed1949 T5469 0 DC 293.14999999999998
Vfixed1950 T5470 0 DC 293.14999999999998
Vfixed1951 T5471 0 DC 293.14999999999998
Vfixed1952 T5472 0 DC 293.14999999999998
Vfixed1953 T5473 0 DC 293.14999999999998
Vfixed1954 T5474 0 DC 293.14999999999998
Vfixed1955 T5475 0 DC 293.14999999999998
Vfixed1956 T5476 0 DC 293.14999999999998
Vfixed1957 T5477 0 DC 293.14999999999998
Vfixed1958 T5478 0 DC 293.14999999999998
Vfixed1959 T5479 0 DC 293.14999999999998
Vfixed1960 T5480 0 DC 293.14999999999998
Vfixed1961 T5481 0 DC 293.14999999999998
Vfixed1962 T5482 0 DC 293.14999999999998
Vfixed1963 T5483 0 DC 293.14999999999998
Vfixed1964 T5484 0 DC 293.14999999999998
Vfixed1965 T5485 0 DC 293.14999999999998
Vfixed1966 T5486 0 DC 293.14999999999998
Vfixed1967 T5487 0 DC 293.14999999999998
Vfixed1968 T5488 0 DC 293.14999999999998
Vfixed1969 T5489 0 DC 293.14999999999998
Vfixed1970 T5490 0 DC 293.14999999999998
Vfixed1971 T5491 0 DC 293.14999999999998
Vfixed1972 T5492 0 DC 293.14999999999998
Vfixed1973 T5493 0 DC 293.14999999999998
Vfixed1974 T5494 0 DC 293.14999999999998
Vfixed1975 T5495 0 DC 293.14999999999998
Vfixed1976 T5496 0 DC 293.14999999999998
Vfixed1977 T5497 0 DC 293.14999999999998
Vfixed1978 T5498 0 DC 293.14999999999998
Vfixed1979 T5499 0 DC 293.14999999999998
Vfixed1980 T5500 0 DC 293.14999999999998
Vfixed1981 T5501 0 DC 293.14999999999998
Vfixed1982 T5502 0 DC 293.14999999999998
Vfixed1983 T5503 0 DC 293.14999999999998
Vfixed1984 T5504 0 DC 293.14999999999998
Vfixed1985 T5505 0 DC 293.14999999999998
Vfixed1986 T5506 0 DC 293.14999999999998
Vfixed1987 T5507 0 DC 293.14999999999998
Vfixed1988 T5508 0 DC 293.14999999999998
Vfixed1989 T5509 0 DC 293.14999999999998
Vfixed1990 T5510 0 DC 293.14999999999998
Vfixed1991 T5511 0 DC 293.14999999999998
Vfixed1992 T5512 0 DC 293.14999999999998
Vfixed1993 T5513 0 DC 293.14999999999998
Vfixed1994 T5514 0 DC 293.14999999999998
Vfixed1995 T5515 0 DC 293.14999999999998
Vfixed1996 T5516 0 DC 293.14999999999998
Vfixed1997 T5517 0 DC 293.14999999999998
Vfixed1998 T5518 0 DC 293.14999999999998
Vfixed1999 T5519 0 DC 293.14999999999998
Vfixed2000 T5520 0 DC 293.14999999999998
Vfixed2001 T5521 0 DC 293.14999999999998
Vfixed2002 T5522 0 DC 293.14999999999998
Vfixed2003 T5523 0 DC 293.14999999999998
Vfixed2004 T5524 0 DC 293.14999999999998
Vfixed2005 T5525 0 DC 293.14999999999998
Vfixed2006 T5526 0 DC 293.14999999999998
Vfixed2007 T5527 0 DC 293.14999999999998
Vfixed2008 T5528 0 DC 293.14999999999998
Vfixed2009 T5529 0 DC 293.14999999999998
Vfixed2010 T5530 0 DC 293.14999999999998
Vfixed2011 T5531 0 DC 293.14999999999998
Vfixed2012 T5532 0 DC 293.14999999999998
Vfixed2013 T5533 0 DC 293.14999999999998
Vfixed2014 T5534 0 DC 293.14999999999998
Vfixed2015 T5535 0 DC 293.14999999999998
Vfixed2016 T5536 0 DC 293.14999999999998
Vfixed2017 T5537 0 DC 293.14999999999998
Vfixed2018 T5538 0 DC 293.14999999999998
Vfixed2019 T5539 0 DC 293.14999999999998
Vfixed2020 T5540 0 DC 293.14999999999998
Vfixed2021 T5541 0 DC 293.14999999999998
Vfixed2022 T5542 0 DC 293.14999999999998
Vfixed2023 T5543 0 DC 293.14999999999998
Vfixed2024 T5544 0 DC 293.14999999999998
Vfixed2025 T5545 0 DC 293.14999999999998
Vfixed2026 T5546 0 DC 293.14999999999998
Vfixed2027 T5547 0 DC 293.14999999999998
Vfixed2028 T5548 0 DC 293.14999999999998
Vfixed2029 T5549 0 DC 293.14999999999998
Vfixed2030 T5550 0 DC 293.14999999999998
Vfixed2031 T5551 0 DC 293.14999999999998
Vfixed2032 T5552 0 DC 293.14999999999998
Vfixed2033 T5553 0 DC 293.14999999999998
Vfixed2034 T5554 0 DC 293.14999999999998
Vfixed2035 T5555 0 DC 293.14999999999998
Vfixed2036 T5556 0 DC 293.14999999999998
Vfixed2037 T5557 0 DC 293.14999999999998
Vfixed2038 T5558 0 DC 293.14999999999998
Vfixed2039 T5559 0 DC 293.14999999999998
Vfixed2040 T5560 0 DC 293.14999999999998
Vfixed2041 T5561 0 DC 293.14999999999998
Vfixed2042 T5562 0 DC 293.14999999999998
Vfixed2043 T5563 0 DC 293.14999999999998
Vfixed2044 T5564 0 DC 293.14999999999998
Vfixed2045 T5565 0 DC 293.14999999999998
Vfixed2046 T5566 0 DC 293.14999999999998
Vfixed2047 T5567 0 DC 293.14999999999998
Vfixed2048 T5568 0 DC 293.14999999999998
Vfixed2049 T5569 0 DC 293.14999999999998
Vfixed2050 T5570 0 DC 293.14999999999998
Vfixed2051 T5571 0 DC 293.14999999999998
Vfixed2052 T5572 0 DC 293.14999999999998
Vfixed2053 T5573 0 DC 293.14999999999998
Vfixed2054 T5574 0 DC 293.14999999999998
Vfixed2055 T5575 0 DC 293.14999999999998
Vfixed2056 T5576 0 DC 293.14999999999998
Vfixed2057 T5577 0 DC 293.14999999999998
Vfixed2058 T5578 0 DC 293.14999999999998
Vfixed2059 T5579 0 DC 293.14999999999998
Vfixed2060 T5580 0 DC 293.14999999999998
Vfixed2061 T5581 0 DC 293.14999999999998
Vfixed2062 T5582 0 DC 293.14999999999998
Vfixed2063 T5583 0 DC 293.14999999999998
Vfixed2064 T5584 0 DC 293.14999999999998
Vfixed2065 T5585 0 DC 293.14999999999998
Vfixed2066 T5586 0 DC 293.14999999999998
Vfixed2067 T5587 0 DC 293.14999999999998
Vfixed2068 T5588 0 DC 293.14999999999998
Vfixed2069 T5589 0 DC 293.14999999999998
Vfixed2070 T5590 0 DC 293.14999999999998
Vfixed2071 T5591 0 DC 293.14999999999998
Vfixed2072 T5592 0 DC 293.14999999999998
Vfixed2073 T5593 0 DC 293.14999999999998
Vfixed2074 T5594 0 DC 293.14999999999998
Vfixed2075 T5595 0 DC 293.14999999999998
Vfixed2076 T5596 0 DC 293.14999999999998
Vfixed2077 T5597 0 DC 293.14999999999998
Vfixed2078 T5598 0 DC 293.14999999999998
Vfixed2079 T5599 0 DC 293.14999999999998
Vfixed2080 T5600 0 DC 293.14999999999998
Vfixed2081 T5601 0 DC 293.14999999999998
Vfixed2082 T5602 0 DC 293.14999999999998
Vfixed2083 T5603 0 DC 293.14999999999998
Vfixed2084 T5604 0 DC 293.14999999999998
Vfixed2085 T5605 0 DC 293.14999999999998
Vfixed2086 T5606 0 DC 293.14999999999998
Vfixed2087 T5607 0 DC 293.14999999999998
Vfixed2088 T5608 0 DC 293.14999999999998
Vfixed2089 T5609 0 DC 293.14999999999998
Vfixed2090 T5610 0 DC 293.14999999999998
Vfixed2091 T5611 0 DC 293.14999999999998
Vfixed2092 T5612 0 DC 293.14999999999998
Vfixed2093 T5613 0 DC 293.14999999999998
Vfixed2094 T5614 0 DC 293.14999999999998
Vfixed2095 T5615 0 DC 293.14999999999998
Vfixed2096 T5616 0 DC 293.14999999999998
Vfixed2097 T5617 0 DC 293.14999999999998
Vfixed2098 T5618 0 DC 293.14999999999998
Vfixed2099 T5619 0 DC 293.14999999999998
Vfixed2100 T5620 0 DC 293.14999999999998
Vfixed2101 T5621 0 DC 293.14999999999998
Vfixed2102 T5622 0 DC 293.14999999999998
Vfixed2103 T5623 0 DC 293.14999999999998
Vfixed2104 T5624 0 DC 293.14999999999998
Vfixed2105 T5625 0 DC 293.14999999999998
Vfixed2106 T5626 0 DC 293.14999999999998
Vfixed2107 T5627 0 DC 293.14999999999998
Vfixed2108 T5628 0 DC 293.14999999999998
Vfixed2109 T5629 0 DC 293.14999999999998
Vfixed2110 T5630 0 DC 293.14999999999998
Vfixed2111 T5631 0 DC 293.14999999999998
Vfixed2112 T5632 0 DC 293.14999999999998
Vfixed2113 T5633 0 DC 293.14999999999998
Vfixed2114 T5634 0 DC 293.14999999999998
Vfixed2115 T5635 0 DC 293.14999999999998
Vfixed2116 T5636 0 DC 293.14999999999998
Vfixed2117 T5637 0 DC 293.14999999999998
Vfixed2118 T5638 0 DC 293.14999999999998
Vfixed2119 T5639 0 DC 293.14999999999998
Vfixed2120 T5640 0 DC 293.14999999999998
Vfixed2121 T5641 0 DC 293.14999999999998
Vfixed2122 T5642 0 DC 293.14999999999998
Vfixed2123 T5643 0 DC 293.14999999999998
Vfixed2124 T5644 0 DC 293.14999999999998
Vfixed2125 T5645 0 DC 293.14999999999998
Vfixed2126 T5646 0 DC 293.14999999999998
Vfixed2127 T5647 0 DC 293.14999999999998
Vfixed2128 T5648 0 DC 293.14999999999998
Vfixed2129 T5649 0 DC 293.14999999999998
Vfixed2130 T5650 0 DC 293.14999999999998
Vfixed2131 T5651 0 DC 293.14999999999998
Vfixed2132 T5652 0 DC 293.14999999999998
Vfixed2133 T5653 0 DC 293.14999999999998
Vfixed2134 T5654 0 DC 293.14999999999998
Vfixed2135 T5655 0 DC 293.14999999999998
Vfixed2136 T5656 0 DC 293.14999999999998
Vfixed2137 T5657 0 DC 293.14999999999998
Vfixed2138 T5658 0 DC 293.14999999999998
Vfixed2139 T5659 0 DC 293.14999999999998
Vfixed2140 T5660 0 DC 293.14999999999998
Vfixed2141 T5661 0 DC 293.14999999999998
Vfixed2142 T5662 0 DC 293.14999999999998
Vfixed2143 T5663 0 DC 293.14999999999998
Vfixed2144 T5664 0 DC 293.14999999999998
Vfixed2145 T5665 0 DC 293.14999999999998
Vfixed2146 T5666 0 DC 293.14999999999998
Vfixed2147 T5667 0 DC 293.14999999999998
Vfixed2148 T5668 0 DC 293.14999999999998
Vfixed2149 T5669 0 DC 293.14999999999998
Vfixed2150 T5670 0 DC 293.14999999999998
Vfixed2151 T5671 0 DC 293.14999999999998
Vfixed2152 T5672 0 DC 293.14999999999998
Vfixed2153 T5673 0 DC 293.14999999999998
Vfixed2154 T5674 0 DC 293.14999999999998
Vfixed2155 T5675 0 DC 293.14999999999998
Vfixed2156 T5676 0 DC 293.14999999999998
Vfixed2157 T5677 0 DC 293.14999999999998
Vfixed2158 T5678 0 DC 293.14999999999998
Vfixed2159 T5679 0 DC 293.14999999999998
Vfixed2160 T5680 0 DC 293.14999999999998
Vfixed2161 T5681 0 DC 293.14999999999998
Vfixed2162 T5682 0 DC 293.14999999999998
Vfixed2163 T5683 0 DC 293.14999999999998
Vfixed2164 T5684 0 DC 293.14999999999998
Vfixed2165 T5685 0 DC 293.14999999999998
Vfixed2166 T5686 0 DC 293.14999999999998
Vfixed2167 T5687 0 DC 293.14999999999998
Vfixed2168 T5688 0 DC 293.14999999999998
Vfixed2169 T5689 0 DC 293.14999999999998
Vfixed2170 T5690 0 DC 293.14999999999998
Vfixed2171 T5691 0 DC 293.14999999999998
Vfixed2172 T5692 0 DC 293.14999999999998
Vfixed2173 T5693 0 DC 293.14999999999998
Vfixed2174 T5694 0 DC 293.14999999999998
Vfixed2175 T5695 0 DC 293.14999999999998
Vfixed2176 T5696 0 DC 293.14999999999998
Vfixed2177 T5697 0 DC 293.14999999999998
Vfixed2178 T5698 0 DC 293.14999999999998
Vfixed2179 T5699 0 DC 293.14999999999998
Vfixed2180 T5700 0 DC 293.14999999999998
Vfixed2181 T5701 0 DC 293.14999999999998
Vfixed2182 T5702 0 DC 293.14999999999998
Vfixed2183 T5703 0 DC 293.14999999999998
Vfixed2184 T5704 0 DC 293.14999999999998
Vfixed2185 T5705 0 DC 293.14999999999998
Vfixed2186 T5706 0 DC 293.14999999999998
Vfixed2187 T5707 0 DC 293.14999999999998
Vfixed2188 T5708 0 DC 293.14999999999998
Vfixed2189 T5709 0 DC 293.14999999999998
Vfixed2190 T5710 0 DC 293.14999999999998
Vfixed2191 T5711 0 DC 293.14999999999998
Vfixed2192 T5712 0 DC 293.14999999999998
Vfixed2193 T5713 0 DC 293.14999999999998
Vfixed2194 T5714 0 DC 293.14999999999998
Vfixed2195 T5715 0 DC 293.14999999999998
Vfixed2196 T5716 0 DC 293.14999999999998
Vfixed2197 T5717 0 DC 293.14999999999998
Vfixed2198 T5718 0 DC 293.14999999999998
Vfixed2199 T5719 0 DC 293.14999999999998
Vfixed2200 T5720 0 DC 293.14999999999998
Vfixed2201 T5721 0 DC 293.14999999999998
Vfixed2202 T5722 0 DC 293.14999999999998
Vfixed2203 T5723 0 DC 293.14999999999998
Vfixed2204 T5724 0 DC 293.14999999999998
Vfixed2205 T5725 0 DC 293.14999999999998
Vfixed2206 T5726 0 DC 293.14999999999998
Vfixed2207 T5727 0 DC 293.14999999999998
Vfixed2208 T5728 0 DC 293.14999999999998
Vfixed2209 T5729 0 DC 293.14999999999998
Vfixed2210 T5730 0 DC 293.14999999999998
Vfixed2211 T5731 0 DC 293.14999999999998
Vfixed2212 T5732 0 DC 293.14999999999998
Vfixed2213 T5733 0 DC 293.14999999999998
Vfixed2214 T5734 0 DC 293.14999999999998
Vfixed2215 T5735 0 DC 293.14999999999998
Vfixed2216 T5736 0 DC 293.14999999999998
Vfixed2217 T5737 0 DC 293.14999999999998
Vfixed2218 T5738 0 DC 293.14999999999998
Vfixed2219 T5739 0 DC 293.14999999999998
Vfixed2220 T5740 0 DC 293.14999999999998
Vfixed2221 T5741 0 DC 293.14999999999998
Vfixed2222 T5742 0 DC 293.14999999999998
Vfixed2223 T5743 0 DC 293.14999999999998
Vfixed2224 T5744 0 DC 293.14999999999998
Vfixed2225 T5745 0 DC 293.14999999999998
Vfixed2226 T5746 0 DC 293.14999999999998
Vfixed2227 T5747 0 DC 293.14999999999998
Vfixed2228 T5748 0 DC 293.14999999999998
Vfixed2229 T5749 0 DC 293.14999999999998
Vfixed2230 T5750 0 DC 293.14999999999998
Vfixed2231 T5751 0 DC 293.14999999999998
Vfixed2232 T5752 0 DC 293.14999999999998
Vfixed2233 T5753 0 DC 293.14999999999998
Vfixed2234 T5754 0 DC 293.14999999999998
Vfixed2235 T5755 0 DC 293.14999999999998
Vfixed2236 T5756 0 DC 293.14999999999998
Vfixed2237 T5757 0 DC 293.14999999999998
Vfixed2238 T5758 0 DC 293.14999999999998
Vfixed2239 T5759 0 DC 293.14999999999998
Vfixed2240 T5760 0 DC 293.14999999999998
Vfixed2241 T5761 0 DC 293.14999999999998
Vfixed2242 T5762 0 DC 293.14999999999998
Vfixed2243 T5763 0 DC 293.14999999999998
Vfixed2244 T5764 0 DC 293.14999999999998
Vfixed2245 T5765 0 DC 293.14999999999998
Vfixed2246 T5766 0 DC 293.14999999999998
Vfixed2247 T5767 0 DC 293.14999999999998
Vfixed2248 T5768 0 DC 293.14999999999998
Vfixed2249 T5769 0 DC 293.14999999999998
Vfixed2250 T5770 0 DC 293.14999999999998
Vfixed2251 T5771 0 DC 293.14999999999998
Vfixed2252 T5772 0 DC 293.14999999999998
Vfixed2253 T5773 0 DC 293.14999999999998
Vfixed2254 T5774 0 DC 293.14999999999998
Vfixed2255 T5775 0 DC 293.14999999999998
Vfixed2256 T5776 0 DC 293.14999999999998
Vfixed2257 T5777 0 DC 293.14999999999998
Vfixed2258 T5778 0 DC 293.14999999999998
Vfixed2259 T5779 0 DC 293.14999999999998
Vfixed2260 T5780 0 DC 293.14999999999998
Vfixed2261 T5781 0 DC 293.14999999999998
Vfixed2262 T5782 0 DC 293.14999999999998
Vfixed2263 T5783 0 DC 293.14999999999998
Vfixed2264 T5784 0 DC 293.14999999999998
Vfixed2265 T5785 0 DC 293.14999999999998
Vfixed2266 T5786 0 DC 293.14999999999998
Vfixed2267 T5787 0 DC 293.14999999999998
Vfixed2268 T5788 0 DC 293.14999999999998
Vfixed2269 T5789 0 DC 293.14999999999998
Vfixed2270 T5790 0 DC 293.14999999999998
Vfixed2271 T5791 0 DC 293.14999999999998
Vfixed2272 T5792 0 DC 293.14999999999998
Vfixed2273 T5793 0 DC 293.14999999999998
Vfixed2274 T5794 0 DC 293.14999999999998
Vfixed2275 T5795 0 DC 293.14999999999998
Vfixed2276 T5796 0 DC 293.14999999999998
Vfixed2277 T5797 0 DC 293.14999999999998
Vfixed2278 T5798 0 DC 293.14999999999998
Vfixed2279 T5799 0 DC 293.14999999999998
Vfixed2280 T5800 0 DC 293.14999999999998
Vfixed2281 T5801 0 DC 293.14999999999998
Vfixed2282 T5802 0 DC 293.14999999999998
Vfixed2283 T5803 0 DC 293.14999999999998
Vfixed2284 T5804 0 DC 293.14999999999998
Vfixed2285 T5805 0 DC 293.14999999999998
Vfixed2286 T5806 0 DC 293.14999999999998
Vfixed2287 T5807 0 DC 293.14999999999998
Vfixed2288 T5808 0 DC 293.14999999999998
Vfixed2289 T5809 0 DC 293.14999999999998
Vfixed2290 T5810 0 DC 293.14999999999998
Vfixed2291 T5811 0 DC 293.14999999999998
Vfixed2292 T5812 0 DC 293.14999999999998
Vfixed2293 T5813 0 DC 293.14999999999998
Vfixed2294 T5814 0 DC 293.14999999999998
Vfixed2295 T5815 0 DC 293.14999999999998
Vfixed2296 T5816 0 DC 293.14999999999998
Vfixed2297 T5817 0 DC 293.14999999999998
Vfixed2298 T5818 0 DC 293.14999999999998
Vfixed2299 T5819 0 DC 293.14999999999998
Vfixed2300 T5820 0 DC 293.14999999999998
Vfixed2301 T5821 0 DC 293.14999999999998
Vfixed2302 T5822 0 DC 293.14999999999998
Vfixed2303 T5823 0 DC 293.14999999999998
Vfixed2304 T5824 0 DC 293.14999999999998
Vfixed2305 T5825 0 DC 293.14999999999998
Vfixed2306 T5826 0 DC 293.14999999999998
Vfixed2307 T5827 0 DC 293.14999999999998
Vfixed2308 T5828 0 DC 293.14999999999998
Vfixed2309 T5829 0 DC 293.14999999999998
Vfixed2310 T5830 0 DC 293.14999999999998
Vfixed2311 T5831 0 DC 293.14999999999998
Vfixed2312 T5832 0 DC 293.14999999999998
Vfixed2313 T5833 0 DC 293.14999999999998
Vfixed2314 T5834 0 DC 293.14999999999998
Vfixed2315 T5835 0 DC 293.14999999999998
Vfixed2316 T5836 0 DC 293.14999999999998
Vfixed2317 T5837 0 DC 293.14999999999998
Vfixed2318 T5838 0 DC 293.14999999999998
Vfixed2319 T5839 0 DC 293.14999999999998
Vfixed2320 T5840 0 DC 293.14999999999998
Vfixed2321 T5841 0 DC 293.14999999999998
Vfixed2322 T5842 0 DC 293.14999999999998
Vfixed2323 T5843 0 DC 293.14999999999998
Vfixed2324 T5844 0 DC 293.14999999999998
Vfixed2325 T5845 0 DC 293.14999999999998
Vfixed2326 T5846 0 DC 293.14999999999998
Vfixed2327 T5847 0 DC 293.14999999999998
Vfixed2328 T5848 0 DC 293.14999999999998
Vfixed2329 T5849 0 DC 293.14999999999998
Vfixed2330 T5850 0 DC 293.14999999999998
Vfixed2331 T5851 0 DC 293.14999999999998
Vfixed2332 T5852 0 DC 293.14999999999998
Vfixed2333 T5853 0 DC 293.14999999999998
Vfixed2334 T5854 0 DC 293.14999999999998
Vfixed2335 T5855 0 DC 293.14999999999998
Vfixed2336 T5856 0 DC 293.14999999999998
Vfixed2337 T5857 0 DC 293.14999999999998
Vfixed2338 T5858 0 DC 293.14999999999998
Vfixed2339 T5859 0 DC 293.14999999999998
Vfixed2340 T5860 0 DC 293.14999999999998
Vfixed2341 T5861 0 DC 293.14999999999998
Vfixed2342 T5862 0 DC 293.14999999999998
Vfixed2343 T5863 0 DC 293.14999999999998
Vfixed2344 T5864 0 DC 293.14999999999998
Vfixed2345 T5865 0 DC 293.14999999999998
Vfixed2346 T5866 0 DC 293.14999999999998
Vfixed2347 T5867 0 DC 293.14999999999998
Vfixed2348 T5868 0 DC 293.14999999999998
Vfixed2349 T5869 0 DC 293.14999999999998
Vfixed2350 T5870 0 DC 293.14999999999998
Vfixed2351 T5871 0 DC 293.14999999999998
Vfixed2352 T5872 0 DC 293.14999999999998
Vfixed2353 T5873 0 DC 293.14999999999998
Vfixed2354 T5874 0 DC 293.14999999999998
Vfixed2355 T5875 0 DC 293.14999999999998
Vfixed2356 T5876 0 DC 293.14999999999998
Vfixed2357 T5877 0 DC 293.14999999999998
Vfixed2358 T5878 0 DC 293.14999999999998
Vfixed2359 T5879 0 DC 293.14999999999998
Vfixed2360 T5880 0 DC 293.14999999999998
Vfixed2361 T5881 0 DC 293.14999999999998
Vfixed2362 T5882 0 DC 293.14999999999998
Vfixed2363 T5883 0 DC 293.14999999999998
Vfixed2364 T5884 0 DC 293.14999999999998
Vfixed2365 T5885 0 DC 293.14999999999998
Vfixed2366 T5886 0 DC 293.14999999999998
Vfixed2367 T5887 0 DC 293.14999999999998
Vfixed2368 T5888 0 DC 293.14999999999998
Vfixed2369 T5889 0 DC 293.14999999999998
Vfixed2370 T5890 0 DC 293.14999999999998
Vfixed2371 T5891 0 DC 293.14999999999998
Vfixed2372 T5892 0 DC 293.14999999999998
Vfixed2373 T5893 0 DC 293.14999999999998
Vfixed2374 T5894 0 DC 293.14999999999998
Vfixed2375 T5895 0 DC 293.14999999999998
Vfixed2376 T5896 0 DC 293.14999999999998
Vfixed2377 T5897 0 DC 293.14999999999998
Vfixed2378 T5898 0 DC 293.14999999999998
Vfixed2379 T5899 0 DC 293.14999999999998
Vfixed2380 T5900 0 DC 293.14999999999998
Vfixed2381 T5901 0 DC 293.14999999999998
Vfixed2382 T5902 0 DC 293.14999999999998
Vfixed2383 T5903 0 DC 293.14999999999998
Vfixed2384 T5904 0 DC 293.14999999999998
Vfixed2385 T5905 0 DC 293.14999999999998
Vfixed2386 T5906 0 DC 293.14999999999998
Vfixed2387 T5907 0 DC 293.14999999999998
Vfixed2388 T5908 0 DC 293.14999999999998
Vfixed2389 T5909 0 DC 293.14999999999998
Vfixed2390 T5910 0 DC 293.14999999999998
Vfixed2391 T5911 0 DC 293.14999999999998
Vfixed2392 T5912 0 DC 293.14999999999998
Vfixed2393 T5913 0 DC 293.14999999999998
Vfixed2394 T5914 0 DC 293.14999999999998
Vfixed2395 T5915 0 DC 293.14999999999998
Vfixed2396 T5916 0 DC 293.14999999999998
Vfixed2397 T5917 0 DC 293.14999999999998
Vfixed2398 T5918 0 DC 293.14999999999998
Vfixed2399 T5919 0 DC 293.14999999999998
Vfixed2400 T5920 0 DC 293.14999999999998
Vfixed2401 T5921 0 DC 293.14999999999998
Vfixed2402 T5922 0 DC 293.14999999999998
Vfixed2403 T5923 0 DC 293.14999999999998
Vfixed2404 T5924 0 DC 293.14999999999998
Vfixed2405 T5925 0 DC 293.14999999999998
Vfixed2406 T5926 0 DC 293.14999999999998
Vfixed2407 T5927 0 DC 293.14999999999998
Vfixed2408 T5928 0 DC 293.14999999999998
Vfixed2409 T5929 0 DC 293.14999999999998
Vfixed2410 T5930 0 DC 293.14999999999998
Vfixed2411 T5931 0 DC 293.14999999999998
Vfixed2412 T5932 0 DC 293.14999999999998
Vfixed2413 T5933 0 DC 293.14999999999998
Vfixed2414 T5934 0 DC 293.14999999999998
Vfixed2415 T5935 0 DC 293.14999999999998
Vfixed2416 T5936 0 DC 293.14999999999998
Vfixed2417 T5937 0 DC 293.14999999999998
Vfixed2418 T5938 0 DC 293.14999999999998
Vfixed2419 T5939 0 DC 293.14999999999998
Vfixed2420 T5940 0 DC 293.14999999999998
Vfixed2421 T5941 0 DC 293.14999999999998
Vfixed2422 T5942 0 DC 293.14999999999998
Vfixed2423 T5943 0 DC 293.14999999999998
Vfixed2424 T5944 0 DC 293.14999999999998
Vfixed2425 T5945 0 DC 293.14999999999998
Vfixed2426 T5946 0 DC 293.14999999999998
Vfixed2427 T5947 0 DC 293.14999999999998
Vfixed2428 T5948 0 DC 293.14999999999998
Vfixed2429 T5949 0 DC 293.14999999999998
Vfixed2430 T5950 0 DC 293.14999999999998
Vfixed2431 T5951 0 DC 293.14999999999998
Vfixed2432 T5952 0 DC 293.14999999999998
Vfixed2433 T5953 0 DC 293.14999999999998
Vfixed2434 T5954 0 DC 293.14999999999998
Vfixed2435 T5955 0 DC 293.14999999999998
Vfixed2436 T5956 0 DC 293.14999999999998
Vfixed2437 T5957 0 DC 293.14999999999998
Vfixed2438 T5958 0 DC 293.14999999999998
Vfixed2439 T5959 0 DC 293.14999999999998
Vfixed2440 T5960 0 DC 293.14999999999998
Vfixed2441 T5961 0 DC 293.14999999999998
Vfixed2442 T5962 0 DC 293.14999999999998
Vfixed2443 T5963 0 DC 293.14999999999998
Vfixed2444 T5964 0 DC 293.14999999999998
Vfixed2445 T5965 0 DC 293.14999999999998
Vfixed2446 T5966 0 DC 293.14999999999998
Vfixed2447 T5967 0 DC 293.14999999999998
Vfixed2448 T5968 0 DC 293.14999999999998
Vfixed2449 T5969 0 DC 293.14999999999998
Vfixed2450 T5970 0 DC 293.14999999999998
Vfixed2451 T5971 0 DC 293.14999999999998
Vfixed2452 T5972 0 DC 293.14999999999998
Vfixed2453 T5973 0 DC 293.14999999999998
Vfixed2454 T5974 0 DC 293.14999999999998
Vfixed2455 T5975 0 DC 293.14999999999998
Vfixed2456 T5976 0 DC 293.14999999999998
Vfixed2457 T5977 0 DC 293.14999999999998
Vfixed2458 T5978 0 DC 293.14999999999998
Vfixed2459 T5979 0 DC 293.14999999999998
Vfixed2460 T5980 0 DC 293.14999999999998
Vfixed2461 T5981 0 DC 293.14999999999998
Vfixed2462 T5982 0 DC 293.14999999999998
Vfixed2463 T5983 0 DC 293.14999999999998
Vfixed2464 T5984 0 DC 293.14999999999998
Vfixed2465 T5985 0 DC 293.14999999999998
Vfixed2466 T5986 0 DC 293.14999999999998
Vfixed2467 T5987 0 DC 293.14999999999998
Vfixed2468 T5988 0 DC 293.14999999999998
Vfixed2469 T5989 0 DC 293.14999999999998
Vfixed2470 T5990 0 DC 293.14999999999998
Vfixed2471 T5991 0 DC 293.14999999999998
Vfixed2472 T5992 0 DC 293.14999999999998
Vfixed2473 T5993 0 DC 293.14999999999998
Vfixed2474 T5994 0 DC 293.14999999999998
Vfixed2475 T5995 0 DC 293.14999999999998
Vfixed2476 T5996 0 DC 293.14999999999998
Vfixed2477 T5997 0 DC 293.14999999999998
Vfixed2478 T5998 0 DC 293.14999999999998
Vfixed2479 T5999 0 DC 293.14999999999998
Vfixed2480 T6000 0 DC 293.14999999999998
Vfixed2481 T6001 0 DC 293.14999999999998
Vfixed2482 T6002 0 DC 293.14999999999998
Vfixed2483 T6003 0 DC 293.14999999999998
Vfixed2484 T6004 0 DC 293.14999999999998
Vfixed2485 T6005 0 DC 293.14999999999998
Vfixed2486 T6006 0 DC 293.14999999999998
Vfixed2487 T6007 0 DC 293.14999999999998
Vfixed2488 T6008 0 DC 293.14999999999998
Vfixed2489 T6009 0 DC 293.14999999999998
Vfixed2490 T6010 0 DC 293.14999999999998
Vfixed2491 T6011 0 DC 293.14999999999998
Vfixed2492 T6012 0 DC 293.14999999999998
Vfixed2493 T6013 0 DC 293.14999999999998
Vfixed2494 T6014 0 DC 293.14999999999998
Vfixed2495 T6015 0 DC 293.14999999999998
Vfixed2496 T6016 0 DC 293.14999999999998
Vfixed2497 T6017 0 DC 293.14999999999998
Vfixed2498 T6018 0 DC 293.14999999999998
Vfixed2499 T6019 0 DC 293.14999999999998
Vfixed2500 T6020 0 DC 293.14999999999998
Vfixed2501 T6021 0 DC 293.14999999999998
Vfixed2502 T6022 0 DC 293.14999999999998
Vfixed2503 T6023 0 DC 293.14999999999998
Vfixed2504 T6024 0 DC 293.14999999999998
Vfixed2505 T6025 0 DC 293.14999999999998
Vfixed2506 T6026 0 DC 293.14999999999998
Vfixed2507 T6027 0 DC 293.14999999999998
Vfixed2508 T6028 0 DC 293.14999999999998
Vfixed2509 T6029 0 DC 293.14999999999998
Vfixed2510 T6030 0 DC 293.14999999999998
Vfixed2511 T6031 0 DC 293.14999999999998
Vfixed2512 T6032 0 DC 293.14999999999998
Vfixed2513 T6033 0 DC 293.14999999999998
Vfixed2514 T6034 0 DC 293.14999999999998
Vfixed2515 T6035 0 DC 293.14999999999998
Vfixed2516 T6036 0 DC 293.14999999999998
Vfixed2517 T6037 0 DC 293.14999999999998
Vfixed2518 T6038 0 DC 293.14999999999998
Vfixed2519 T6039 0 DC 293.14999999999998
Vfixed2520 T6040 0 DC 293.14999999999998
Vfixed2521 T6041 0 DC 293.14999999999998
Vfixed2522 T6042 0 DC 293.14999999999998
Vfixed2523 T6043 0 DC 293.14999999999998
Vfixed2524 T6044 0 DC 293.14999999999998
Vfixed2525 T6045 0 DC 293.14999999999998
Vfixed2526 T6046 0 DC 293.14999999999998
Vfixed2527 T6047 0 DC 293.14999999999998
Vfixed2528 T6048 0 DC 293.14999999999998
Vfixed2529 T6049 0 DC 293.14999999999998
Vfixed2530 T6050 0 DC 293.14999999999998
Vfixed2531 T6051 0 DC 293.14999999999998
Vfixed2532 T6052 0 DC 293.14999999999998
Vfixed2533 T6053 0 DC 293.14999999999998
Vfixed2534 T6054 0 DC 293.14999999999998
Vfixed2535 T6055 0 DC 293.14999999999998
Vfixed2536 T6056 0 DC 293.14999999999998
Vfixed2537 T6057 0 DC 293.14999999999998
Vfixed2538 T6058 0 DC 293.14999999999998
Vfixed2539 T6059 0 DC 293.14999999999998
Vfixed2540 T6060 0 DC 293.14999999999998
Vfixed2541 T6061 0 DC 293.14999999999998
Vfixed2542 T6062 0 DC 293.14999999999998
Vfixed2543 T6063 0 DC 293.14999999999998
Vfixed2544 T6064 0 DC 293.14999999999998
Vfixed2545 T6065 0 DC 293.14999999999998
Vfixed2546 T6066 0 DC 293.14999999999998
Vfixed2547 T6067 0 DC 293.14999999999998
Vfixed2548 T6068 0 DC 293.14999999999998
Vfixed2549 T6069 0 DC 293.14999999999998
Vfixed2550 T6070 0 DC 293.14999999999998
Vfixed2551 T6071 0 DC 293.14999999999998
Vfixed2552 T6072 0 DC 293.14999999999998
Vfixed2553 T6073 0 DC 293.14999999999998
Vfixed2554 T6074 0 DC 293.14999999999998
Vfixed2555 T6075 0 DC 293.14999999999998
Vfixed2556 T6076 0 DC 293.14999999999998
Vfixed2557 T6077 0 DC 293.14999999999998
Vfixed2558 T6078 0 DC 293.14999999999998
Vfixed2559 T6079 0 DC 293.14999999999998
Vfixed2560 T6080 0 DC 293.14999999999998
Vfixed2561 T6081 0 DC 293.14999999999998
Vfixed2562 T6082 0 DC 293.14999999999998
Vfixed2563 T6083 0 DC 293.14999999999998
Vfixed2564 T6084 0 DC 293.14999999999998
Vfixed2565 T6085 0 DC 293.14999999999998
Vfixed2566 T6086 0 DC 293.14999999999998
Vfixed2567 T6087 0 DC 293.14999999999998
Vfixed2568 T6088 0 DC 293.14999999999998
Vfixed2569 T6089 0 DC 293.14999999999998

.op
.probe V(*)
.end
